* Functional test stimulus file for 10ns period

* TT process corner
.lib "/u1/fanals/asic-data-operation/OpenRAM/sky130A/libs.tech/ngspice/sky130.lib.spice" tt
.include "/tmp/openram_fanals_4159571_temp/sram.sp"

* Global Power Supplies
Vvdd vdd 0 3.3

*Nodes gnd and 0 are the same global ground node in ngspice/hspice/xa. Otherwise, this source may be needed.
*Vgnd gnd 0 0.0

* Instantiation of the SRAM
Xsram_16x2 din0_0 din0_1 din1_0 din1_1 a0_0 a0_1 a0_2 a0_3 a1_0 a1_1 a1_2 a1_3 CSB0 CSB1 WEB0 WEB1 clk0 clk1 dout0_0 dout0_1 dout1_0 dout1_1 vdd gnd sram_16x2

* SRAM output loads
CD00 dout0_0  0 27.56f
CD01 dout0_1  0 27.56f
CD10 dout1_0  0 27.56f
CD11 dout1_1  0 27.56f

* Important signals for debug
* bl:	xsram:xbank0:bl_0_1
* br:	xsram:xbank0:br_0_1
* s_en:	xsram:s_en
* q:	xsram:xbank0:xbitcell_array:xbitcell_array:xbit_r0_c0.Q
* qbar:	xsram:xbank0:xbitcell_array:xbitcell_array:xbit_r0_c0.Q_bar

* Sequence of operations
*	Idle during cycle 0 (0ns - 10ns)
*	Writing 01  to  address 1110 (from port 0) during cycle 1 (10ns - 20ns)
*	Writing 10  to  address 1110 (from port 1) during cycle 1 (10ns - 20ns)
*	Writing 01  to  address 0000 (from port 0) during cycle 2 (20ns - 30ns)
*	Writing 10  to  address 0000 (from port 1) during cycle 2 (20ns - 30ns)
*	Writing 01  to  address 0000 (from port 0) during cycle 3 (30ns - 40ns)
*	Writing 01  to  address 0000 (from port 1) during cycle 3 (30ns - 40ns)
*	Reading 01 from address 0000 (from port 0) during cycle 4 (40ns - 50ns)
*	Reading 10 from address 1110 (from port 1) during cycle 4 (40ns - 50ns)
*	Reading 01 from address 0000 (from port 0) during cycle 6 (60ns - 70ns)
*	Reading 01 from address 0000 (from port 1) during cycle 6 (60ns - 70ns)
*	Writing 01  to  address 0000 (from port 1) during cycle 7 (70ns - 80ns)
*	Reading 01 from address 0000 (from port 0) during cycle 8 (80ns - 90ns)
*	Reading 10 from address 1110 (from port 1) during cycle 8 (80ns - 90ns)
*	Reading 01 from address 0000 (from port 1) during cycle 9 (90ns - 100ns)
*	Reading 01 from address 0000 (from port 0) during cycle 10 (100ns - 110ns)
*	Reading 01 from address 0000 (from port 1) during cycle 10 (100ns - 110ns)
*	Writing 11  to  address 0000 (from port 0) during cycle 11 (110ns - 120ns)
*	Writing 11  to  address 1110 (from port 1) during cycle 11 (110ns - 120ns)
*	Reading 11 from address 1110 (from port 0) during cycle 12 (120ns - 130ns)
*	Reading 11 from address 1110 (from port 1) during cycle 12 (120ns - 130ns)
*	Writing 11  to  address 0000 (from port 0) during cycle 13 (130ns - 140ns)
*	Reading 11 from address 1110 (from port 1) during cycle 13 (130ns - 140ns)
*	Writing 11  to  address 1110 (from port 0) during cycle 15 (150ns - 160ns)
*	Reading 11 from address 0000 (from port 1) during cycle 15 (150ns - 160ns)
*	Reading 11 from address 1110 (from port 0) during cycle 17 (170ns - 180ns)
*	Reading 11 from address 1110 (from port 1) during cycle 18 (180ns - 190ns)
*	Writing 01  to  address 1110 (from port 1) during cycle 20 (200ns - 210ns)
*	Reading 01 from address 1110 (from port 0) during cycle 21 (210ns - 220ns)
*	Writing 11  to  address 0000 (from port 0) during cycle 22 (220ns - 230ns)
*	Reading 01 from address 1110 (from port 0) during cycle 23 (230ns - 240ns)
*	Reading 01 from address 1110 (from port 1) during cycle 23 (230ns - 240ns)
*	Reading 11 from address 0000 (from port 0) during cycle 24 (240ns - 250ns)
*	Writing 10  to  address 1110 (from port 0) during cycle 25 (250ns - 260ns)
*	Reading 11 from address 0000 (from port 1) during cycle 26 (260ns - 270ns)
*	Reading 10 from address 1110 (from port 0) during cycle 27 (270ns - 280ns)
*	Writing 01  to  address 0000 (from port 1) during cycle 28 (280ns - 290ns)
*	Reading 01 from address 0000 (from port 0) during cycle 29 (290ns - 300ns)
*	Reading 10 from address 1110 (from port 1) during cycle 29 (290ns - 300ns)
*	Reading 10 from address 1110 (from port 0) during cycle 30 (300ns - 310ns)
*	Writing 10  to  address 0000 (from port 1) during cycle 30 (300ns - 310ns)
*	Reading 10 from address 0000 (from port 1) during cycle 31 (310ns - 320ns)
*	Reading 10 from address 0000 (from port 1) during cycle 32 (320ns - 330ns)
*	Reading 10 from address 1110 (from port 0) during cycle 34 (340ns - 350ns)
*	Writing 10  to  address 0000 (from port 1) during cycle 34 (340ns - 350ns)
*	Writing 10  to  address 1110 (from port 0) during cycle 35 (350ns - 360ns)
*	Writing 11  to  address 0000 (from port 1) during cycle 35 (350ns - 360ns)
*	Reading 10 from address 1110 (from port 0) during cycle 36 (360ns - 370ns)
*	Reading 10 from address 1110 (from port 0) during cycle 37 (370ns - 380ns)
*	Writing 10  to  address 0000 (from port 1) during cycle 37 (370ns - 380ns)
*	Writing 11  to  address 1110 (from port 0) during cycle 38 (380ns - 390ns)
*	Reading 11 from address 1110 (from port 0) during cycle 39 (390ns - 400ns)
*	Writing 01  to  address 1110 (from port 1) during cycle 39 (390ns - 400ns)
*	Writing 10  to  address 1110 (from port 0) during cycle 40 (400ns - 410ns)
*	Reading 10 from address 1110 (from port 0) during cycle 41 (410ns - 420ns)
*	Reading 10 from address 1110 (from port 0) during cycle 42 (420ns - 430ns)
*	Reading 10 from address 1110 (from port 1) during cycle 42 (420ns - 430ns)
*	Reading 10 from address 1110 (from port 0) during cycle 43 (430ns - 440ns)
*	Writing 01  to  address 1110 (from port 1) during cycle 43 (430ns - 440ns)
*	Reading 01 from address 1110 (from port 1) during cycle 44 (440ns - 450ns)
*	Writing 11  to  address 0000 (from port 0) during cycle 45 (450ns - 460ns)
*	Reading 01 from address 1110 (from port 0) during cycle 46 (460ns - 470ns)
*	Reading 11 from address 0000 (from port 1) during cycle 46 (460ns - 470ns)
*	Reading 01 from address 1110 (from port 0) during cycle 47 (470ns - 480ns)
*	Reading 11 from address 0000 (from port 1) during cycle 47 (470ns - 480ns)
*	Reading 11 from address 0000 (from port 0) during cycle 48 (480ns - 490ns)
*	Writing 01  to  address 0000 (from port 1) during cycle 48 (480ns - 490ns)
*	Reading 01 from address 1110 (from port 0) during cycle 49 (490ns - 500ns)
*	Reading 01 from address 1110 (from port 1) during cycle 49 (490ns - 500ns)
*	Reading 01 from address 1110 (from port 1) during cycle 50 (500ns - 510ns)
*	Writing 11  to  address 1110 (from port 1) during cycle 51 (510ns - 520ns)
*	Reading 11 from address 1110 (from port 0) during cycle 52 (520ns - 530ns)
*	Writing 01  to  address 1110 (from port 0) during cycle 54 (540ns - 550ns)
*	Writing 11  to  address 1110 (from port 0) during cycle 55 (550ns - 560ns)
*	Writing 10  to  address 0000 (from port 0) during cycle 56 (560ns - 570ns)
*	Writing 11  to  address 0000 (from port 0) during cycle 57 (570ns - 580ns)
*	Writing 10  to  address 1110 (from port 1) during cycle 57 (570ns - 580ns)
*	Reading 10 from address 1110 (from port 0) during cycle 58 (580ns - 590ns)
*	Reading 10 from address 1110 (from port 0) during cycle 59 (590ns - 600ns)
*	Reading 10 from address 1110 (from port 0) during cycle 60 (600ns - 610ns)
*	Writing 10  to  address 0000 (from port 0) during cycle 61 (610ns - 620ns)
*	Reading 10 from address 1110 (from port 1) during cycle 61 (610ns - 620ns)
*	Reading 10 from address 0000 (from port 0) during cycle 62 (620ns - 630ns)
*	Reading 10 from address 1110 (from port 1) during cycle 62 (620ns - 630ns)
*	Reading 10 from address 0000 (from port 0) during cycle 63 (630ns - 640ns)
*	Reading 10 from address 1110 (from port 1) during cycle 63 (630ns - 640ns)
*	Reading 10 from address 0000 (from port 0) during cycle 64 (640ns - 650ns)
*	Writing 10  to  address 1110 (from port 1) during cycle 64 (640ns - 650ns)
*	Reading 10 from address 0000 (from port 0) during cycle 65 (650ns - 660ns)
*	Writing 10  to  address 1110 (from port 1) during cycle 65 (650ns - 660ns)
*	Reading 10 from address 1110 (from port 0) during cycle 66 (660ns - 670ns)
*	Writing 10  to  address 0000 (from port 1) during cycle 66 (660ns - 670ns)
*	Reading 10 from address 0000 (from port 0) during cycle 67 (670ns - 680ns)
*	Writing 10  to  address 0000 (from port 1) during cycle 67 (670ns - 680ns)
*	Reading 10 from address 0000 (from port 0) during cycle 68 (680ns - 690ns)
*	Writing 10  to  address 0000 (from port 0) during cycle 69 (690ns - 700ns)
*	Reading 10 from address 1110 (from port 1) during cycle 70 (700ns - 710ns)
*	Reading 10 from address 0000 (from port 0) during cycle 71 (710ns - 720ns)
*	Reading 10 from address 1110 (from port 0) during cycle 72 (720ns - 730ns)
*	Writing 11  to  address 1110 (from port 1) during cycle 72 (720ns - 730ns)
*	Reading 10 from address 0000 (from port 0) during cycle 73 (730ns - 740ns)
*	Writing 10  to  address 0000 (from port 0) during cycle 74 (740ns - 750ns)
*	Writing 10  to  address 1110 (from port 1) during cycle 74 (740ns - 750ns)
*	Reading 10 from address 0000 (from port 0) during cycle 75 (750ns - 760ns)
*	Writing 01  to  address 0000 (from port 0) during cycle 76 (760ns - 770ns)
*	Reading 10 from address 1110 (from port 0) during cycle 77 (770ns - 780ns)
*	Reading 10 from address 1110 (from port 0) during cycle 78 (780ns - 790ns)
*	Reading 10 from address 1110 (from port 1) during cycle 78 (780ns - 790ns)
*	Writing 10  to  address 1110 (from port 0) during cycle 79 (790ns - 800ns)
*	Reading 01 from address 0000 (from port 1) during cycle 79 (790ns - 800ns)
*	Reading 10 from address 1110 (from port 0) during cycle 80 (800ns - 810ns)
*	Reading 01 from address 0000 (from port 1) during cycle 80 (800ns - 810ns)
*	Reading 10 from address 1110 (from port 0) during cycle 81 (810ns - 820ns)
*	Reading 10 from address 1110 (from port 1) during cycle 81 (810ns - 820ns)
*	Reading 01 from address 0000 (from port 0) during cycle 82 (820ns - 830ns)
*	Writing 10  to  address 1110 (from port 1) during cycle 82 (820ns - 830ns)
*	Reading 10 from address 1110 (from port 0) during cycle 83 (830ns - 840ns)
*	Writing 11  to  address 0000 (from port 0) during cycle 84 (840ns - 850ns)
*	Reading 10 from address 1110 (from port 1) during cycle 84 (840ns - 850ns)
*	Reading 11 from address 0000 (from port 0) during cycle 85 (850ns - 860ns)
*	Writing 11  to  address 1110 (from port 1) during cycle 85 (850ns - 860ns)
*	Reading 11 from address 1110 (from port 1) during cycle 86 (860ns - 870ns)
*	Writing 11  to  address 0000 (from port 0) during cycle 87 (870ns - 880ns)
*	Reading 11 from address 1110 (from port 0) during cycle 88 (880ns - 890ns)
*	Reading 11 from address 1110 (from port 1) during cycle 88 (880ns - 890ns)
*	Reading 11 from address 0000 (from port 0) during cycle 89 (890ns - 900ns)
*	Reading 11 from address 1110 (from port 1) during cycle 90 (900ns - 910ns)
*	Reading 11 from address 0000 (from port 0) during cycle 91 (910ns - 920ns)
*	Reading 11 from address 0000 (from port 1) during cycle 91 (910ns - 920ns)
*	Reading 11 from address 0000 (from port 0) during cycle 92 (920ns - 930ns)
*	Reading 11 from address 1110 (from port 1) during cycle 92 (920ns - 930ns)
*	Reading 11 from address 0000 (from port 1) during cycle 94 (940ns - 950ns)
*	Writing 01  to  address 1110 (from port 0) during cycle 95 (950ns - 960ns)
*	Reading 11 from address 0000 (from port 1) during cycle 95 (950ns - 960ns)
*	Reading 11 from address 0000 (from port 1) during cycle 97 (970ns - 980ns)
*	Reading 11 from address 0000 (from port 1) during cycle 98 (980ns - 990ns)
*	Writing 11  to  address 0000 (from port 1) during cycle 100 (1000ns - 1010ns)
*	Reading 01 from address 1110 (from port 0) during cycle 101 (1010ns - 1020ns)
*	Reading 01 from address 1110 (from port 1) during cycle 101 (1010ns - 1020ns)
*	Writing 11  to  address 0000 (from port 0) during cycle 102 (1020ns - 1030ns)
*	Writing 11  to  address 1110 (from port 0) during cycle 103 (1030ns - 1040ns)
*	Reading 11 from address 0000 (from port 1) during cycle 103 (1030ns - 1040ns)
*	Reading 11 from address 1110 (from port 0) during cycle 104 (1040ns - 1050ns)
*	Reading 11 from address 0000 (from port 1) during cycle 104 (1040ns - 1050ns)
*	Reading 11 from address 1110 (from port 0) during cycle 105 (1050ns - 1060ns)
*	Writing 11  to  address 0000 (from port 1) during cycle 106 (1060ns - 1070ns)
*	Reading 11 from address 0000 (from port 0) during cycle 107 (1070ns - 1080ns)
*	Reading 11 from address 0000 (from port 0) during cycle 108 (1080ns - 1090ns)
*	Reading 11 from address 0000 (from port 1) during cycle 108 (1080ns - 1090ns)
*	Reading 11 from address 1110 (from port 0) during cycle 109 (1090ns - 1100ns)
*	Reading 11 from address 1110 (from port 1) during cycle 109 (1090ns - 1100ns)
*	Writing 11  to  address 1110 (from port 0) during cycle 110 (1100ns - 1110ns)
*	Reading 11 from address 0000 (from port 0) during cycle 111 (1110ns - 1120ns)
*	Reading 11 from address 0000 (from port 1) during cycle 112 (1120ns - 1130ns)
*	Reading 11 from address 0000 (from port 1) during cycle 113 (1130ns - 1140ns)
*	Writing 10  to  address 1110 (from port 1) during cycle 114 (1140ns - 1150ns)
*	Reading 11 from address 0000 (from port 0) during cycle 115 (1150ns - 1160ns)
*	Writing 10  to  address 1110 (from port 1) during cycle 115 (1150ns - 1160ns)
*	Writing 10  to  address 0000 (from port 0) during cycle 116 (1160ns - 1170ns)
*	Writing 01  to  address 1110 (from port 1) during cycle 116 (1160ns - 1170ns)
*	Reading 01 from address 1110 (from port 0) during cycle 117 (1170ns - 1180ns)
*	Writing 11  to  address 0000 (from port 0) during cycle 118 (1180ns - 1190ns)
*	Writing 11  to  address 1110 (from port 1) during cycle 118 (1180ns - 1190ns)
*	Reading 11 from address 1110 (from port 0) during cycle 119 (1190ns - 1200ns)
*	Writing 10  to  address 1110 (from port 0) during cycle 121 (1210ns - 1220ns)
*	Writing 01  to  address 1110 (from port 0) during cycle 122 (1220ns - 1230ns)
*	Writing 01  to  address 1110 (from port 0) during cycle 123 (1230ns - 1240ns)
*	Writing 11  to  address 0000 (from port 1) during cycle 123 (1230ns - 1240ns)
*	Reading 01 from address 1110 (from port 0) during cycle 124 (1240ns - 1250ns)
*	Reading 11 from address 0000 (from port 1) during cycle 125 (1250ns - 1260ns)
*	Reading 01 from address 1110 (from port 0) during cycle 126 (1260ns - 1270ns)
*	Reading 01 from address 1110 (from port 0) during cycle 127 (1270ns - 1280ns)
*	Reading 01 from address 1110 (from port 1) during cycle 127 (1270ns - 1280ns)
*	Reading 01 from address 1110 (from port 0) during cycle 128 (1280ns - 1290ns)
*	Reading 11 from address 0000 (from port 0) during cycle 129 (1290ns - 1300ns)
*	Reading 01 from address 1110 (from port 1) during cycle 129 (1290ns - 1300ns)
*	Reading 01 from address 1110 (from port 0) during cycle 130 (1300ns - 1310ns)
*	Writing 11  to  address 1110 (from port 1) during cycle 130 (1300ns - 1310ns)
*	Reading 11 from address 1110 (from port 0) during cycle 131 (1310ns - 1320ns)
*	Writing 01  to  address 0000 (from port 0) during cycle 132 (1320ns - 1330ns)
*	Reading 11 from address 1110 (from port 0) during cycle 133 (1330ns - 1340ns)
*	Reading 11 from address 1110 (from port 1) during cycle 133 (1330ns - 1340ns)
*	Reading 11 from address 1110 (from port 0) during cycle 134 (1340ns - 1350ns)
*	Reading 11 from address 1110 (from port 1) during cycle 134 (1340ns - 1350ns)
*	Reading 11 from address 1110 (from port 0) during cycle 135 (1350ns - 1360ns)
*	Writing 11  to  address 0000 (from port 1) during cycle 135 (1350ns - 1360ns)
*	Reading 11 from address 0000 (from port 0) during cycle 136 (1360ns - 1370ns)
*	Writing 10  to  address 1110 (from port 1) during cycle 136 (1360ns - 1370ns)
*	Writing 01  to  address 0000 (from port 0) during cycle 137 (1370ns - 1380ns)
*	Writing 01  to  address 1110 (from port 1) during cycle 138 (1380ns - 1390ns)
*	Writing 01  to  address 0000 (from port 0) during cycle 139 (1390ns - 1400ns)
*	Writing 11  to  address 1110 (from port 0) during cycle 140 (1400ns - 1410ns)
*	Reading 11 from address 1110 (from port 1) during cycle 141 (1410ns - 1420ns)
*	Reading 01 from address 0000 (from port 0) during cycle 142 (1420ns - 1430ns)
*	Writing 01  to  address 1110 (from port 1) during cycle 142 (1420ns - 1430ns)
*	Reading 01 from address 1110 (from port 1) during cycle 143 (1430ns - 1440ns)
*	Reading 01 from address 1110 (from port 1) during cycle 144 (1440ns - 1450ns)
*	Writing 11  to  address 1110 (from port 0) during cycle 145 (1450ns - 1460ns)
*	Reading 01 from address 0000 (from port 1) during cycle 145 (1450ns - 1460ns)
*	Reading 01 from address 0000 (from port 0) during cycle 147 (1470ns - 1480ns)
*	Reading 01 from address 0000 (from port 1) during cycle 147 (1470ns - 1480ns)
*	Reading 01 from address 0000 (from port 0) during cycle 148 (1480ns - 1490ns)
*	Writing 11  to  address 1110 (from port 0) during cycle 149 (1490ns - 1500ns)
*	Writing 10  to  address 0000 (from port 1) during cycle 149 (1490ns - 1500ns)
*	Writing 10  to  address 0000 (from port 0) during cycle 150 (1500ns - 1510ns)
*	Writing 01  to  address 1110 (from port 1) during cycle 150 (1500ns - 1510ns)
*	Reading 01 from address 1110 (from port 1) during cycle 151 (1510ns - 1520ns)
*	Writing 11  to  address 0000 (from port 0) during cycle 152 (1520ns - 1530ns)
*	Writing 10  to  address 0000 (from port 1) during cycle 153 (1530ns - 1540ns)
*	Reading 10 from address 0000 (from port 1) during cycle 154 (1540ns - 1550ns)
*	Writing 01  to  address 0000 (from port 0) during cycle 155 (1550ns - 1560ns)
*	Reading 01 from address 1110 (from port 1) during cycle 155 (1550ns - 1560ns)
*	Reading 01 from address 0000 (from port 0) during cycle 156 (1560ns - 1570ns)
*	Writing 10  to  address 0000 (from port 1) during cycle 156 (1560ns - 1570ns)
*	Writing 11  to  address 1110 (from port 0) during cycle 157 (1570ns - 1580ns)
*	Writing 10  to  address 1110 (from port 0) during cycle 158 (1580ns - 1590ns)
*	Writing 11  to  address 0000 (from port 1) during cycle 158 (1580ns - 1590ns)
*	Reading 11 from address 0000 (from port 0) during cycle 159 (1590ns - 1600ns)
*	Reading 10 from address 1110 (from port 1) during cycle 159 (1590ns - 1600ns)
*	Reading 10 from address 1110 (from port 0) during cycle 160 (1600ns - 1610ns)
*	Reading 10 from address 1110 (from port 1) during cycle 160 (1600ns - 1610ns)
*	Reading 11 from address 0000 (from port 0) during cycle 161 (1610ns - 1620ns)
*	Writing 11  to  address 0000 (from port 0) during cycle 162 (1620ns - 1630ns)
*	Writing 01  to  address 0000 (from port 1) during cycle 163 (1630ns - 1640ns)
*	Reading 10 from address 1110 (from port 0) during cycle 164 (1640ns - 1650ns)
*	Reading 01 from address 0000 (from port 0) during cycle 165 (1650ns - 1660ns)
*	Reading 01 from address 0000 (from port 1) during cycle 165 (1650ns - 1660ns)
*	Reading 10 from address 1110 (from port 0) during cycle 166 (1660ns - 1670ns)
*	Writing 01  to  address 1110 (from port 1) during cycle 167 (1670ns - 1680ns)
*	Reading 01 from address 1110 (from port 0) during cycle 168 (1680ns - 1690ns)
*	Reading 01 from address 0000 (from port 1) during cycle 168 (1680ns - 1690ns)
*	Reading 01 from address 0000 (from port 0) during cycle 169 (1690ns - 1700ns)
*	Writing 10  to  address 1110 (from port 1) during cycle 169 (1690ns - 1700ns)
*	Reading 01 from address 0000 (from port 0) during cycle 170 (1700ns - 1710ns)
*	Writing 11  to  address 1110 (from port 1) during cycle 170 (1700ns - 1710ns)
*	Reading 01 from address 0000 (from port 1) during cycle 171 (1710ns - 1720ns)
*	Reading 01 from address 0000 (from port 0) during cycle 172 (1720ns - 1730ns)
*	Reading 11 from address 1110 (from port 1) during cycle 172 (1720ns - 1730ns)
*	Reading 01 from address 0000 (from port 1) during cycle 173 (1730ns - 1740ns)
*	Writing 11  to  address 0000 (from port 0) during cycle 174 (1740ns - 1750ns)
*	Reading 11 from address 1110 (from port 0) during cycle 175 (1750ns - 1760ns)
*	Reading 11 from address 0000 (from port 1) during cycle 175 (1750ns - 1760ns)
*	Reading 11 from address 0000 (from port 0) during cycle 176 (1760ns - 1770ns)
*	Reading 11 from address 0000 (from port 1) during cycle 176 (1760ns - 1770ns)
*	Reading 11 from address 1110 (from port 0) during cycle 177 (1770ns - 1780ns)
*	Reading 11 from address 0000 (from port 1) during cycle 177 (1770ns - 1780ns)
*	Reading 11 from address 0000 (from port 0) during cycle 178 (1780ns - 1790ns)
*	Reading 11 from address 0000 (from port 1) during cycle 178 (1780ns - 1790ns)
*	Reading 11 from address 0000 (from port 0) during cycle 179 (1790ns - 1800ns)
*	Writing 10  to  address 0000 (from port 1) during cycle 179 (1790ns - 1800ns)
*	Reading 10 from address 0000 (from port 0) during cycle 180 (1800ns - 1810ns)
*	Reading 10 from address 0000 (from port 1) during cycle 180 (1800ns - 1810ns)
*	Reading 11 from address 1110 (from port 0) during cycle 181 (1810ns - 1820ns)
*	Reading 11 from address 1110 (from port 0) during cycle 182 (1820ns - 1830ns)
*	Reading 11 from address 1110 (from port 0) during cycle 183 (1830ns - 1840ns)
*	Reading 11 from address 1110 (from port 0) during cycle 184 (1840ns - 1850ns)
*	Reading 11 from address 1110 (from port 1) during cycle 184 (1840ns - 1850ns)
*	Writing 11  to  address 1110 (from port 0) during cycle 185 (1850ns - 1860ns)
*	Reading 11 from address 1110 (from port 0) during cycle 186 (1860ns - 1870ns)
*	Writing 01  to  address 0000 (from port 1) during cycle 186 (1860ns - 1870ns)
*	Writing 10  to  address 1110 (from port 0) during cycle 187 (1870ns - 1880ns)
*	Reading 01 from address 0000 (from port 1) during cycle 187 (1870ns - 1880ns)
*	Reading 10 from address 1110 (from port 0) during cycle 188 (1880ns - 1890ns)
*	Reading 10 from address 1110 (from port 1) during cycle 188 (1880ns - 1890ns)
*	Writing 11  to  address 0000 (from port 0) during cycle 189 (1890ns - 1900ns)
*	Writing 10  to  address 1110 (from port 0) during cycle 191 (1910ns - 1920ns)
*	Reading 11 from address 0000 (from port 1) during cycle 191 (1910ns - 1920ns)
*	Writing 01  to  address 1110 (from port 0) during cycle 192 (1920ns - 1930ns)
*	Reading 11 from address 0000 (from port 1) during cycle 192 (1920ns - 1930ns)
*	Writing 10  to  address 0000 (from port 0) during cycle 193 (1930ns - 1940ns)
*	Writing 10  to  address 1110 (from port 1) during cycle 193 (1930ns - 1940ns)
*	Reading 10 from address 1110 (from port 0) during cycle 194 (1940ns - 1950ns)
*	Writing 11  to  address 0000 (from port 1) during cycle 194 (1940ns - 1950ns)
*	Writing 01  to  address 1110 (from port 0) during cycle 195 (1950ns - 1960ns)
*	Writing 10  to  address 1110 (from port 0) during cycle 196 (1960ns - 1970ns)
*	Reading 11 from address 0000 (from port 0) during cycle 198 (1980ns - 1990ns)
*	Reading 11 from address 0000 (from port 1) during cycle 198 (1980ns - 1990ns)
*	Writing 10  to  address 1110 (from port 0) during cycle 199 (1990ns - 2000ns)
*	Reading 10 from address 1110 (from port 1) during cycle 200 (2000ns - 2010ns)
*	Reading 11 from address 0000 (from port 1) during cycle 201 (2010ns - 2020ns)
*	Reading 10 from address 1110 (from port 1) during cycle 202 (2020ns - 2030ns)
*	Reading 10 from address 1110 (from port 0) during cycle 203 (2030ns - 2040ns)
*	Writing 01  to  address 0000 (from port 0) during cycle 204 (2040ns - 2050ns)
*	Writing 01  to  address 1110 (from port 1) during cycle 204 (2040ns - 2050ns)
*	Idle during cycle 205 (2050ns - 2060ns)

* Generation of data and address signals
* (time, data): [(0, 0), (10, 1), (20, 1), (30, 1), (40, 1), (50, 1), (60, 1), (70, 1), (80, 1), (90, 1), (100, 1), (110, 1), (120, 1), (130, 1), (140, 1), (150, 1), (160, 1), (170, 1), (180, 1), (190, 1), (200, 1), (210, 1), (220, 1), (230, 1), (240, 1), (250, 0), (260, 0), (270, 0), (280, 0), (290, 0), (300, 0), (310, 0), (320, 0), (330, 0), (340, 0), (350, 0), (360, 0), (370, 0), (380, 1), (390, 1), (400, 0), (410, 0), (420, 0), (430, 0), (440, 0), (450, 1), (460, 1), (470, 1), (480, 1), (490, 1), (500, 1), (510, 1), (520, 1), (530, 1), (540, 1), (550, 1), (560, 0), (570, 1), (580, 1), (590, 1), (600, 1), (610, 0), (620, 0), (630, 0), (640, 0), (650, 0), (660, 0), (670, 0), (680, 0), (690, 0), (700, 0), (710, 0), (720, 0), (730, 0), (740, 0), (750, 0), (760, 1), (770, 1), (780, 1), (790, 0), (800, 0), (810, 0), (820, 0), (830, 0), (840, 1), (850, 1), (860, 1), (870, 1), (880, 1), (890, 1), (900, 1), (910, 1), (920, 1), (930, 1), (940, 1), (950, 1), (960, 1), (970, 1), (980, 1), (990, 1), (1000, 1), (1010, 1), (1020, 1), (1030, 1), (1040, 1), (1050, 1), (1060, 1), (1070, 1), (1080, 1), (1090, 1), (1100, 1), (1110, 1), (1120, 1), (1130, 1), (1140, 1), (1150, 1), (1160, 0), (1170, 0), (1180, 1), (1190, 1), (1200, 1), (1210, 0), (1220, 1), (1230, 1), (1240, 1), (1250, 1), (1260, 1), (1270, 1), (1280, 1), (1290, 1), (1300, 1), (1310, 1), (1320, 1), (1330, 1), (1340, 1), (1350, 1), (1360, 1), (1370, 1), (1380, 1), (1390, 1), (1400, 1), (1410, 1), (1420, 1), (1430, 1), (1440, 1), (1450, 1), (1460, 1), (1470, 1), (1480, 1), (1490, 1), (1500, 0), (1510, 0), (1520, 1), (1530, 1), (1540, 1), (1550, 1), (1560, 1), (1570, 1), (1580, 0), (1590, 0), (1600, 0), (1610, 0), (1620, 1), (1630, 1), (1640, 1), (1650, 1), (1660, 1), (1670, 1), (1680, 1), (1690, 1), (1700, 1), (1710, 1), (1720, 1), (1730, 1), (1740, 1), (1750, 1), (1760, 1), (1770, 1), (1780, 1), (1790, 1), (1800, 1), (1810, 1), (1820, 1), (1830, 1), (1840, 1), (1850, 1), (1860, 1), (1870, 0), (1880, 0), (1890, 1), (1900, 1), (1910, 0), (1920, 1), (1930, 0), (1940, 0), (1950, 1), (1960, 0), (1970, 0), (1980, 0), (1990, 0), (2000, 0), (2010, 0), (2020, 0), (2030, 0), (2040, 1), (2050, 1)]
Vdin0_0  din0_0  0 PWL (0n 0.0v 9.495n 0.0v 9.505n 3.3v 19.495n 3.3v 19.505n 3.3v 29.495n 3.3v 29.505n 3.3v 39.495n 3.3v 39.505n 3.3v 49.495n 3.3v 49.505n 3.3v 59.495n 3.3v 59.505n 3.3v 69.495n 3.3v 69.505n 3.3v 79.495n 3.3v 79.505n 3.3v 89.495n 3.3v 89.505n 3.3v 99.495n 3.3v 99.505n 3.3v 109.495n 3.3v 109.505n 3.3v 119.495n 3.3v 119.505n 3.3v 129.495n 3.3v 129.505n 3.3v 139.495n 3.3v 139.505n 3.3v 149.495n 3.3v 149.505n 3.3v 159.495n 3.3v 159.505n 3.3v 169.495n 3.3v 169.505n 3.3v 179.495n 3.3v 179.505n 3.3v 189.495n 3.3v 189.505n 3.3v 199.495n 3.3v 199.505n 3.3v 209.495n 3.3v 209.505n 3.3v 219.495n 3.3v 219.505n 3.3v 229.495n 3.3v 229.505n 3.3v 239.495n 3.3v 239.505n 3.3v 249.495n 3.3v 249.505n 0.0v 259.495n 0.0v 259.505n 0.0v 269.495n 0.0v 269.505n 0.0v 279.495n 0.0v 279.505n 0.0v 289.495n 0.0v 289.505n 0.0v 299.495n 0.0v 299.505n 0.0v 309.495n 0.0v 309.505n 0.0v 319.495n 0.0v 319.505n 0.0v 329.495n 0.0v 329.505n 0.0v 339.495n 0.0v 339.505n 0.0v 349.495n 0.0v 349.505n 0.0v 359.495n 0.0v 359.505n 0.0v 369.495n 0.0v 369.505n 0.0v 379.495n 0.0v 379.505n 3.3v 389.495n 3.3v 389.505n 3.3v 399.495n 3.3v 399.505n 0.0v 409.495n 0.0v 409.505n 0.0v 419.495n 0.0v 419.505n 0.0v 429.495n 0.0v 429.505n 0.0v 439.495n 0.0v 439.505n 0.0v 449.495n 0.0v 449.505n 3.3v 459.495n 3.3v 459.505n 3.3v 469.495n 3.3v 469.505n 3.3v 479.495n 3.3v 479.505n 3.3v 489.495n 3.3v 489.505n 3.3v 499.495n 3.3v 499.505n 3.3v 509.495n 3.3v 509.505n 3.3v 519.495n 3.3v 519.505n 3.3v 529.495n 3.3v 529.505n 3.3v 539.495n 3.3v 539.505n 3.3v 549.495n 3.3v 549.505n 3.3v 559.495n 3.3v 559.505n 0.0v 569.495n 0.0v 569.505n 3.3v 579.495n 3.3v 579.505n 3.3v 589.495n 3.3v 589.505n 3.3v 599.495n 3.3v 599.505n 3.3v 609.495n 3.3v 609.505n 0.0v 619.495n 0.0v 619.505n 0.0v 629.495n 0.0v 629.505n 0.0v 639.495n 0.0v 639.505n 0.0v 649.495n 0.0v 649.505n 0.0v 659.495n 0.0v 659.505n 0.0v 669.495n 0.0v 669.505n 0.0v 679.495n 0.0v 679.505n 0.0v 689.495n 0.0v 689.505n 0.0v 699.495n 0.0v 699.505n 0.0v 709.495n 0.0v 709.505n 0.0v 719.495n 0.0v 719.505n 0.0v 729.495n 0.0v 729.505n 0.0v 739.495n 0.0v 739.505n 0.0v 749.495n 0.0v 749.505n 0.0v 759.495n 0.0v 759.505n 3.3v 769.495n 3.3v 769.505n 3.3v 779.495n 3.3v 779.505n 3.3v 789.495n 3.3v 789.505n 0.0v 799.495n 0.0v 799.505n 0.0v 809.495n 0.0v 809.505n 0.0v 819.495n 0.0v 819.505n 0.0v 829.495n 0.0v 829.505n 0.0v 839.495n 0.0v 839.505n 3.3v 849.495n 3.3v 849.505n 3.3v 859.495n 3.3v 859.505n 3.3v 869.495n 3.3v 869.505n 3.3v 879.495n 3.3v 879.505n 3.3v 889.495n 3.3v 889.505n 3.3v 899.495n 3.3v 899.505n 3.3v 909.495n 3.3v 909.505n 3.3v 919.495n 3.3v 919.505n 3.3v 929.495n 3.3v 929.505n 3.3v 939.495n 3.3v 939.505n 3.3v 949.495n 3.3v 949.505n 3.3v 959.495n 3.3v 959.505n 3.3v 969.495n 3.3v 969.505n 3.3v 979.495n 3.3v 979.505n 3.3v 989.495n 3.3v 989.505n 3.3v 999.495n 3.3v 999.505n 3.3v 1009.495n 3.3v 1009.505n 3.3v 1019.495n 3.3v 1019.505n 3.3v 1029.495n 3.3v 1029.505n 3.3v 1039.495n 3.3v 1039.505n 3.3v 1049.495n 3.3v 1049.505n 3.3v 1059.495n 3.3v 1059.505n 3.3v 1069.495n 3.3v 1069.505n 3.3v 1079.495n 3.3v 1079.505n 3.3v 1089.495n 3.3v 1089.505n 3.3v 1099.495n 3.3v 1099.505n 3.3v 1109.495n 3.3v 1109.505n 3.3v 1119.495n 3.3v 1119.505n 3.3v 1129.495n 3.3v 1129.505n 3.3v 1139.495n 3.3v 1139.505n 3.3v 1149.495n 3.3v 1149.505n 3.3v 1159.495n 3.3v 1159.505n 0.0v 1169.495n 0.0v 1169.505n 0.0v 1179.495n 0.0v 1179.505n 3.3v 1189.495n 3.3v 1189.505n 3.3v 1199.495n 3.3v 1199.505n 3.3v 1209.495n 3.3v 1209.505n 0.0v 1219.495n 0.0v 1219.505n 3.3v 1229.495n 3.3v 1229.505n 3.3v 1239.495n 3.3v 1239.505n 3.3v 1249.495n 3.3v 1249.505n 3.3v 1259.495n 3.3v 1259.505n 3.3v 1269.495n 3.3v 1269.505n 3.3v 1279.495n 3.3v 1279.505n 3.3v 1289.495n 3.3v 1289.505n 3.3v 1299.495n 3.3v 1299.505n 3.3v 1309.495n 3.3v 1309.505n 3.3v 1319.495n 3.3v 1319.505n 3.3v 1329.495n 3.3v 1329.505n 3.3v 1339.495n 3.3v 1339.505n 3.3v 1349.495n 3.3v 1349.505n 3.3v 1359.495n 3.3v 1359.505n 3.3v 1369.495n 3.3v 1369.505n 3.3v 1379.495n 3.3v 1379.505n 3.3v 1389.495n 3.3v 1389.505n 3.3v 1399.495n 3.3v 1399.505n 3.3v 1409.495n 3.3v 1409.505n 3.3v 1419.495n 3.3v 1419.505n 3.3v 1429.495n 3.3v 1429.505n 3.3v 1439.495n 3.3v 1439.505n 3.3v 1449.495n 3.3v 1449.505n 3.3v 1459.495n 3.3v 1459.505n 3.3v 1469.495n 3.3v 1469.505n 3.3v 1479.495n 3.3v 1479.505n 3.3v 1489.495n 3.3v 1489.505n 3.3v 1499.495n 3.3v 1499.505n 0.0v 1509.495n 0.0v 1509.505n 0.0v 1519.495n 0.0v 1519.505n 3.3v 1529.495n 3.3v 1529.505n 3.3v 1539.495n 3.3v 1539.505n 3.3v 1549.495n 3.3v 1549.505n 3.3v 1559.495n 3.3v 1559.505n 3.3v 1569.495n 3.3v 1569.505n 3.3v 1579.495n 3.3v 1579.505n 0.0v 1589.495n 0.0v 1589.505n 0.0v 1599.495n 0.0v 1599.505n 0.0v 1609.495n 0.0v 1609.505n 0.0v 1619.495n 0.0v 1619.505n 3.3v 1629.495n 3.3v 1629.505n 3.3v 1639.495n 3.3v 1639.505n 3.3v 1649.495n 3.3v 1649.505n 3.3v 1659.495n 3.3v 1659.505n 3.3v 1669.495n 3.3v 1669.505n 3.3v 1679.495n 3.3v 1679.505n 3.3v 1689.495n 3.3v 1689.505n 3.3v 1699.495n 3.3v 1699.505n 3.3v 1709.495n 3.3v 1709.505n 3.3v 1719.495n 3.3v 1719.505n 3.3v 1729.495n 3.3v 1729.505n 3.3v 1739.495n 3.3v 1739.505n 3.3v 1749.495n 3.3v 1749.505n 3.3v 1759.495n 3.3v 1759.505n 3.3v 1769.495n 3.3v 1769.505n 3.3v 1779.495n 3.3v 1779.505n 3.3v 1789.495n 3.3v 1789.505n 3.3v 1799.495n 3.3v 1799.505n 3.3v 1809.495n 3.3v 1809.505n 3.3v 1819.495n 3.3v 1819.505n 3.3v 1829.495n 3.3v 1829.505n 3.3v 1839.495n 3.3v 1839.505n 3.3v 1849.495n 3.3v 1849.505n 3.3v 1859.495n 3.3v 1859.505n 3.3v 1869.495n 3.3v 1869.505n 0.0v 1879.495n 0.0v 1879.505n 0.0v 1889.495n 0.0v 1889.505n 3.3v 1899.495n 3.3v 1899.505n 3.3v 1909.495n 3.3v 1909.505n 0.0v 1919.495n 0.0v 1919.505n 3.3v 1929.495n 3.3v 1929.505n 0.0v 1939.495n 0.0v 1939.505n 0.0v 1949.495n 0.0v 1949.505n 3.3v 1959.495n 3.3v 1959.505n 0.0v 1969.495n 0.0v 1969.505n 0.0v 1979.495n 0.0v 1979.505n 0.0v 1989.495n 0.0v 1989.505n 0.0v 1999.495n 0.0v 1999.505n 0.0v 2009.495n 0.0v 2009.505n 0.0v 2019.495n 0.0v 2019.505n 0.0v 2029.495n 0.0v 2029.505n 0.0v 2039.495n 0.0v 2039.505n 3.3v 2049.495n 3.3v 2049.505n 3.3v )
* (time, data): [(0, 0), (10, 0), (20, 0), (30, 0), (40, 0), (50, 0), (60, 0), (70, 0), (80, 0), (90, 0), (100, 0), (110, 1), (120, 1), (130, 1), (140, 1), (150, 1), (160, 1), (170, 1), (180, 1), (190, 1), (200, 1), (210, 1), (220, 1), (230, 1), (240, 1), (250, 1), (260, 1), (270, 1), (280, 1), (290, 1), (300, 1), (310, 1), (320, 1), (330, 1), (340, 1), (350, 1), (360, 1), (370, 1), (380, 1), (390, 1), (400, 1), (410, 1), (420, 1), (430, 1), (440, 1), (450, 1), (460, 1), (470, 1), (480, 1), (490, 1), (500, 1), (510, 1), (520, 1), (530, 1), (540, 0), (550, 1), (560, 1), (570, 1), (580, 1), (590, 1), (600, 1), (610, 1), (620, 1), (630, 1), (640, 1), (650, 1), (660, 1), (670, 1), (680, 1), (690, 1), (700, 1), (710, 1), (720, 1), (730, 1), (740, 1), (750, 1), (760, 0), (770, 0), (780, 0), (790, 1), (800, 1), (810, 1), (820, 1), (830, 1), (840, 1), (850, 1), (860, 1), (870, 1), (880, 1), (890, 1), (900, 1), (910, 1), (920, 1), (930, 1), (940, 1), (950, 0), (960, 0), (970, 0), (980, 0), (990, 0), (1000, 0), (1010, 0), (1020, 1), (1030, 1), (1040, 1), (1050, 1), (1060, 1), (1070, 1), (1080, 1), (1090, 1), (1100, 1), (1110, 1), (1120, 1), (1130, 1), (1140, 1), (1150, 1), (1160, 1), (1170, 1), (1180, 1), (1190, 1), (1200, 1), (1210, 1), (1220, 0), (1230, 0), (1240, 0), (1250, 0), (1260, 0), (1270, 0), (1280, 0), (1290, 0), (1300, 0), (1310, 0), (1320, 0), (1330, 0), (1340, 0), (1350, 0), (1360, 0), (1370, 0), (1380, 0), (1390, 0), (1400, 1), (1410, 1), (1420, 1), (1430, 1), (1440, 1), (1450, 1), (1460, 1), (1470, 1), (1480, 1), (1490, 1), (1500, 1), (1510, 1), (1520, 1), (1530, 1), (1540, 1), (1550, 0), (1560, 0), (1570, 1), (1580, 1), (1590, 1), (1600, 1), (1610, 1), (1620, 1), (1630, 1), (1640, 1), (1650, 1), (1660, 1), (1670, 1), (1680, 1), (1690, 1), (1700, 1), (1710, 1), (1720, 1), (1730, 1), (1740, 1), (1750, 1), (1760, 1), (1770, 1), (1780, 1), (1790, 1), (1800, 1), (1810, 1), (1820, 1), (1830, 1), (1840, 1), (1850, 1), (1860, 1), (1870, 1), (1880, 1), (1890, 1), (1900, 1), (1910, 1), (1920, 0), (1930, 1), (1940, 1), (1950, 0), (1960, 1), (1970, 1), (1980, 1), (1990, 1), (2000, 1), (2010, 1), (2020, 1), (2030, 1), (2040, 0), (2050, 0)]
Vdin0_1  din0_1  0 PWL (0n 0.0v 9.495n 0.0v 9.505n 0.0v 19.495n 0.0v 19.505n 0.0v 29.495n 0.0v 29.505n 0.0v 39.495n 0.0v 39.505n 0.0v 49.495n 0.0v 49.505n 0.0v 59.495n 0.0v 59.505n 0.0v 69.495n 0.0v 69.505n 0.0v 79.495n 0.0v 79.505n 0.0v 89.495n 0.0v 89.505n 0.0v 99.495n 0.0v 99.505n 0.0v 109.495n 0.0v 109.505n 3.3v 119.495n 3.3v 119.505n 3.3v 129.495n 3.3v 129.505n 3.3v 139.495n 3.3v 139.505n 3.3v 149.495n 3.3v 149.505n 3.3v 159.495n 3.3v 159.505n 3.3v 169.495n 3.3v 169.505n 3.3v 179.495n 3.3v 179.505n 3.3v 189.495n 3.3v 189.505n 3.3v 199.495n 3.3v 199.505n 3.3v 209.495n 3.3v 209.505n 3.3v 219.495n 3.3v 219.505n 3.3v 229.495n 3.3v 229.505n 3.3v 239.495n 3.3v 239.505n 3.3v 249.495n 3.3v 249.505n 3.3v 259.495n 3.3v 259.505n 3.3v 269.495n 3.3v 269.505n 3.3v 279.495n 3.3v 279.505n 3.3v 289.495n 3.3v 289.505n 3.3v 299.495n 3.3v 299.505n 3.3v 309.495n 3.3v 309.505n 3.3v 319.495n 3.3v 319.505n 3.3v 329.495n 3.3v 329.505n 3.3v 339.495n 3.3v 339.505n 3.3v 349.495n 3.3v 349.505n 3.3v 359.495n 3.3v 359.505n 3.3v 369.495n 3.3v 369.505n 3.3v 379.495n 3.3v 379.505n 3.3v 389.495n 3.3v 389.505n 3.3v 399.495n 3.3v 399.505n 3.3v 409.495n 3.3v 409.505n 3.3v 419.495n 3.3v 419.505n 3.3v 429.495n 3.3v 429.505n 3.3v 439.495n 3.3v 439.505n 3.3v 449.495n 3.3v 449.505n 3.3v 459.495n 3.3v 459.505n 3.3v 469.495n 3.3v 469.505n 3.3v 479.495n 3.3v 479.505n 3.3v 489.495n 3.3v 489.505n 3.3v 499.495n 3.3v 499.505n 3.3v 509.495n 3.3v 509.505n 3.3v 519.495n 3.3v 519.505n 3.3v 529.495n 3.3v 529.505n 3.3v 539.495n 3.3v 539.505n 0.0v 549.495n 0.0v 549.505n 3.3v 559.495n 3.3v 559.505n 3.3v 569.495n 3.3v 569.505n 3.3v 579.495n 3.3v 579.505n 3.3v 589.495n 3.3v 589.505n 3.3v 599.495n 3.3v 599.505n 3.3v 609.495n 3.3v 609.505n 3.3v 619.495n 3.3v 619.505n 3.3v 629.495n 3.3v 629.505n 3.3v 639.495n 3.3v 639.505n 3.3v 649.495n 3.3v 649.505n 3.3v 659.495n 3.3v 659.505n 3.3v 669.495n 3.3v 669.505n 3.3v 679.495n 3.3v 679.505n 3.3v 689.495n 3.3v 689.505n 3.3v 699.495n 3.3v 699.505n 3.3v 709.495n 3.3v 709.505n 3.3v 719.495n 3.3v 719.505n 3.3v 729.495n 3.3v 729.505n 3.3v 739.495n 3.3v 739.505n 3.3v 749.495n 3.3v 749.505n 3.3v 759.495n 3.3v 759.505n 0.0v 769.495n 0.0v 769.505n 0.0v 779.495n 0.0v 779.505n 0.0v 789.495n 0.0v 789.505n 3.3v 799.495n 3.3v 799.505n 3.3v 809.495n 3.3v 809.505n 3.3v 819.495n 3.3v 819.505n 3.3v 829.495n 3.3v 829.505n 3.3v 839.495n 3.3v 839.505n 3.3v 849.495n 3.3v 849.505n 3.3v 859.495n 3.3v 859.505n 3.3v 869.495n 3.3v 869.505n 3.3v 879.495n 3.3v 879.505n 3.3v 889.495n 3.3v 889.505n 3.3v 899.495n 3.3v 899.505n 3.3v 909.495n 3.3v 909.505n 3.3v 919.495n 3.3v 919.505n 3.3v 929.495n 3.3v 929.505n 3.3v 939.495n 3.3v 939.505n 3.3v 949.495n 3.3v 949.505n 0.0v 959.495n 0.0v 959.505n 0.0v 969.495n 0.0v 969.505n 0.0v 979.495n 0.0v 979.505n 0.0v 989.495n 0.0v 989.505n 0.0v 999.495n 0.0v 999.505n 0.0v 1009.495n 0.0v 1009.505n 0.0v 1019.495n 0.0v 1019.505n 3.3v 1029.495n 3.3v 1029.505n 3.3v 1039.495n 3.3v 1039.505n 3.3v 1049.495n 3.3v 1049.505n 3.3v 1059.495n 3.3v 1059.505n 3.3v 1069.495n 3.3v 1069.505n 3.3v 1079.495n 3.3v 1079.505n 3.3v 1089.495n 3.3v 1089.505n 3.3v 1099.495n 3.3v 1099.505n 3.3v 1109.495n 3.3v 1109.505n 3.3v 1119.495n 3.3v 1119.505n 3.3v 1129.495n 3.3v 1129.505n 3.3v 1139.495n 3.3v 1139.505n 3.3v 1149.495n 3.3v 1149.505n 3.3v 1159.495n 3.3v 1159.505n 3.3v 1169.495n 3.3v 1169.505n 3.3v 1179.495n 3.3v 1179.505n 3.3v 1189.495n 3.3v 1189.505n 3.3v 1199.495n 3.3v 1199.505n 3.3v 1209.495n 3.3v 1209.505n 3.3v 1219.495n 3.3v 1219.505n 0.0v 1229.495n 0.0v 1229.505n 0.0v 1239.495n 0.0v 1239.505n 0.0v 1249.495n 0.0v 1249.505n 0.0v 1259.495n 0.0v 1259.505n 0.0v 1269.495n 0.0v 1269.505n 0.0v 1279.495n 0.0v 1279.505n 0.0v 1289.495n 0.0v 1289.505n 0.0v 1299.495n 0.0v 1299.505n 0.0v 1309.495n 0.0v 1309.505n 0.0v 1319.495n 0.0v 1319.505n 0.0v 1329.495n 0.0v 1329.505n 0.0v 1339.495n 0.0v 1339.505n 0.0v 1349.495n 0.0v 1349.505n 0.0v 1359.495n 0.0v 1359.505n 0.0v 1369.495n 0.0v 1369.505n 0.0v 1379.495n 0.0v 1379.505n 0.0v 1389.495n 0.0v 1389.505n 0.0v 1399.495n 0.0v 1399.505n 3.3v 1409.495n 3.3v 1409.505n 3.3v 1419.495n 3.3v 1419.505n 3.3v 1429.495n 3.3v 1429.505n 3.3v 1439.495n 3.3v 1439.505n 3.3v 1449.495n 3.3v 1449.505n 3.3v 1459.495n 3.3v 1459.505n 3.3v 1469.495n 3.3v 1469.505n 3.3v 1479.495n 3.3v 1479.505n 3.3v 1489.495n 3.3v 1489.505n 3.3v 1499.495n 3.3v 1499.505n 3.3v 1509.495n 3.3v 1509.505n 3.3v 1519.495n 3.3v 1519.505n 3.3v 1529.495n 3.3v 1529.505n 3.3v 1539.495n 3.3v 1539.505n 3.3v 1549.495n 3.3v 1549.505n 0.0v 1559.495n 0.0v 1559.505n 0.0v 1569.495n 0.0v 1569.505n 3.3v 1579.495n 3.3v 1579.505n 3.3v 1589.495n 3.3v 1589.505n 3.3v 1599.495n 3.3v 1599.505n 3.3v 1609.495n 3.3v 1609.505n 3.3v 1619.495n 3.3v 1619.505n 3.3v 1629.495n 3.3v 1629.505n 3.3v 1639.495n 3.3v 1639.505n 3.3v 1649.495n 3.3v 1649.505n 3.3v 1659.495n 3.3v 1659.505n 3.3v 1669.495n 3.3v 1669.505n 3.3v 1679.495n 3.3v 1679.505n 3.3v 1689.495n 3.3v 1689.505n 3.3v 1699.495n 3.3v 1699.505n 3.3v 1709.495n 3.3v 1709.505n 3.3v 1719.495n 3.3v 1719.505n 3.3v 1729.495n 3.3v 1729.505n 3.3v 1739.495n 3.3v 1739.505n 3.3v 1749.495n 3.3v 1749.505n 3.3v 1759.495n 3.3v 1759.505n 3.3v 1769.495n 3.3v 1769.505n 3.3v 1779.495n 3.3v 1779.505n 3.3v 1789.495n 3.3v 1789.505n 3.3v 1799.495n 3.3v 1799.505n 3.3v 1809.495n 3.3v 1809.505n 3.3v 1819.495n 3.3v 1819.505n 3.3v 1829.495n 3.3v 1829.505n 3.3v 1839.495n 3.3v 1839.505n 3.3v 1849.495n 3.3v 1849.505n 3.3v 1859.495n 3.3v 1859.505n 3.3v 1869.495n 3.3v 1869.505n 3.3v 1879.495n 3.3v 1879.505n 3.3v 1889.495n 3.3v 1889.505n 3.3v 1899.495n 3.3v 1899.505n 3.3v 1909.495n 3.3v 1909.505n 3.3v 1919.495n 3.3v 1919.505n 0.0v 1929.495n 0.0v 1929.505n 3.3v 1939.495n 3.3v 1939.505n 3.3v 1949.495n 3.3v 1949.505n 0.0v 1959.495n 0.0v 1959.505n 3.3v 1969.495n 3.3v 1969.505n 3.3v 1979.495n 3.3v 1979.505n 3.3v 1989.495n 3.3v 1989.505n 3.3v 1999.495n 3.3v 1999.505n 3.3v 2009.495n 3.3v 2009.505n 3.3v 2019.495n 3.3v 2019.505n 3.3v 2029.495n 3.3v 2029.505n 3.3v 2039.495n 3.3v 2039.505n 0.0v 2049.495n 0.0v 2049.505n 0.0v )
* (time, data): [(0, 0), (10, 0), (20, 0), (30, 1), (40, 1), (50, 1), (60, 1), (70, 1), (80, 1), (90, 1), (100, 1), (110, 1), (120, 1), (130, 1), (140, 1), (150, 1), (160, 1), (170, 1), (180, 1), (190, 1), (200, 1), (210, 1), (220, 1), (230, 1), (240, 1), (250, 1), (260, 1), (270, 1), (280, 1), (290, 1), (300, 0), (310, 0), (320, 0), (330, 0), (340, 0), (350, 1), (360, 1), (370, 0), (380, 0), (390, 1), (400, 1), (410, 1), (420, 1), (430, 1), (440, 1), (450, 1), (460, 1), (470, 1), (480, 1), (490, 1), (500, 1), (510, 1), (520, 1), (530, 1), (540, 1), (550, 1), (560, 1), (570, 0), (580, 0), (590, 0), (600, 0), (610, 0), (620, 0), (630, 0), (640, 0), (650, 0), (660, 0), (670, 0), (680, 0), (690, 0), (700, 0), (710, 0), (720, 1), (730, 1), (740, 0), (750, 0), (760, 0), (770, 0), (780, 0), (790, 0), (800, 0), (810, 0), (820, 0), (830, 0), (840, 0), (850, 1), (860, 1), (870, 1), (880, 1), (890, 1), (900, 1), (910, 1), (920, 1), (930, 1), (940, 1), (950, 1), (960, 1), (970, 1), (980, 1), (990, 1), (1000, 1), (1010, 1), (1020, 1), (1030, 1), (1040, 1), (1050, 1), (1060, 1), (1070, 1), (1080, 1), (1090, 1), (1100, 1), (1110, 1), (1120, 1), (1130, 1), (1140, 0), (1150, 0), (1160, 1), (1170, 1), (1180, 1), (1190, 1), (1200, 1), (1210, 1), (1220, 1), (1230, 1), (1240, 1), (1250, 1), (1260, 1), (1270, 1), (1280, 1), (1290, 1), (1300, 1), (1310, 1), (1320, 1), (1330, 1), (1340, 1), (1350, 1), (1360, 0), (1370, 0), (1380, 1), (1390, 1), (1400, 1), (1410, 1), (1420, 1), (1430, 1), (1440, 1), (1450, 1), (1460, 1), (1470, 1), (1480, 1), (1490, 0), (1500, 1), (1510, 1), (1520, 1), (1530, 0), (1540, 0), (1550, 0), (1560, 0), (1570, 0), (1580, 1), (1590, 1), (1600, 1), (1610, 1), (1620, 1), (1630, 1), (1640, 1), (1650, 1), (1660, 1), (1670, 1), (1680, 1), (1690, 0), (1700, 1), (1710, 1), (1720, 1), (1730, 1), (1740, 1), (1750, 1), (1760, 1), (1770, 1), (1780, 1), (1790, 0), (1800, 0), (1810, 0), (1820, 0), (1830, 0), (1840, 0), (1850, 0), (1860, 1), (1870, 1), (1880, 1), (1890, 1), (1900, 1), (1910, 1), (1920, 1), (1930, 0), (1940, 1), (1950, 1), (1960, 1), (1970, 1), (1980, 1), (1990, 1), (2000, 1), (2010, 1), (2020, 1), (2030, 1), (2040, 1), (2050, 1)]
Vdin1_0  din1_0  0 PWL (0n 0.0v 9.495n 0.0v 9.505n 0.0v 19.495n 0.0v 19.505n 0.0v 29.495n 0.0v 29.505n 3.3v 39.495n 3.3v 39.505n 3.3v 49.495n 3.3v 49.505n 3.3v 59.495n 3.3v 59.505n 3.3v 69.495n 3.3v 69.505n 3.3v 79.495n 3.3v 79.505n 3.3v 89.495n 3.3v 89.505n 3.3v 99.495n 3.3v 99.505n 3.3v 109.495n 3.3v 109.505n 3.3v 119.495n 3.3v 119.505n 3.3v 129.495n 3.3v 129.505n 3.3v 139.495n 3.3v 139.505n 3.3v 149.495n 3.3v 149.505n 3.3v 159.495n 3.3v 159.505n 3.3v 169.495n 3.3v 169.505n 3.3v 179.495n 3.3v 179.505n 3.3v 189.495n 3.3v 189.505n 3.3v 199.495n 3.3v 199.505n 3.3v 209.495n 3.3v 209.505n 3.3v 219.495n 3.3v 219.505n 3.3v 229.495n 3.3v 229.505n 3.3v 239.495n 3.3v 239.505n 3.3v 249.495n 3.3v 249.505n 3.3v 259.495n 3.3v 259.505n 3.3v 269.495n 3.3v 269.505n 3.3v 279.495n 3.3v 279.505n 3.3v 289.495n 3.3v 289.505n 3.3v 299.495n 3.3v 299.505n 0.0v 309.495n 0.0v 309.505n 0.0v 319.495n 0.0v 319.505n 0.0v 329.495n 0.0v 329.505n 0.0v 339.495n 0.0v 339.505n 0.0v 349.495n 0.0v 349.505n 3.3v 359.495n 3.3v 359.505n 3.3v 369.495n 3.3v 369.505n 0.0v 379.495n 0.0v 379.505n 0.0v 389.495n 0.0v 389.505n 3.3v 399.495n 3.3v 399.505n 3.3v 409.495n 3.3v 409.505n 3.3v 419.495n 3.3v 419.505n 3.3v 429.495n 3.3v 429.505n 3.3v 439.495n 3.3v 439.505n 3.3v 449.495n 3.3v 449.505n 3.3v 459.495n 3.3v 459.505n 3.3v 469.495n 3.3v 469.505n 3.3v 479.495n 3.3v 479.505n 3.3v 489.495n 3.3v 489.505n 3.3v 499.495n 3.3v 499.505n 3.3v 509.495n 3.3v 509.505n 3.3v 519.495n 3.3v 519.505n 3.3v 529.495n 3.3v 529.505n 3.3v 539.495n 3.3v 539.505n 3.3v 549.495n 3.3v 549.505n 3.3v 559.495n 3.3v 559.505n 3.3v 569.495n 3.3v 569.505n 0.0v 579.495n 0.0v 579.505n 0.0v 589.495n 0.0v 589.505n 0.0v 599.495n 0.0v 599.505n 0.0v 609.495n 0.0v 609.505n 0.0v 619.495n 0.0v 619.505n 0.0v 629.495n 0.0v 629.505n 0.0v 639.495n 0.0v 639.505n 0.0v 649.495n 0.0v 649.505n 0.0v 659.495n 0.0v 659.505n 0.0v 669.495n 0.0v 669.505n 0.0v 679.495n 0.0v 679.505n 0.0v 689.495n 0.0v 689.505n 0.0v 699.495n 0.0v 699.505n 0.0v 709.495n 0.0v 709.505n 0.0v 719.495n 0.0v 719.505n 3.3v 729.495n 3.3v 729.505n 3.3v 739.495n 3.3v 739.505n 0.0v 749.495n 0.0v 749.505n 0.0v 759.495n 0.0v 759.505n 0.0v 769.495n 0.0v 769.505n 0.0v 779.495n 0.0v 779.505n 0.0v 789.495n 0.0v 789.505n 0.0v 799.495n 0.0v 799.505n 0.0v 809.495n 0.0v 809.505n 0.0v 819.495n 0.0v 819.505n 0.0v 829.495n 0.0v 829.505n 0.0v 839.495n 0.0v 839.505n 0.0v 849.495n 0.0v 849.505n 3.3v 859.495n 3.3v 859.505n 3.3v 869.495n 3.3v 869.505n 3.3v 879.495n 3.3v 879.505n 3.3v 889.495n 3.3v 889.505n 3.3v 899.495n 3.3v 899.505n 3.3v 909.495n 3.3v 909.505n 3.3v 919.495n 3.3v 919.505n 3.3v 929.495n 3.3v 929.505n 3.3v 939.495n 3.3v 939.505n 3.3v 949.495n 3.3v 949.505n 3.3v 959.495n 3.3v 959.505n 3.3v 969.495n 3.3v 969.505n 3.3v 979.495n 3.3v 979.505n 3.3v 989.495n 3.3v 989.505n 3.3v 999.495n 3.3v 999.505n 3.3v 1009.495n 3.3v 1009.505n 3.3v 1019.495n 3.3v 1019.505n 3.3v 1029.495n 3.3v 1029.505n 3.3v 1039.495n 3.3v 1039.505n 3.3v 1049.495n 3.3v 1049.505n 3.3v 1059.495n 3.3v 1059.505n 3.3v 1069.495n 3.3v 1069.505n 3.3v 1079.495n 3.3v 1079.505n 3.3v 1089.495n 3.3v 1089.505n 3.3v 1099.495n 3.3v 1099.505n 3.3v 1109.495n 3.3v 1109.505n 3.3v 1119.495n 3.3v 1119.505n 3.3v 1129.495n 3.3v 1129.505n 3.3v 1139.495n 3.3v 1139.505n 0.0v 1149.495n 0.0v 1149.505n 0.0v 1159.495n 0.0v 1159.505n 3.3v 1169.495n 3.3v 1169.505n 3.3v 1179.495n 3.3v 1179.505n 3.3v 1189.495n 3.3v 1189.505n 3.3v 1199.495n 3.3v 1199.505n 3.3v 1209.495n 3.3v 1209.505n 3.3v 1219.495n 3.3v 1219.505n 3.3v 1229.495n 3.3v 1229.505n 3.3v 1239.495n 3.3v 1239.505n 3.3v 1249.495n 3.3v 1249.505n 3.3v 1259.495n 3.3v 1259.505n 3.3v 1269.495n 3.3v 1269.505n 3.3v 1279.495n 3.3v 1279.505n 3.3v 1289.495n 3.3v 1289.505n 3.3v 1299.495n 3.3v 1299.505n 3.3v 1309.495n 3.3v 1309.505n 3.3v 1319.495n 3.3v 1319.505n 3.3v 1329.495n 3.3v 1329.505n 3.3v 1339.495n 3.3v 1339.505n 3.3v 1349.495n 3.3v 1349.505n 3.3v 1359.495n 3.3v 1359.505n 0.0v 1369.495n 0.0v 1369.505n 0.0v 1379.495n 0.0v 1379.505n 3.3v 1389.495n 3.3v 1389.505n 3.3v 1399.495n 3.3v 1399.505n 3.3v 1409.495n 3.3v 1409.505n 3.3v 1419.495n 3.3v 1419.505n 3.3v 1429.495n 3.3v 1429.505n 3.3v 1439.495n 3.3v 1439.505n 3.3v 1449.495n 3.3v 1449.505n 3.3v 1459.495n 3.3v 1459.505n 3.3v 1469.495n 3.3v 1469.505n 3.3v 1479.495n 3.3v 1479.505n 3.3v 1489.495n 3.3v 1489.505n 0.0v 1499.495n 0.0v 1499.505n 3.3v 1509.495n 3.3v 1509.505n 3.3v 1519.495n 3.3v 1519.505n 3.3v 1529.495n 3.3v 1529.505n 0.0v 1539.495n 0.0v 1539.505n 0.0v 1549.495n 0.0v 1549.505n 0.0v 1559.495n 0.0v 1559.505n 0.0v 1569.495n 0.0v 1569.505n 0.0v 1579.495n 0.0v 1579.505n 3.3v 1589.495n 3.3v 1589.505n 3.3v 1599.495n 3.3v 1599.505n 3.3v 1609.495n 3.3v 1609.505n 3.3v 1619.495n 3.3v 1619.505n 3.3v 1629.495n 3.3v 1629.505n 3.3v 1639.495n 3.3v 1639.505n 3.3v 1649.495n 3.3v 1649.505n 3.3v 1659.495n 3.3v 1659.505n 3.3v 1669.495n 3.3v 1669.505n 3.3v 1679.495n 3.3v 1679.505n 3.3v 1689.495n 3.3v 1689.505n 0.0v 1699.495n 0.0v 1699.505n 3.3v 1709.495n 3.3v 1709.505n 3.3v 1719.495n 3.3v 1719.505n 3.3v 1729.495n 3.3v 1729.505n 3.3v 1739.495n 3.3v 1739.505n 3.3v 1749.495n 3.3v 1749.505n 3.3v 1759.495n 3.3v 1759.505n 3.3v 1769.495n 3.3v 1769.505n 3.3v 1779.495n 3.3v 1779.505n 3.3v 1789.495n 3.3v 1789.505n 0.0v 1799.495n 0.0v 1799.505n 0.0v 1809.495n 0.0v 1809.505n 0.0v 1819.495n 0.0v 1819.505n 0.0v 1829.495n 0.0v 1829.505n 0.0v 1839.495n 0.0v 1839.505n 0.0v 1849.495n 0.0v 1849.505n 0.0v 1859.495n 0.0v 1859.505n 3.3v 1869.495n 3.3v 1869.505n 3.3v 1879.495n 3.3v 1879.505n 3.3v 1889.495n 3.3v 1889.505n 3.3v 1899.495n 3.3v 1899.505n 3.3v 1909.495n 3.3v 1909.505n 3.3v 1919.495n 3.3v 1919.505n 3.3v 1929.495n 3.3v 1929.505n 0.0v 1939.495n 0.0v 1939.505n 3.3v 1949.495n 3.3v 1949.505n 3.3v 1959.495n 3.3v 1959.505n 3.3v 1969.495n 3.3v 1969.505n 3.3v 1979.495n 3.3v 1979.505n 3.3v 1989.495n 3.3v 1989.505n 3.3v 1999.495n 3.3v 1999.505n 3.3v 2009.495n 3.3v 2009.505n 3.3v 2019.495n 3.3v 2019.505n 3.3v 2029.495n 3.3v 2029.505n 3.3v 2039.495n 3.3v 2039.505n 3.3v 2049.495n 3.3v 2049.505n 3.3v )
* (time, data): [(0, 0), (10, 1), (20, 1), (30, 0), (40, 0), (50, 0), (60, 0), (70, 0), (80, 0), (90, 0), (100, 0), (110, 1), (120, 1), (130, 1), (140, 1), (150, 1), (160, 1), (170, 1), (180, 1), (190, 1), (200, 0), (210, 0), (220, 0), (230, 0), (240, 0), (250, 0), (260, 0), (270, 0), (280, 0), (290, 0), (300, 1), (310, 1), (320, 1), (330, 1), (340, 1), (350, 1), (360, 1), (370, 1), (380, 1), (390, 0), (400, 0), (410, 0), (420, 0), (430, 0), (440, 0), (450, 0), (460, 0), (470, 0), (480, 0), (490, 0), (500, 0), (510, 1), (520, 1), (530, 1), (540, 1), (550, 1), (560, 1), (570, 1), (580, 1), (590, 1), (600, 1), (610, 1), (620, 1), (630, 1), (640, 1), (650, 1), (660, 1), (670, 1), (680, 1), (690, 1), (700, 1), (710, 1), (720, 1), (730, 1), (740, 1), (750, 1), (760, 1), (770, 1), (780, 1), (790, 1), (800, 1), (810, 1), (820, 1), (830, 1), (840, 1), (850, 1), (860, 1), (870, 1), (880, 1), (890, 1), (900, 1), (910, 1), (920, 1), (930, 1), (940, 1), (950, 1), (960, 1), (970, 1), (980, 1), (990, 1), (1000, 1), (1010, 1), (1020, 1), (1030, 1), (1040, 1), (1050, 1), (1060, 1), (1070, 1), (1080, 1), (1090, 1), (1100, 1), (1110, 1), (1120, 1), (1130, 1), (1140, 1), (1150, 1), (1160, 0), (1170, 0), (1180, 1), (1190, 1), (1200, 1), (1210, 1), (1220, 1), (1230, 1), (1240, 1), (1250, 1), (1260, 1), (1270, 1), (1280, 1), (1290, 1), (1300, 1), (1310, 1), (1320, 1), (1330, 1), (1340, 1), (1350, 1), (1360, 1), (1370, 1), (1380, 0), (1390, 0), (1400, 0), (1410, 0), (1420, 0), (1430, 0), (1440, 0), (1450, 0), (1460, 0), (1470, 0), (1480, 0), (1490, 1), (1500, 0), (1510, 0), (1520, 0), (1530, 1), (1540, 1), (1550, 1), (1560, 1), (1570, 1), (1580, 1), (1590, 1), (1600, 1), (1610, 1), (1620, 1), (1630, 0), (1640, 0), (1650, 0), (1660, 0), (1670, 0), (1680, 0), (1690, 1), (1700, 1), (1710, 1), (1720, 1), (1730, 1), (1740, 1), (1750, 1), (1760, 1), (1770, 1), (1780, 1), (1790, 1), (1800, 1), (1810, 1), (1820, 1), (1830, 1), (1840, 1), (1850, 1), (1860, 0), (1870, 0), (1880, 0), (1890, 0), (1900, 0), (1910, 0), (1920, 0), (1930, 1), (1940, 1), (1950, 1), (1960, 1), (1970, 1), (1980, 1), (1990, 1), (2000, 1), (2010, 1), (2020, 1), (2030, 1), (2040, 0), (2050, 0)]
Vdin1_1  din1_1  0 PWL (0n 0.0v 9.495n 0.0v 9.505n 3.3v 19.495n 3.3v 19.505n 3.3v 29.495n 3.3v 29.505n 0.0v 39.495n 0.0v 39.505n 0.0v 49.495n 0.0v 49.505n 0.0v 59.495n 0.0v 59.505n 0.0v 69.495n 0.0v 69.505n 0.0v 79.495n 0.0v 79.505n 0.0v 89.495n 0.0v 89.505n 0.0v 99.495n 0.0v 99.505n 0.0v 109.495n 0.0v 109.505n 3.3v 119.495n 3.3v 119.505n 3.3v 129.495n 3.3v 129.505n 3.3v 139.495n 3.3v 139.505n 3.3v 149.495n 3.3v 149.505n 3.3v 159.495n 3.3v 159.505n 3.3v 169.495n 3.3v 169.505n 3.3v 179.495n 3.3v 179.505n 3.3v 189.495n 3.3v 189.505n 3.3v 199.495n 3.3v 199.505n 0.0v 209.495n 0.0v 209.505n 0.0v 219.495n 0.0v 219.505n 0.0v 229.495n 0.0v 229.505n 0.0v 239.495n 0.0v 239.505n 0.0v 249.495n 0.0v 249.505n 0.0v 259.495n 0.0v 259.505n 0.0v 269.495n 0.0v 269.505n 0.0v 279.495n 0.0v 279.505n 0.0v 289.495n 0.0v 289.505n 0.0v 299.495n 0.0v 299.505n 3.3v 309.495n 3.3v 309.505n 3.3v 319.495n 3.3v 319.505n 3.3v 329.495n 3.3v 329.505n 3.3v 339.495n 3.3v 339.505n 3.3v 349.495n 3.3v 349.505n 3.3v 359.495n 3.3v 359.505n 3.3v 369.495n 3.3v 369.505n 3.3v 379.495n 3.3v 379.505n 3.3v 389.495n 3.3v 389.505n 0.0v 399.495n 0.0v 399.505n 0.0v 409.495n 0.0v 409.505n 0.0v 419.495n 0.0v 419.505n 0.0v 429.495n 0.0v 429.505n 0.0v 439.495n 0.0v 439.505n 0.0v 449.495n 0.0v 449.505n 0.0v 459.495n 0.0v 459.505n 0.0v 469.495n 0.0v 469.505n 0.0v 479.495n 0.0v 479.505n 0.0v 489.495n 0.0v 489.505n 0.0v 499.495n 0.0v 499.505n 0.0v 509.495n 0.0v 509.505n 3.3v 519.495n 3.3v 519.505n 3.3v 529.495n 3.3v 529.505n 3.3v 539.495n 3.3v 539.505n 3.3v 549.495n 3.3v 549.505n 3.3v 559.495n 3.3v 559.505n 3.3v 569.495n 3.3v 569.505n 3.3v 579.495n 3.3v 579.505n 3.3v 589.495n 3.3v 589.505n 3.3v 599.495n 3.3v 599.505n 3.3v 609.495n 3.3v 609.505n 3.3v 619.495n 3.3v 619.505n 3.3v 629.495n 3.3v 629.505n 3.3v 639.495n 3.3v 639.505n 3.3v 649.495n 3.3v 649.505n 3.3v 659.495n 3.3v 659.505n 3.3v 669.495n 3.3v 669.505n 3.3v 679.495n 3.3v 679.505n 3.3v 689.495n 3.3v 689.505n 3.3v 699.495n 3.3v 699.505n 3.3v 709.495n 3.3v 709.505n 3.3v 719.495n 3.3v 719.505n 3.3v 729.495n 3.3v 729.505n 3.3v 739.495n 3.3v 739.505n 3.3v 749.495n 3.3v 749.505n 3.3v 759.495n 3.3v 759.505n 3.3v 769.495n 3.3v 769.505n 3.3v 779.495n 3.3v 779.505n 3.3v 789.495n 3.3v 789.505n 3.3v 799.495n 3.3v 799.505n 3.3v 809.495n 3.3v 809.505n 3.3v 819.495n 3.3v 819.505n 3.3v 829.495n 3.3v 829.505n 3.3v 839.495n 3.3v 839.505n 3.3v 849.495n 3.3v 849.505n 3.3v 859.495n 3.3v 859.505n 3.3v 869.495n 3.3v 869.505n 3.3v 879.495n 3.3v 879.505n 3.3v 889.495n 3.3v 889.505n 3.3v 899.495n 3.3v 899.505n 3.3v 909.495n 3.3v 909.505n 3.3v 919.495n 3.3v 919.505n 3.3v 929.495n 3.3v 929.505n 3.3v 939.495n 3.3v 939.505n 3.3v 949.495n 3.3v 949.505n 3.3v 959.495n 3.3v 959.505n 3.3v 969.495n 3.3v 969.505n 3.3v 979.495n 3.3v 979.505n 3.3v 989.495n 3.3v 989.505n 3.3v 999.495n 3.3v 999.505n 3.3v 1009.495n 3.3v 1009.505n 3.3v 1019.495n 3.3v 1019.505n 3.3v 1029.495n 3.3v 1029.505n 3.3v 1039.495n 3.3v 1039.505n 3.3v 1049.495n 3.3v 1049.505n 3.3v 1059.495n 3.3v 1059.505n 3.3v 1069.495n 3.3v 1069.505n 3.3v 1079.495n 3.3v 1079.505n 3.3v 1089.495n 3.3v 1089.505n 3.3v 1099.495n 3.3v 1099.505n 3.3v 1109.495n 3.3v 1109.505n 3.3v 1119.495n 3.3v 1119.505n 3.3v 1129.495n 3.3v 1129.505n 3.3v 1139.495n 3.3v 1139.505n 3.3v 1149.495n 3.3v 1149.505n 3.3v 1159.495n 3.3v 1159.505n 0.0v 1169.495n 0.0v 1169.505n 0.0v 1179.495n 0.0v 1179.505n 3.3v 1189.495n 3.3v 1189.505n 3.3v 1199.495n 3.3v 1199.505n 3.3v 1209.495n 3.3v 1209.505n 3.3v 1219.495n 3.3v 1219.505n 3.3v 1229.495n 3.3v 1229.505n 3.3v 1239.495n 3.3v 1239.505n 3.3v 1249.495n 3.3v 1249.505n 3.3v 1259.495n 3.3v 1259.505n 3.3v 1269.495n 3.3v 1269.505n 3.3v 1279.495n 3.3v 1279.505n 3.3v 1289.495n 3.3v 1289.505n 3.3v 1299.495n 3.3v 1299.505n 3.3v 1309.495n 3.3v 1309.505n 3.3v 1319.495n 3.3v 1319.505n 3.3v 1329.495n 3.3v 1329.505n 3.3v 1339.495n 3.3v 1339.505n 3.3v 1349.495n 3.3v 1349.505n 3.3v 1359.495n 3.3v 1359.505n 3.3v 1369.495n 3.3v 1369.505n 3.3v 1379.495n 3.3v 1379.505n 0.0v 1389.495n 0.0v 1389.505n 0.0v 1399.495n 0.0v 1399.505n 0.0v 1409.495n 0.0v 1409.505n 0.0v 1419.495n 0.0v 1419.505n 0.0v 1429.495n 0.0v 1429.505n 0.0v 1439.495n 0.0v 1439.505n 0.0v 1449.495n 0.0v 1449.505n 0.0v 1459.495n 0.0v 1459.505n 0.0v 1469.495n 0.0v 1469.505n 0.0v 1479.495n 0.0v 1479.505n 0.0v 1489.495n 0.0v 1489.505n 3.3v 1499.495n 3.3v 1499.505n 0.0v 1509.495n 0.0v 1509.505n 0.0v 1519.495n 0.0v 1519.505n 0.0v 1529.495n 0.0v 1529.505n 3.3v 1539.495n 3.3v 1539.505n 3.3v 1549.495n 3.3v 1549.505n 3.3v 1559.495n 3.3v 1559.505n 3.3v 1569.495n 3.3v 1569.505n 3.3v 1579.495n 3.3v 1579.505n 3.3v 1589.495n 3.3v 1589.505n 3.3v 1599.495n 3.3v 1599.505n 3.3v 1609.495n 3.3v 1609.505n 3.3v 1619.495n 3.3v 1619.505n 3.3v 1629.495n 3.3v 1629.505n 0.0v 1639.495n 0.0v 1639.505n 0.0v 1649.495n 0.0v 1649.505n 0.0v 1659.495n 0.0v 1659.505n 0.0v 1669.495n 0.0v 1669.505n 0.0v 1679.495n 0.0v 1679.505n 0.0v 1689.495n 0.0v 1689.505n 3.3v 1699.495n 3.3v 1699.505n 3.3v 1709.495n 3.3v 1709.505n 3.3v 1719.495n 3.3v 1719.505n 3.3v 1729.495n 3.3v 1729.505n 3.3v 1739.495n 3.3v 1739.505n 3.3v 1749.495n 3.3v 1749.505n 3.3v 1759.495n 3.3v 1759.505n 3.3v 1769.495n 3.3v 1769.505n 3.3v 1779.495n 3.3v 1779.505n 3.3v 1789.495n 3.3v 1789.505n 3.3v 1799.495n 3.3v 1799.505n 3.3v 1809.495n 3.3v 1809.505n 3.3v 1819.495n 3.3v 1819.505n 3.3v 1829.495n 3.3v 1829.505n 3.3v 1839.495n 3.3v 1839.505n 3.3v 1849.495n 3.3v 1849.505n 3.3v 1859.495n 3.3v 1859.505n 0.0v 1869.495n 0.0v 1869.505n 0.0v 1879.495n 0.0v 1879.505n 0.0v 1889.495n 0.0v 1889.505n 0.0v 1899.495n 0.0v 1899.505n 0.0v 1909.495n 0.0v 1909.505n 0.0v 1919.495n 0.0v 1919.505n 0.0v 1929.495n 0.0v 1929.505n 3.3v 1939.495n 3.3v 1939.505n 3.3v 1949.495n 3.3v 1949.505n 3.3v 1959.495n 3.3v 1959.505n 3.3v 1969.495n 3.3v 1969.505n 3.3v 1979.495n 3.3v 1979.505n 3.3v 1989.495n 3.3v 1989.505n 3.3v 1999.495n 3.3v 1999.505n 3.3v 2009.495n 3.3v 2009.505n 3.3v 2019.495n 3.3v 2019.505n 3.3v 2029.495n 3.3v 2029.505n 3.3v 2039.495n 3.3v 2039.505n 0.0v 2049.495n 0.0v 2049.505n 0.0v )
* (time, data): [(0, 0), (10, 0), (20, 0), (30, 0), (40, 0), (50, 0), (60, 0), (70, 0), (80, 0), (90, 0), (100, 0), (110, 0), (120, 0), (130, 0), (140, 0), (150, 0), (160, 0), (170, 0), (180, 0), (190, 0), (200, 0), (210, 0), (220, 0), (230, 0), (240, 0), (250, 0), (260, 0), (270, 0), (280, 0), (290, 0), (300, 0), (310, 0), (320, 0), (330, 0), (340, 0), (350, 0), (360, 0), (370, 0), (380, 0), (390, 0), (400, 0), (410, 0), (420, 0), (430, 0), (440, 0), (450, 0), (460, 0), (470, 0), (480, 0), (490, 0), (500, 0), (510, 0), (520, 0), (530, 0), (540, 0), (550, 0), (560, 0), (570, 0), (580, 0), (590, 0), (600, 0), (610, 0), (620, 0), (630, 0), (640, 0), (650, 0), (660, 0), (670, 0), (680, 0), (690, 0), (700, 0), (710, 0), (720, 0), (730, 0), (740, 0), (750, 0), (760, 0), (770, 0), (780, 0), (790, 0), (800, 0), (810, 0), (820, 0), (830, 0), (840, 0), (850, 0), (860, 0), (870, 0), (880, 0), (890, 0), (900, 0), (910, 0), (920, 0), (930, 0), (940, 0), (950, 0), (960, 0), (970, 0), (980, 0), (990, 0), (1000, 0), (1010, 0), (1020, 0), (1030, 0), (1040, 0), (1050, 0), (1060, 0), (1070, 0), (1080, 0), (1090, 0), (1100, 0), (1110, 0), (1120, 0), (1130, 0), (1140, 0), (1150, 0), (1160, 0), (1170, 0), (1180, 0), (1190, 0), (1200, 0), (1210, 0), (1220, 0), (1230, 0), (1240, 0), (1250, 0), (1260, 0), (1270, 0), (1280, 0), (1290, 0), (1300, 0), (1310, 0), (1320, 0), (1330, 0), (1340, 0), (1350, 0), (1360, 0), (1370, 0), (1380, 0), (1390, 0), (1400, 0), (1410, 0), (1420, 0), (1430, 0), (1440, 0), (1450, 0), (1460, 0), (1470, 0), (1480, 0), (1490, 0), (1500, 0), (1510, 0), (1520, 0), (1530, 0), (1540, 0), (1550, 0), (1560, 0), (1570, 0), (1580, 0), (1590, 0), (1600, 0), (1610, 0), (1620, 0), (1630, 0), (1640, 0), (1650, 0), (1660, 0), (1670, 0), (1680, 0), (1690, 0), (1700, 0), (1710, 0), (1720, 0), (1730, 0), (1740, 0), (1750, 0), (1760, 0), (1770, 0), (1780, 0), (1790, 0), (1800, 0), (1810, 0), (1820, 0), (1830, 0), (1840, 0), (1850, 0), (1860, 0), (1870, 0), (1880, 0), (1890, 0), (1900, 0), (1910, 0), (1920, 0), (1930, 0), (1940, 0), (1950, 0), (1960, 0), (1970, 0), (1980, 0), (1990, 0), (2000, 0), (2010, 0), (2020, 0), (2030, 0), (2040, 0), (2050, 0)]
Va0_0  a0_0  0 PWL (0n 0.0v 9.495n 0.0v 9.505n 0.0v 19.495n 0.0v 19.505n 0.0v 29.495n 0.0v 29.505n 0.0v 39.495n 0.0v 39.505n 0.0v 49.495n 0.0v 49.505n 0.0v 59.495n 0.0v 59.505n 0.0v 69.495n 0.0v 69.505n 0.0v 79.495n 0.0v 79.505n 0.0v 89.495n 0.0v 89.505n 0.0v 99.495n 0.0v 99.505n 0.0v 109.495n 0.0v 109.505n 0.0v 119.495n 0.0v 119.505n 0.0v 129.495n 0.0v 129.505n 0.0v 139.495n 0.0v 139.505n 0.0v 149.495n 0.0v 149.505n 0.0v 159.495n 0.0v 159.505n 0.0v 169.495n 0.0v 169.505n 0.0v 179.495n 0.0v 179.505n 0.0v 189.495n 0.0v 189.505n 0.0v 199.495n 0.0v 199.505n 0.0v 209.495n 0.0v 209.505n 0.0v 219.495n 0.0v 219.505n 0.0v 229.495n 0.0v 229.505n 0.0v 239.495n 0.0v 239.505n 0.0v 249.495n 0.0v 249.505n 0.0v 259.495n 0.0v 259.505n 0.0v 269.495n 0.0v 269.505n 0.0v 279.495n 0.0v 279.505n 0.0v 289.495n 0.0v 289.505n 0.0v 299.495n 0.0v 299.505n 0.0v 309.495n 0.0v 309.505n 0.0v 319.495n 0.0v 319.505n 0.0v 329.495n 0.0v 329.505n 0.0v 339.495n 0.0v 339.505n 0.0v 349.495n 0.0v 349.505n 0.0v 359.495n 0.0v 359.505n 0.0v 369.495n 0.0v 369.505n 0.0v 379.495n 0.0v 379.505n 0.0v 389.495n 0.0v 389.505n 0.0v 399.495n 0.0v 399.505n 0.0v 409.495n 0.0v 409.505n 0.0v 419.495n 0.0v 419.505n 0.0v 429.495n 0.0v 429.505n 0.0v 439.495n 0.0v 439.505n 0.0v 449.495n 0.0v 449.505n 0.0v 459.495n 0.0v 459.505n 0.0v 469.495n 0.0v 469.505n 0.0v 479.495n 0.0v 479.505n 0.0v 489.495n 0.0v 489.505n 0.0v 499.495n 0.0v 499.505n 0.0v 509.495n 0.0v 509.505n 0.0v 519.495n 0.0v 519.505n 0.0v 529.495n 0.0v 529.505n 0.0v 539.495n 0.0v 539.505n 0.0v 549.495n 0.0v 549.505n 0.0v 559.495n 0.0v 559.505n 0.0v 569.495n 0.0v 569.505n 0.0v 579.495n 0.0v 579.505n 0.0v 589.495n 0.0v 589.505n 0.0v 599.495n 0.0v 599.505n 0.0v 609.495n 0.0v 609.505n 0.0v 619.495n 0.0v 619.505n 0.0v 629.495n 0.0v 629.505n 0.0v 639.495n 0.0v 639.505n 0.0v 649.495n 0.0v 649.505n 0.0v 659.495n 0.0v 659.505n 0.0v 669.495n 0.0v 669.505n 0.0v 679.495n 0.0v 679.505n 0.0v 689.495n 0.0v 689.505n 0.0v 699.495n 0.0v 699.505n 0.0v 709.495n 0.0v 709.505n 0.0v 719.495n 0.0v 719.505n 0.0v 729.495n 0.0v 729.505n 0.0v 739.495n 0.0v 739.505n 0.0v 749.495n 0.0v 749.505n 0.0v 759.495n 0.0v 759.505n 0.0v 769.495n 0.0v 769.505n 0.0v 779.495n 0.0v 779.505n 0.0v 789.495n 0.0v 789.505n 0.0v 799.495n 0.0v 799.505n 0.0v 809.495n 0.0v 809.505n 0.0v 819.495n 0.0v 819.505n 0.0v 829.495n 0.0v 829.505n 0.0v 839.495n 0.0v 839.505n 0.0v 849.495n 0.0v 849.505n 0.0v 859.495n 0.0v 859.505n 0.0v 869.495n 0.0v 869.505n 0.0v 879.495n 0.0v 879.505n 0.0v 889.495n 0.0v 889.505n 0.0v 899.495n 0.0v 899.505n 0.0v 909.495n 0.0v 909.505n 0.0v 919.495n 0.0v 919.505n 0.0v 929.495n 0.0v 929.505n 0.0v 939.495n 0.0v 939.505n 0.0v 949.495n 0.0v 949.505n 0.0v 959.495n 0.0v 959.505n 0.0v 969.495n 0.0v 969.505n 0.0v 979.495n 0.0v 979.505n 0.0v 989.495n 0.0v 989.505n 0.0v 999.495n 0.0v 999.505n 0.0v 1009.495n 0.0v 1009.505n 0.0v 1019.495n 0.0v 1019.505n 0.0v 1029.495n 0.0v 1029.505n 0.0v 1039.495n 0.0v 1039.505n 0.0v 1049.495n 0.0v 1049.505n 0.0v 1059.495n 0.0v 1059.505n 0.0v 1069.495n 0.0v 1069.505n 0.0v 1079.495n 0.0v 1079.505n 0.0v 1089.495n 0.0v 1089.505n 0.0v 1099.495n 0.0v 1099.505n 0.0v 1109.495n 0.0v 1109.505n 0.0v 1119.495n 0.0v 1119.505n 0.0v 1129.495n 0.0v 1129.505n 0.0v 1139.495n 0.0v 1139.505n 0.0v 1149.495n 0.0v 1149.505n 0.0v 1159.495n 0.0v 1159.505n 0.0v 1169.495n 0.0v 1169.505n 0.0v 1179.495n 0.0v 1179.505n 0.0v 1189.495n 0.0v 1189.505n 0.0v 1199.495n 0.0v 1199.505n 0.0v 1209.495n 0.0v 1209.505n 0.0v 1219.495n 0.0v 1219.505n 0.0v 1229.495n 0.0v 1229.505n 0.0v 1239.495n 0.0v 1239.505n 0.0v 1249.495n 0.0v 1249.505n 0.0v 1259.495n 0.0v 1259.505n 0.0v 1269.495n 0.0v 1269.505n 0.0v 1279.495n 0.0v 1279.505n 0.0v 1289.495n 0.0v 1289.505n 0.0v 1299.495n 0.0v 1299.505n 0.0v 1309.495n 0.0v 1309.505n 0.0v 1319.495n 0.0v 1319.505n 0.0v 1329.495n 0.0v 1329.505n 0.0v 1339.495n 0.0v 1339.505n 0.0v 1349.495n 0.0v 1349.505n 0.0v 1359.495n 0.0v 1359.505n 0.0v 1369.495n 0.0v 1369.505n 0.0v 1379.495n 0.0v 1379.505n 0.0v 1389.495n 0.0v 1389.505n 0.0v 1399.495n 0.0v 1399.505n 0.0v 1409.495n 0.0v 1409.505n 0.0v 1419.495n 0.0v 1419.505n 0.0v 1429.495n 0.0v 1429.505n 0.0v 1439.495n 0.0v 1439.505n 0.0v 1449.495n 0.0v 1449.505n 0.0v 1459.495n 0.0v 1459.505n 0.0v 1469.495n 0.0v 1469.505n 0.0v 1479.495n 0.0v 1479.505n 0.0v 1489.495n 0.0v 1489.505n 0.0v 1499.495n 0.0v 1499.505n 0.0v 1509.495n 0.0v 1509.505n 0.0v 1519.495n 0.0v 1519.505n 0.0v 1529.495n 0.0v 1529.505n 0.0v 1539.495n 0.0v 1539.505n 0.0v 1549.495n 0.0v 1549.505n 0.0v 1559.495n 0.0v 1559.505n 0.0v 1569.495n 0.0v 1569.505n 0.0v 1579.495n 0.0v 1579.505n 0.0v 1589.495n 0.0v 1589.505n 0.0v 1599.495n 0.0v 1599.505n 0.0v 1609.495n 0.0v 1609.505n 0.0v 1619.495n 0.0v 1619.505n 0.0v 1629.495n 0.0v 1629.505n 0.0v 1639.495n 0.0v 1639.505n 0.0v 1649.495n 0.0v 1649.505n 0.0v 1659.495n 0.0v 1659.505n 0.0v 1669.495n 0.0v 1669.505n 0.0v 1679.495n 0.0v 1679.505n 0.0v 1689.495n 0.0v 1689.505n 0.0v 1699.495n 0.0v 1699.505n 0.0v 1709.495n 0.0v 1709.505n 0.0v 1719.495n 0.0v 1719.505n 0.0v 1729.495n 0.0v 1729.505n 0.0v 1739.495n 0.0v 1739.505n 0.0v 1749.495n 0.0v 1749.505n 0.0v 1759.495n 0.0v 1759.505n 0.0v 1769.495n 0.0v 1769.505n 0.0v 1779.495n 0.0v 1779.505n 0.0v 1789.495n 0.0v 1789.505n 0.0v 1799.495n 0.0v 1799.505n 0.0v 1809.495n 0.0v 1809.505n 0.0v 1819.495n 0.0v 1819.505n 0.0v 1829.495n 0.0v 1829.505n 0.0v 1839.495n 0.0v 1839.505n 0.0v 1849.495n 0.0v 1849.505n 0.0v 1859.495n 0.0v 1859.505n 0.0v 1869.495n 0.0v 1869.505n 0.0v 1879.495n 0.0v 1879.505n 0.0v 1889.495n 0.0v 1889.505n 0.0v 1899.495n 0.0v 1899.505n 0.0v 1909.495n 0.0v 1909.505n 0.0v 1919.495n 0.0v 1919.505n 0.0v 1929.495n 0.0v 1929.505n 0.0v 1939.495n 0.0v 1939.505n 0.0v 1949.495n 0.0v 1949.505n 0.0v 1959.495n 0.0v 1959.505n 0.0v 1969.495n 0.0v 1969.505n 0.0v 1979.495n 0.0v 1979.505n 0.0v 1989.495n 0.0v 1989.505n 0.0v 1999.495n 0.0v 1999.505n 0.0v 2009.495n 0.0v 2009.505n 0.0v 2019.495n 0.0v 2019.505n 0.0v 2029.495n 0.0v 2029.505n 0.0v 2039.495n 0.0v 2039.505n 0.0v 2049.495n 0.0v 2049.505n 0.0v )
* (time, data): [(0, 0), (10, 1), (20, 0), (30, 0), (40, 0), (50, 0), (60, 0), (70, 0), (80, 0), (90, 0), (100, 0), (110, 0), (120, 1), (130, 0), (140, 0), (150, 1), (160, 1), (170, 1), (180, 1), (190, 1), (200, 1), (210, 1), (220, 0), (230, 1), (240, 0), (250, 1), (260, 1), (270, 1), (280, 1), (290, 0), (300, 1), (310, 1), (320, 1), (330, 1), (340, 1), (350, 1), (360, 1), (370, 1), (380, 1), (390, 1), (400, 1), (410, 1), (420, 1), (430, 1), (440, 1), (450, 0), (460, 1), (470, 1), (480, 0), (490, 1), (500, 1), (510, 1), (520, 1), (530, 1), (540, 1), (550, 1), (560, 0), (570, 0), (580, 1), (590, 1), (600, 1), (610, 0), (620, 0), (630, 0), (640, 0), (650, 0), (660, 1), (670, 0), (680, 0), (690, 0), (700, 0), (710, 0), (720, 1), (730, 0), (740, 0), (750, 0), (760, 0), (770, 1), (780, 1), (790, 1), (800, 1), (810, 1), (820, 0), (830, 1), (840, 0), (850, 0), (860, 0), (870, 0), (880, 1), (890, 0), (900, 0), (910, 0), (920, 0), (930, 0), (940, 0), (950, 1), (960, 1), (970, 1), (980, 1), (990, 1), (1000, 1), (1010, 1), (1020, 0), (1030, 1), (1040, 1), (1050, 1), (1060, 1), (1070, 0), (1080, 0), (1090, 1), (1100, 1), (1110, 0), (1120, 0), (1130, 0), (1140, 0), (1150, 0), (1160, 0), (1170, 1), (1180, 0), (1190, 1), (1200, 1), (1210, 1), (1220, 1), (1230, 1), (1240, 1), (1250, 1), (1260, 1), (1270, 1), (1280, 1), (1290, 0), (1300, 1), (1310, 1), (1320, 0), (1330, 1), (1340, 1), (1350, 1), (1360, 0), (1370, 0), (1380, 0), (1390, 0), (1400, 1), (1410, 1), (1420, 0), (1430, 0), (1440, 0), (1450, 1), (1460, 1), (1470, 0), (1480, 0), (1490, 1), (1500, 0), (1510, 0), (1520, 0), (1530, 0), (1540, 0), (1550, 0), (1560, 0), (1570, 1), (1580, 1), (1590, 0), (1600, 1), (1610, 0), (1620, 0), (1630, 0), (1640, 1), (1650, 0), (1660, 1), (1670, 1), (1680, 1), (1690, 0), (1700, 0), (1710, 0), (1720, 0), (1730, 0), (1740, 0), (1750, 1), (1760, 0), (1770, 1), (1780, 0), (1790, 0), (1800, 0), (1810, 1), (1820, 1), (1830, 1), (1840, 1), (1850, 1), (1860, 1), (1870, 1), (1880, 1), (1890, 0), (1900, 0), (1910, 1), (1920, 1), (1930, 0), (1940, 1), (1950, 1), (1960, 1), (1970, 1), (1980, 0), (1990, 1), (2000, 1), (2010, 1), (2020, 1), (2030, 1), (2040, 0), (2050, 0)]
Va0_1  a0_1  0 PWL (0n 0.0v 9.495n 0.0v 9.505n 3.3v 19.495n 3.3v 19.505n 0.0v 29.495n 0.0v 29.505n 0.0v 39.495n 0.0v 39.505n 0.0v 49.495n 0.0v 49.505n 0.0v 59.495n 0.0v 59.505n 0.0v 69.495n 0.0v 69.505n 0.0v 79.495n 0.0v 79.505n 0.0v 89.495n 0.0v 89.505n 0.0v 99.495n 0.0v 99.505n 0.0v 109.495n 0.0v 109.505n 0.0v 119.495n 0.0v 119.505n 3.3v 129.495n 3.3v 129.505n 0.0v 139.495n 0.0v 139.505n 0.0v 149.495n 0.0v 149.505n 3.3v 159.495n 3.3v 159.505n 3.3v 169.495n 3.3v 169.505n 3.3v 179.495n 3.3v 179.505n 3.3v 189.495n 3.3v 189.505n 3.3v 199.495n 3.3v 199.505n 3.3v 209.495n 3.3v 209.505n 3.3v 219.495n 3.3v 219.505n 0.0v 229.495n 0.0v 229.505n 3.3v 239.495n 3.3v 239.505n 0.0v 249.495n 0.0v 249.505n 3.3v 259.495n 3.3v 259.505n 3.3v 269.495n 3.3v 269.505n 3.3v 279.495n 3.3v 279.505n 3.3v 289.495n 3.3v 289.505n 0.0v 299.495n 0.0v 299.505n 3.3v 309.495n 3.3v 309.505n 3.3v 319.495n 3.3v 319.505n 3.3v 329.495n 3.3v 329.505n 3.3v 339.495n 3.3v 339.505n 3.3v 349.495n 3.3v 349.505n 3.3v 359.495n 3.3v 359.505n 3.3v 369.495n 3.3v 369.505n 3.3v 379.495n 3.3v 379.505n 3.3v 389.495n 3.3v 389.505n 3.3v 399.495n 3.3v 399.505n 3.3v 409.495n 3.3v 409.505n 3.3v 419.495n 3.3v 419.505n 3.3v 429.495n 3.3v 429.505n 3.3v 439.495n 3.3v 439.505n 3.3v 449.495n 3.3v 449.505n 0.0v 459.495n 0.0v 459.505n 3.3v 469.495n 3.3v 469.505n 3.3v 479.495n 3.3v 479.505n 0.0v 489.495n 0.0v 489.505n 3.3v 499.495n 3.3v 499.505n 3.3v 509.495n 3.3v 509.505n 3.3v 519.495n 3.3v 519.505n 3.3v 529.495n 3.3v 529.505n 3.3v 539.495n 3.3v 539.505n 3.3v 549.495n 3.3v 549.505n 3.3v 559.495n 3.3v 559.505n 0.0v 569.495n 0.0v 569.505n 0.0v 579.495n 0.0v 579.505n 3.3v 589.495n 3.3v 589.505n 3.3v 599.495n 3.3v 599.505n 3.3v 609.495n 3.3v 609.505n 0.0v 619.495n 0.0v 619.505n 0.0v 629.495n 0.0v 629.505n 0.0v 639.495n 0.0v 639.505n 0.0v 649.495n 0.0v 649.505n 0.0v 659.495n 0.0v 659.505n 3.3v 669.495n 3.3v 669.505n 0.0v 679.495n 0.0v 679.505n 0.0v 689.495n 0.0v 689.505n 0.0v 699.495n 0.0v 699.505n 0.0v 709.495n 0.0v 709.505n 0.0v 719.495n 0.0v 719.505n 3.3v 729.495n 3.3v 729.505n 0.0v 739.495n 0.0v 739.505n 0.0v 749.495n 0.0v 749.505n 0.0v 759.495n 0.0v 759.505n 0.0v 769.495n 0.0v 769.505n 3.3v 779.495n 3.3v 779.505n 3.3v 789.495n 3.3v 789.505n 3.3v 799.495n 3.3v 799.505n 3.3v 809.495n 3.3v 809.505n 3.3v 819.495n 3.3v 819.505n 0.0v 829.495n 0.0v 829.505n 3.3v 839.495n 3.3v 839.505n 0.0v 849.495n 0.0v 849.505n 0.0v 859.495n 0.0v 859.505n 0.0v 869.495n 0.0v 869.505n 0.0v 879.495n 0.0v 879.505n 3.3v 889.495n 3.3v 889.505n 0.0v 899.495n 0.0v 899.505n 0.0v 909.495n 0.0v 909.505n 0.0v 919.495n 0.0v 919.505n 0.0v 929.495n 0.0v 929.505n 0.0v 939.495n 0.0v 939.505n 0.0v 949.495n 0.0v 949.505n 3.3v 959.495n 3.3v 959.505n 3.3v 969.495n 3.3v 969.505n 3.3v 979.495n 3.3v 979.505n 3.3v 989.495n 3.3v 989.505n 3.3v 999.495n 3.3v 999.505n 3.3v 1009.495n 3.3v 1009.505n 3.3v 1019.495n 3.3v 1019.505n 0.0v 1029.495n 0.0v 1029.505n 3.3v 1039.495n 3.3v 1039.505n 3.3v 1049.495n 3.3v 1049.505n 3.3v 1059.495n 3.3v 1059.505n 3.3v 1069.495n 3.3v 1069.505n 0.0v 1079.495n 0.0v 1079.505n 0.0v 1089.495n 0.0v 1089.505n 3.3v 1099.495n 3.3v 1099.505n 3.3v 1109.495n 3.3v 1109.505n 0.0v 1119.495n 0.0v 1119.505n 0.0v 1129.495n 0.0v 1129.505n 0.0v 1139.495n 0.0v 1139.505n 0.0v 1149.495n 0.0v 1149.505n 0.0v 1159.495n 0.0v 1159.505n 0.0v 1169.495n 0.0v 1169.505n 3.3v 1179.495n 3.3v 1179.505n 0.0v 1189.495n 0.0v 1189.505n 3.3v 1199.495n 3.3v 1199.505n 3.3v 1209.495n 3.3v 1209.505n 3.3v 1219.495n 3.3v 1219.505n 3.3v 1229.495n 3.3v 1229.505n 3.3v 1239.495n 3.3v 1239.505n 3.3v 1249.495n 3.3v 1249.505n 3.3v 1259.495n 3.3v 1259.505n 3.3v 1269.495n 3.3v 1269.505n 3.3v 1279.495n 3.3v 1279.505n 3.3v 1289.495n 3.3v 1289.505n 0.0v 1299.495n 0.0v 1299.505n 3.3v 1309.495n 3.3v 1309.505n 3.3v 1319.495n 3.3v 1319.505n 0.0v 1329.495n 0.0v 1329.505n 3.3v 1339.495n 3.3v 1339.505n 3.3v 1349.495n 3.3v 1349.505n 3.3v 1359.495n 3.3v 1359.505n 0.0v 1369.495n 0.0v 1369.505n 0.0v 1379.495n 0.0v 1379.505n 0.0v 1389.495n 0.0v 1389.505n 0.0v 1399.495n 0.0v 1399.505n 3.3v 1409.495n 3.3v 1409.505n 3.3v 1419.495n 3.3v 1419.505n 0.0v 1429.495n 0.0v 1429.505n 0.0v 1439.495n 0.0v 1439.505n 0.0v 1449.495n 0.0v 1449.505n 3.3v 1459.495n 3.3v 1459.505n 3.3v 1469.495n 3.3v 1469.505n 0.0v 1479.495n 0.0v 1479.505n 0.0v 1489.495n 0.0v 1489.505n 3.3v 1499.495n 3.3v 1499.505n 0.0v 1509.495n 0.0v 1509.505n 0.0v 1519.495n 0.0v 1519.505n 0.0v 1529.495n 0.0v 1529.505n 0.0v 1539.495n 0.0v 1539.505n 0.0v 1549.495n 0.0v 1549.505n 0.0v 1559.495n 0.0v 1559.505n 0.0v 1569.495n 0.0v 1569.505n 3.3v 1579.495n 3.3v 1579.505n 3.3v 1589.495n 3.3v 1589.505n 0.0v 1599.495n 0.0v 1599.505n 3.3v 1609.495n 3.3v 1609.505n 0.0v 1619.495n 0.0v 1619.505n 0.0v 1629.495n 0.0v 1629.505n 0.0v 1639.495n 0.0v 1639.505n 3.3v 1649.495n 3.3v 1649.505n 0.0v 1659.495n 0.0v 1659.505n 3.3v 1669.495n 3.3v 1669.505n 3.3v 1679.495n 3.3v 1679.505n 3.3v 1689.495n 3.3v 1689.505n 0.0v 1699.495n 0.0v 1699.505n 0.0v 1709.495n 0.0v 1709.505n 0.0v 1719.495n 0.0v 1719.505n 0.0v 1729.495n 0.0v 1729.505n 0.0v 1739.495n 0.0v 1739.505n 0.0v 1749.495n 0.0v 1749.505n 3.3v 1759.495n 3.3v 1759.505n 0.0v 1769.495n 0.0v 1769.505n 3.3v 1779.495n 3.3v 1779.505n 0.0v 1789.495n 0.0v 1789.505n 0.0v 1799.495n 0.0v 1799.505n 0.0v 1809.495n 0.0v 1809.505n 3.3v 1819.495n 3.3v 1819.505n 3.3v 1829.495n 3.3v 1829.505n 3.3v 1839.495n 3.3v 1839.505n 3.3v 1849.495n 3.3v 1849.505n 3.3v 1859.495n 3.3v 1859.505n 3.3v 1869.495n 3.3v 1869.505n 3.3v 1879.495n 3.3v 1879.505n 3.3v 1889.495n 3.3v 1889.505n 0.0v 1899.495n 0.0v 1899.505n 0.0v 1909.495n 0.0v 1909.505n 3.3v 1919.495n 3.3v 1919.505n 3.3v 1929.495n 3.3v 1929.505n 0.0v 1939.495n 0.0v 1939.505n 3.3v 1949.495n 3.3v 1949.505n 3.3v 1959.495n 3.3v 1959.505n 3.3v 1969.495n 3.3v 1969.505n 3.3v 1979.495n 3.3v 1979.505n 0.0v 1989.495n 0.0v 1989.505n 3.3v 1999.495n 3.3v 1999.505n 3.3v 2009.495n 3.3v 2009.505n 3.3v 2019.495n 3.3v 2019.505n 3.3v 2029.495n 3.3v 2029.505n 3.3v 2039.495n 3.3v 2039.505n 0.0v 2049.495n 0.0v 2049.505n 0.0v )
* (time, data): [(0, 0), (10, 1), (20, 0), (30, 0), (40, 0), (50, 0), (60, 0), (70, 0), (80, 0), (90, 0), (100, 0), (110, 0), (120, 1), (130, 0), (140, 0), (150, 1), (160, 1), (170, 1), (180, 1), (190, 1), (200, 1), (210, 1), (220, 0), (230, 1), (240, 0), (250, 1), (260, 1), (270, 1), (280, 1), (290, 0), (300, 1), (310, 1), (320, 1), (330, 1), (340, 1), (350, 1), (360, 1), (370, 1), (380, 1), (390, 1), (400, 1), (410, 1), (420, 1), (430, 1), (440, 1), (450, 0), (460, 1), (470, 1), (480, 0), (490, 1), (500, 1), (510, 1), (520, 1), (530, 1), (540, 1), (550, 1), (560, 0), (570, 0), (580, 1), (590, 1), (600, 1), (610, 0), (620, 0), (630, 0), (640, 0), (650, 0), (660, 1), (670, 0), (680, 0), (690, 0), (700, 0), (710, 0), (720, 1), (730, 0), (740, 0), (750, 0), (760, 0), (770, 1), (780, 1), (790, 1), (800, 1), (810, 1), (820, 0), (830, 1), (840, 0), (850, 0), (860, 0), (870, 0), (880, 1), (890, 0), (900, 0), (910, 0), (920, 0), (930, 0), (940, 0), (950, 1), (960, 1), (970, 1), (980, 1), (990, 1), (1000, 1), (1010, 1), (1020, 0), (1030, 1), (1040, 1), (1050, 1), (1060, 1), (1070, 0), (1080, 0), (1090, 1), (1100, 1), (1110, 0), (1120, 0), (1130, 0), (1140, 0), (1150, 0), (1160, 0), (1170, 1), (1180, 0), (1190, 1), (1200, 1), (1210, 1), (1220, 1), (1230, 1), (1240, 1), (1250, 1), (1260, 1), (1270, 1), (1280, 1), (1290, 0), (1300, 1), (1310, 1), (1320, 0), (1330, 1), (1340, 1), (1350, 1), (1360, 0), (1370, 0), (1380, 0), (1390, 0), (1400, 1), (1410, 1), (1420, 0), (1430, 0), (1440, 0), (1450, 1), (1460, 1), (1470, 0), (1480, 0), (1490, 1), (1500, 0), (1510, 0), (1520, 0), (1530, 0), (1540, 0), (1550, 0), (1560, 0), (1570, 1), (1580, 1), (1590, 0), (1600, 1), (1610, 0), (1620, 0), (1630, 0), (1640, 1), (1650, 0), (1660, 1), (1670, 1), (1680, 1), (1690, 0), (1700, 0), (1710, 0), (1720, 0), (1730, 0), (1740, 0), (1750, 1), (1760, 0), (1770, 1), (1780, 0), (1790, 0), (1800, 0), (1810, 1), (1820, 1), (1830, 1), (1840, 1), (1850, 1), (1860, 1), (1870, 1), (1880, 1), (1890, 0), (1900, 0), (1910, 1), (1920, 1), (1930, 0), (1940, 1), (1950, 1), (1960, 1), (1970, 1), (1980, 0), (1990, 1), (2000, 1), (2010, 1), (2020, 1), (2030, 1), (2040, 0), (2050, 0)]
Va0_2  a0_2  0 PWL (0n 0.0v 9.495n 0.0v 9.505n 3.3v 19.495n 3.3v 19.505n 0.0v 29.495n 0.0v 29.505n 0.0v 39.495n 0.0v 39.505n 0.0v 49.495n 0.0v 49.505n 0.0v 59.495n 0.0v 59.505n 0.0v 69.495n 0.0v 69.505n 0.0v 79.495n 0.0v 79.505n 0.0v 89.495n 0.0v 89.505n 0.0v 99.495n 0.0v 99.505n 0.0v 109.495n 0.0v 109.505n 0.0v 119.495n 0.0v 119.505n 3.3v 129.495n 3.3v 129.505n 0.0v 139.495n 0.0v 139.505n 0.0v 149.495n 0.0v 149.505n 3.3v 159.495n 3.3v 159.505n 3.3v 169.495n 3.3v 169.505n 3.3v 179.495n 3.3v 179.505n 3.3v 189.495n 3.3v 189.505n 3.3v 199.495n 3.3v 199.505n 3.3v 209.495n 3.3v 209.505n 3.3v 219.495n 3.3v 219.505n 0.0v 229.495n 0.0v 229.505n 3.3v 239.495n 3.3v 239.505n 0.0v 249.495n 0.0v 249.505n 3.3v 259.495n 3.3v 259.505n 3.3v 269.495n 3.3v 269.505n 3.3v 279.495n 3.3v 279.505n 3.3v 289.495n 3.3v 289.505n 0.0v 299.495n 0.0v 299.505n 3.3v 309.495n 3.3v 309.505n 3.3v 319.495n 3.3v 319.505n 3.3v 329.495n 3.3v 329.505n 3.3v 339.495n 3.3v 339.505n 3.3v 349.495n 3.3v 349.505n 3.3v 359.495n 3.3v 359.505n 3.3v 369.495n 3.3v 369.505n 3.3v 379.495n 3.3v 379.505n 3.3v 389.495n 3.3v 389.505n 3.3v 399.495n 3.3v 399.505n 3.3v 409.495n 3.3v 409.505n 3.3v 419.495n 3.3v 419.505n 3.3v 429.495n 3.3v 429.505n 3.3v 439.495n 3.3v 439.505n 3.3v 449.495n 3.3v 449.505n 0.0v 459.495n 0.0v 459.505n 3.3v 469.495n 3.3v 469.505n 3.3v 479.495n 3.3v 479.505n 0.0v 489.495n 0.0v 489.505n 3.3v 499.495n 3.3v 499.505n 3.3v 509.495n 3.3v 509.505n 3.3v 519.495n 3.3v 519.505n 3.3v 529.495n 3.3v 529.505n 3.3v 539.495n 3.3v 539.505n 3.3v 549.495n 3.3v 549.505n 3.3v 559.495n 3.3v 559.505n 0.0v 569.495n 0.0v 569.505n 0.0v 579.495n 0.0v 579.505n 3.3v 589.495n 3.3v 589.505n 3.3v 599.495n 3.3v 599.505n 3.3v 609.495n 3.3v 609.505n 0.0v 619.495n 0.0v 619.505n 0.0v 629.495n 0.0v 629.505n 0.0v 639.495n 0.0v 639.505n 0.0v 649.495n 0.0v 649.505n 0.0v 659.495n 0.0v 659.505n 3.3v 669.495n 3.3v 669.505n 0.0v 679.495n 0.0v 679.505n 0.0v 689.495n 0.0v 689.505n 0.0v 699.495n 0.0v 699.505n 0.0v 709.495n 0.0v 709.505n 0.0v 719.495n 0.0v 719.505n 3.3v 729.495n 3.3v 729.505n 0.0v 739.495n 0.0v 739.505n 0.0v 749.495n 0.0v 749.505n 0.0v 759.495n 0.0v 759.505n 0.0v 769.495n 0.0v 769.505n 3.3v 779.495n 3.3v 779.505n 3.3v 789.495n 3.3v 789.505n 3.3v 799.495n 3.3v 799.505n 3.3v 809.495n 3.3v 809.505n 3.3v 819.495n 3.3v 819.505n 0.0v 829.495n 0.0v 829.505n 3.3v 839.495n 3.3v 839.505n 0.0v 849.495n 0.0v 849.505n 0.0v 859.495n 0.0v 859.505n 0.0v 869.495n 0.0v 869.505n 0.0v 879.495n 0.0v 879.505n 3.3v 889.495n 3.3v 889.505n 0.0v 899.495n 0.0v 899.505n 0.0v 909.495n 0.0v 909.505n 0.0v 919.495n 0.0v 919.505n 0.0v 929.495n 0.0v 929.505n 0.0v 939.495n 0.0v 939.505n 0.0v 949.495n 0.0v 949.505n 3.3v 959.495n 3.3v 959.505n 3.3v 969.495n 3.3v 969.505n 3.3v 979.495n 3.3v 979.505n 3.3v 989.495n 3.3v 989.505n 3.3v 999.495n 3.3v 999.505n 3.3v 1009.495n 3.3v 1009.505n 3.3v 1019.495n 3.3v 1019.505n 0.0v 1029.495n 0.0v 1029.505n 3.3v 1039.495n 3.3v 1039.505n 3.3v 1049.495n 3.3v 1049.505n 3.3v 1059.495n 3.3v 1059.505n 3.3v 1069.495n 3.3v 1069.505n 0.0v 1079.495n 0.0v 1079.505n 0.0v 1089.495n 0.0v 1089.505n 3.3v 1099.495n 3.3v 1099.505n 3.3v 1109.495n 3.3v 1109.505n 0.0v 1119.495n 0.0v 1119.505n 0.0v 1129.495n 0.0v 1129.505n 0.0v 1139.495n 0.0v 1139.505n 0.0v 1149.495n 0.0v 1149.505n 0.0v 1159.495n 0.0v 1159.505n 0.0v 1169.495n 0.0v 1169.505n 3.3v 1179.495n 3.3v 1179.505n 0.0v 1189.495n 0.0v 1189.505n 3.3v 1199.495n 3.3v 1199.505n 3.3v 1209.495n 3.3v 1209.505n 3.3v 1219.495n 3.3v 1219.505n 3.3v 1229.495n 3.3v 1229.505n 3.3v 1239.495n 3.3v 1239.505n 3.3v 1249.495n 3.3v 1249.505n 3.3v 1259.495n 3.3v 1259.505n 3.3v 1269.495n 3.3v 1269.505n 3.3v 1279.495n 3.3v 1279.505n 3.3v 1289.495n 3.3v 1289.505n 0.0v 1299.495n 0.0v 1299.505n 3.3v 1309.495n 3.3v 1309.505n 3.3v 1319.495n 3.3v 1319.505n 0.0v 1329.495n 0.0v 1329.505n 3.3v 1339.495n 3.3v 1339.505n 3.3v 1349.495n 3.3v 1349.505n 3.3v 1359.495n 3.3v 1359.505n 0.0v 1369.495n 0.0v 1369.505n 0.0v 1379.495n 0.0v 1379.505n 0.0v 1389.495n 0.0v 1389.505n 0.0v 1399.495n 0.0v 1399.505n 3.3v 1409.495n 3.3v 1409.505n 3.3v 1419.495n 3.3v 1419.505n 0.0v 1429.495n 0.0v 1429.505n 0.0v 1439.495n 0.0v 1439.505n 0.0v 1449.495n 0.0v 1449.505n 3.3v 1459.495n 3.3v 1459.505n 3.3v 1469.495n 3.3v 1469.505n 0.0v 1479.495n 0.0v 1479.505n 0.0v 1489.495n 0.0v 1489.505n 3.3v 1499.495n 3.3v 1499.505n 0.0v 1509.495n 0.0v 1509.505n 0.0v 1519.495n 0.0v 1519.505n 0.0v 1529.495n 0.0v 1529.505n 0.0v 1539.495n 0.0v 1539.505n 0.0v 1549.495n 0.0v 1549.505n 0.0v 1559.495n 0.0v 1559.505n 0.0v 1569.495n 0.0v 1569.505n 3.3v 1579.495n 3.3v 1579.505n 3.3v 1589.495n 3.3v 1589.505n 0.0v 1599.495n 0.0v 1599.505n 3.3v 1609.495n 3.3v 1609.505n 0.0v 1619.495n 0.0v 1619.505n 0.0v 1629.495n 0.0v 1629.505n 0.0v 1639.495n 0.0v 1639.505n 3.3v 1649.495n 3.3v 1649.505n 0.0v 1659.495n 0.0v 1659.505n 3.3v 1669.495n 3.3v 1669.505n 3.3v 1679.495n 3.3v 1679.505n 3.3v 1689.495n 3.3v 1689.505n 0.0v 1699.495n 0.0v 1699.505n 0.0v 1709.495n 0.0v 1709.505n 0.0v 1719.495n 0.0v 1719.505n 0.0v 1729.495n 0.0v 1729.505n 0.0v 1739.495n 0.0v 1739.505n 0.0v 1749.495n 0.0v 1749.505n 3.3v 1759.495n 3.3v 1759.505n 0.0v 1769.495n 0.0v 1769.505n 3.3v 1779.495n 3.3v 1779.505n 0.0v 1789.495n 0.0v 1789.505n 0.0v 1799.495n 0.0v 1799.505n 0.0v 1809.495n 0.0v 1809.505n 3.3v 1819.495n 3.3v 1819.505n 3.3v 1829.495n 3.3v 1829.505n 3.3v 1839.495n 3.3v 1839.505n 3.3v 1849.495n 3.3v 1849.505n 3.3v 1859.495n 3.3v 1859.505n 3.3v 1869.495n 3.3v 1869.505n 3.3v 1879.495n 3.3v 1879.505n 3.3v 1889.495n 3.3v 1889.505n 0.0v 1899.495n 0.0v 1899.505n 0.0v 1909.495n 0.0v 1909.505n 3.3v 1919.495n 3.3v 1919.505n 3.3v 1929.495n 3.3v 1929.505n 0.0v 1939.495n 0.0v 1939.505n 3.3v 1949.495n 3.3v 1949.505n 3.3v 1959.495n 3.3v 1959.505n 3.3v 1969.495n 3.3v 1969.505n 3.3v 1979.495n 3.3v 1979.505n 0.0v 1989.495n 0.0v 1989.505n 3.3v 1999.495n 3.3v 1999.505n 3.3v 2009.495n 3.3v 2009.505n 3.3v 2019.495n 3.3v 2019.505n 3.3v 2029.495n 3.3v 2029.505n 3.3v 2039.495n 3.3v 2039.505n 0.0v 2049.495n 0.0v 2049.505n 0.0v )
* (time, data): [(0, 0), (10, 1), (20, 0), (30, 0), (40, 0), (50, 0), (60, 0), (70, 0), (80, 0), (90, 0), (100, 0), (110, 0), (120, 1), (130, 0), (140, 0), (150, 1), (160, 1), (170, 1), (180, 1), (190, 1), (200, 1), (210, 1), (220, 0), (230, 1), (240, 0), (250, 1), (260, 1), (270, 1), (280, 1), (290, 0), (300, 1), (310, 1), (320, 1), (330, 1), (340, 1), (350, 1), (360, 1), (370, 1), (380, 1), (390, 1), (400, 1), (410, 1), (420, 1), (430, 1), (440, 1), (450, 0), (460, 1), (470, 1), (480, 0), (490, 1), (500, 1), (510, 1), (520, 1), (530, 1), (540, 1), (550, 1), (560, 0), (570, 0), (580, 1), (590, 1), (600, 1), (610, 0), (620, 0), (630, 0), (640, 0), (650, 0), (660, 1), (670, 0), (680, 0), (690, 0), (700, 0), (710, 0), (720, 1), (730, 0), (740, 0), (750, 0), (760, 0), (770, 1), (780, 1), (790, 1), (800, 1), (810, 1), (820, 0), (830, 1), (840, 0), (850, 0), (860, 0), (870, 0), (880, 1), (890, 0), (900, 0), (910, 0), (920, 0), (930, 0), (940, 0), (950, 1), (960, 1), (970, 1), (980, 1), (990, 1), (1000, 1), (1010, 1), (1020, 0), (1030, 1), (1040, 1), (1050, 1), (1060, 1), (1070, 0), (1080, 0), (1090, 1), (1100, 1), (1110, 0), (1120, 0), (1130, 0), (1140, 0), (1150, 0), (1160, 0), (1170, 1), (1180, 0), (1190, 1), (1200, 1), (1210, 1), (1220, 1), (1230, 1), (1240, 1), (1250, 1), (1260, 1), (1270, 1), (1280, 1), (1290, 0), (1300, 1), (1310, 1), (1320, 0), (1330, 1), (1340, 1), (1350, 1), (1360, 0), (1370, 0), (1380, 0), (1390, 0), (1400, 1), (1410, 1), (1420, 0), (1430, 0), (1440, 0), (1450, 1), (1460, 1), (1470, 0), (1480, 0), (1490, 1), (1500, 0), (1510, 0), (1520, 0), (1530, 0), (1540, 0), (1550, 0), (1560, 0), (1570, 1), (1580, 1), (1590, 0), (1600, 1), (1610, 0), (1620, 0), (1630, 0), (1640, 1), (1650, 0), (1660, 1), (1670, 1), (1680, 1), (1690, 0), (1700, 0), (1710, 0), (1720, 0), (1730, 0), (1740, 0), (1750, 1), (1760, 0), (1770, 1), (1780, 0), (1790, 0), (1800, 0), (1810, 1), (1820, 1), (1830, 1), (1840, 1), (1850, 1), (1860, 1), (1870, 1), (1880, 1), (1890, 0), (1900, 0), (1910, 1), (1920, 1), (1930, 0), (1940, 1), (1950, 1), (1960, 1), (1970, 1), (1980, 0), (1990, 1), (2000, 1), (2010, 1), (2020, 1), (2030, 1), (2040, 0), (2050, 0)]
Va0_3  a0_3  0 PWL (0n 0.0v 9.495n 0.0v 9.505n 3.3v 19.495n 3.3v 19.505n 0.0v 29.495n 0.0v 29.505n 0.0v 39.495n 0.0v 39.505n 0.0v 49.495n 0.0v 49.505n 0.0v 59.495n 0.0v 59.505n 0.0v 69.495n 0.0v 69.505n 0.0v 79.495n 0.0v 79.505n 0.0v 89.495n 0.0v 89.505n 0.0v 99.495n 0.0v 99.505n 0.0v 109.495n 0.0v 109.505n 0.0v 119.495n 0.0v 119.505n 3.3v 129.495n 3.3v 129.505n 0.0v 139.495n 0.0v 139.505n 0.0v 149.495n 0.0v 149.505n 3.3v 159.495n 3.3v 159.505n 3.3v 169.495n 3.3v 169.505n 3.3v 179.495n 3.3v 179.505n 3.3v 189.495n 3.3v 189.505n 3.3v 199.495n 3.3v 199.505n 3.3v 209.495n 3.3v 209.505n 3.3v 219.495n 3.3v 219.505n 0.0v 229.495n 0.0v 229.505n 3.3v 239.495n 3.3v 239.505n 0.0v 249.495n 0.0v 249.505n 3.3v 259.495n 3.3v 259.505n 3.3v 269.495n 3.3v 269.505n 3.3v 279.495n 3.3v 279.505n 3.3v 289.495n 3.3v 289.505n 0.0v 299.495n 0.0v 299.505n 3.3v 309.495n 3.3v 309.505n 3.3v 319.495n 3.3v 319.505n 3.3v 329.495n 3.3v 329.505n 3.3v 339.495n 3.3v 339.505n 3.3v 349.495n 3.3v 349.505n 3.3v 359.495n 3.3v 359.505n 3.3v 369.495n 3.3v 369.505n 3.3v 379.495n 3.3v 379.505n 3.3v 389.495n 3.3v 389.505n 3.3v 399.495n 3.3v 399.505n 3.3v 409.495n 3.3v 409.505n 3.3v 419.495n 3.3v 419.505n 3.3v 429.495n 3.3v 429.505n 3.3v 439.495n 3.3v 439.505n 3.3v 449.495n 3.3v 449.505n 0.0v 459.495n 0.0v 459.505n 3.3v 469.495n 3.3v 469.505n 3.3v 479.495n 3.3v 479.505n 0.0v 489.495n 0.0v 489.505n 3.3v 499.495n 3.3v 499.505n 3.3v 509.495n 3.3v 509.505n 3.3v 519.495n 3.3v 519.505n 3.3v 529.495n 3.3v 529.505n 3.3v 539.495n 3.3v 539.505n 3.3v 549.495n 3.3v 549.505n 3.3v 559.495n 3.3v 559.505n 0.0v 569.495n 0.0v 569.505n 0.0v 579.495n 0.0v 579.505n 3.3v 589.495n 3.3v 589.505n 3.3v 599.495n 3.3v 599.505n 3.3v 609.495n 3.3v 609.505n 0.0v 619.495n 0.0v 619.505n 0.0v 629.495n 0.0v 629.505n 0.0v 639.495n 0.0v 639.505n 0.0v 649.495n 0.0v 649.505n 0.0v 659.495n 0.0v 659.505n 3.3v 669.495n 3.3v 669.505n 0.0v 679.495n 0.0v 679.505n 0.0v 689.495n 0.0v 689.505n 0.0v 699.495n 0.0v 699.505n 0.0v 709.495n 0.0v 709.505n 0.0v 719.495n 0.0v 719.505n 3.3v 729.495n 3.3v 729.505n 0.0v 739.495n 0.0v 739.505n 0.0v 749.495n 0.0v 749.505n 0.0v 759.495n 0.0v 759.505n 0.0v 769.495n 0.0v 769.505n 3.3v 779.495n 3.3v 779.505n 3.3v 789.495n 3.3v 789.505n 3.3v 799.495n 3.3v 799.505n 3.3v 809.495n 3.3v 809.505n 3.3v 819.495n 3.3v 819.505n 0.0v 829.495n 0.0v 829.505n 3.3v 839.495n 3.3v 839.505n 0.0v 849.495n 0.0v 849.505n 0.0v 859.495n 0.0v 859.505n 0.0v 869.495n 0.0v 869.505n 0.0v 879.495n 0.0v 879.505n 3.3v 889.495n 3.3v 889.505n 0.0v 899.495n 0.0v 899.505n 0.0v 909.495n 0.0v 909.505n 0.0v 919.495n 0.0v 919.505n 0.0v 929.495n 0.0v 929.505n 0.0v 939.495n 0.0v 939.505n 0.0v 949.495n 0.0v 949.505n 3.3v 959.495n 3.3v 959.505n 3.3v 969.495n 3.3v 969.505n 3.3v 979.495n 3.3v 979.505n 3.3v 989.495n 3.3v 989.505n 3.3v 999.495n 3.3v 999.505n 3.3v 1009.495n 3.3v 1009.505n 3.3v 1019.495n 3.3v 1019.505n 0.0v 1029.495n 0.0v 1029.505n 3.3v 1039.495n 3.3v 1039.505n 3.3v 1049.495n 3.3v 1049.505n 3.3v 1059.495n 3.3v 1059.505n 3.3v 1069.495n 3.3v 1069.505n 0.0v 1079.495n 0.0v 1079.505n 0.0v 1089.495n 0.0v 1089.505n 3.3v 1099.495n 3.3v 1099.505n 3.3v 1109.495n 3.3v 1109.505n 0.0v 1119.495n 0.0v 1119.505n 0.0v 1129.495n 0.0v 1129.505n 0.0v 1139.495n 0.0v 1139.505n 0.0v 1149.495n 0.0v 1149.505n 0.0v 1159.495n 0.0v 1159.505n 0.0v 1169.495n 0.0v 1169.505n 3.3v 1179.495n 3.3v 1179.505n 0.0v 1189.495n 0.0v 1189.505n 3.3v 1199.495n 3.3v 1199.505n 3.3v 1209.495n 3.3v 1209.505n 3.3v 1219.495n 3.3v 1219.505n 3.3v 1229.495n 3.3v 1229.505n 3.3v 1239.495n 3.3v 1239.505n 3.3v 1249.495n 3.3v 1249.505n 3.3v 1259.495n 3.3v 1259.505n 3.3v 1269.495n 3.3v 1269.505n 3.3v 1279.495n 3.3v 1279.505n 3.3v 1289.495n 3.3v 1289.505n 0.0v 1299.495n 0.0v 1299.505n 3.3v 1309.495n 3.3v 1309.505n 3.3v 1319.495n 3.3v 1319.505n 0.0v 1329.495n 0.0v 1329.505n 3.3v 1339.495n 3.3v 1339.505n 3.3v 1349.495n 3.3v 1349.505n 3.3v 1359.495n 3.3v 1359.505n 0.0v 1369.495n 0.0v 1369.505n 0.0v 1379.495n 0.0v 1379.505n 0.0v 1389.495n 0.0v 1389.505n 0.0v 1399.495n 0.0v 1399.505n 3.3v 1409.495n 3.3v 1409.505n 3.3v 1419.495n 3.3v 1419.505n 0.0v 1429.495n 0.0v 1429.505n 0.0v 1439.495n 0.0v 1439.505n 0.0v 1449.495n 0.0v 1449.505n 3.3v 1459.495n 3.3v 1459.505n 3.3v 1469.495n 3.3v 1469.505n 0.0v 1479.495n 0.0v 1479.505n 0.0v 1489.495n 0.0v 1489.505n 3.3v 1499.495n 3.3v 1499.505n 0.0v 1509.495n 0.0v 1509.505n 0.0v 1519.495n 0.0v 1519.505n 0.0v 1529.495n 0.0v 1529.505n 0.0v 1539.495n 0.0v 1539.505n 0.0v 1549.495n 0.0v 1549.505n 0.0v 1559.495n 0.0v 1559.505n 0.0v 1569.495n 0.0v 1569.505n 3.3v 1579.495n 3.3v 1579.505n 3.3v 1589.495n 3.3v 1589.505n 0.0v 1599.495n 0.0v 1599.505n 3.3v 1609.495n 3.3v 1609.505n 0.0v 1619.495n 0.0v 1619.505n 0.0v 1629.495n 0.0v 1629.505n 0.0v 1639.495n 0.0v 1639.505n 3.3v 1649.495n 3.3v 1649.505n 0.0v 1659.495n 0.0v 1659.505n 3.3v 1669.495n 3.3v 1669.505n 3.3v 1679.495n 3.3v 1679.505n 3.3v 1689.495n 3.3v 1689.505n 0.0v 1699.495n 0.0v 1699.505n 0.0v 1709.495n 0.0v 1709.505n 0.0v 1719.495n 0.0v 1719.505n 0.0v 1729.495n 0.0v 1729.505n 0.0v 1739.495n 0.0v 1739.505n 0.0v 1749.495n 0.0v 1749.505n 3.3v 1759.495n 3.3v 1759.505n 0.0v 1769.495n 0.0v 1769.505n 3.3v 1779.495n 3.3v 1779.505n 0.0v 1789.495n 0.0v 1789.505n 0.0v 1799.495n 0.0v 1799.505n 0.0v 1809.495n 0.0v 1809.505n 3.3v 1819.495n 3.3v 1819.505n 3.3v 1829.495n 3.3v 1829.505n 3.3v 1839.495n 3.3v 1839.505n 3.3v 1849.495n 3.3v 1849.505n 3.3v 1859.495n 3.3v 1859.505n 3.3v 1869.495n 3.3v 1869.505n 3.3v 1879.495n 3.3v 1879.505n 3.3v 1889.495n 3.3v 1889.505n 0.0v 1899.495n 0.0v 1899.505n 0.0v 1909.495n 0.0v 1909.505n 3.3v 1919.495n 3.3v 1919.505n 3.3v 1929.495n 3.3v 1929.505n 0.0v 1939.495n 0.0v 1939.505n 3.3v 1949.495n 3.3v 1949.505n 3.3v 1959.495n 3.3v 1959.505n 3.3v 1969.495n 3.3v 1969.505n 3.3v 1979.495n 3.3v 1979.505n 0.0v 1989.495n 0.0v 1989.505n 3.3v 1999.495n 3.3v 1999.505n 3.3v 2009.495n 3.3v 2009.505n 3.3v 2019.495n 3.3v 2019.505n 3.3v 2029.495n 3.3v 2029.505n 3.3v 2039.495n 3.3v 2039.505n 0.0v 2049.495n 0.0v 2049.505n 0.0v )
* (time, data): [(0, 0), (10, 0), (20, 0), (30, 0), (40, 0), (50, 0), (60, 0), (70, 0), (80, 0), (90, 0), (100, 0), (110, 0), (120, 0), (130, 0), (140, 0), (150, 0), (160, 0), (170, 0), (180, 0), (190, 0), (200, 0), (210, 0), (220, 0), (230, 0), (240, 0), (250, 0), (260, 0), (270, 0), (280, 0), (290, 0), (300, 0), (310, 0), (320, 0), (330, 0), (340, 0), (350, 0), (360, 0), (370, 0), (380, 0), (390, 0), (400, 0), (410, 0), (420, 0), (430, 0), (440, 0), (450, 0), (460, 0), (470, 0), (480, 0), (490, 0), (500, 0), (510, 0), (520, 0), (530, 0), (540, 0), (550, 0), (560, 0), (570, 0), (580, 0), (590, 0), (600, 0), (610, 0), (620, 0), (630, 0), (640, 0), (650, 0), (660, 0), (670, 0), (680, 0), (690, 0), (700, 0), (710, 0), (720, 0), (730, 0), (740, 0), (750, 0), (760, 0), (770, 0), (780, 0), (790, 0), (800, 0), (810, 0), (820, 0), (830, 0), (840, 0), (850, 0), (860, 0), (870, 0), (880, 0), (890, 0), (900, 0), (910, 0), (920, 0), (930, 0), (940, 0), (950, 0), (960, 0), (970, 0), (980, 0), (990, 0), (1000, 0), (1010, 0), (1020, 0), (1030, 0), (1040, 0), (1050, 0), (1060, 0), (1070, 0), (1080, 0), (1090, 0), (1100, 0), (1110, 0), (1120, 0), (1130, 0), (1140, 0), (1150, 0), (1160, 0), (1170, 0), (1180, 0), (1190, 0), (1200, 0), (1210, 0), (1220, 0), (1230, 0), (1240, 0), (1250, 0), (1260, 0), (1270, 0), (1280, 0), (1290, 0), (1300, 0), (1310, 0), (1320, 0), (1330, 0), (1340, 0), (1350, 0), (1360, 0), (1370, 0), (1380, 0), (1390, 0), (1400, 0), (1410, 0), (1420, 0), (1430, 0), (1440, 0), (1450, 0), (1460, 0), (1470, 0), (1480, 0), (1490, 0), (1500, 0), (1510, 0), (1520, 0), (1530, 0), (1540, 0), (1550, 0), (1560, 0), (1570, 0), (1580, 0), (1590, 0), (1600, 0), (1610, 0), (1620, 0), (1630, 0), (1640, 0), (1650, 0), (1660, 0), (1670, 0), (1680, 0), (1690, 0), (1700, 0), (1710, 0), (1720, 0), (1730, 0), (1740, 0), (1750, 0), (1760, 0), (1770, 0), (1780, 0), (1790, 0), (1800, 0), (1810, 0), (1820, 0), (1830, 0), (1840, 0), (1850, 0), (1860, 0), (1870, 0), (1880, 0), (1890, 0), (1900, 0), (1910, 0), (1920, 0), (1930, 0), (1940, 0), (1950, 0), (1960, 0), (1970, 0), (1980, 0), (1990, 0), (2000, 0), (2010, 0), (2020, 0), (2030, 0), (2040, 0), (2050, 0)]
Va1_0  a1_0  0 PWL (0n 0.0v 9.495n 0.0v 9.505n 0.0v 19.495n 0.0v 19.505n 0.0v 29.495n 0.0v 29.505n 0.0v 39.495n 0.0v 39.505n 0.0v 49.495n 0.0v 49.505n 0.0v 59.495n 0.0v 59.505n 0.0v 69.495n 0.0v 69.505n 0.0v 79.495n 0.0v 79.505n 0.0v 89.495n 0.0v 89.505n 0.0v 99.495n 0.0v 99.505n 0.0v 109.495n 0.0v 109.505n 0.0v 119.495n 0.0v 119.505n 0.0v 129.495n 0.0v 129.505n 0.0v 139.495n 0.0v 139.505n 0.0v 149.495n 0.0v 149.505n 0.0v 159.495n 0.0v 159.505n 0.0v 169.495n 0.0v 169.505n 0.0v 179.495n 0.0v 179.505n 0.0v 189.495n 0.0v 189.505n 0.0v 199.495n 0.0v 199.505n 0.0v 209.495n 0.0v 209.505n 0.0v 219.495n 0.0v 219.505n 0.0v 229.495n 0.0v 229.505n 0.0v 239.495n 0.0v 239.505n 0.0v 249.495n 0.0v 249.505n 0.0v 259.495n 0.0v 259.505n 0.0v 269.495n 0.0v 269.505n 0.0v 279.495n 0.0v 279.505n 0.0v 289.495n 0.0v 289.505n 0.0v 299.495n 0.0v 299.505n 0.0v 309.495n 0.0v 309.505n 0.0v 319.495n 0.0v 319.505n 0.0v 329.495n 0.0v 329.505n 0.0v 339.495n 0.0v 339.505n 0.0v 349.495n 0.0v 349.505n 0.0v 359.495n 0.0v 359.505n 0.0v 369.495n 0.0v 369.505n 0.0v 379.495n 0.0v 379.505n 0.0v 389.495n 0.0v 389.505n 0.0v 399.495n 0.0v 399.505n 0.0v 409.495n 0.0v 409.505n 0.0v 419.495n 0.0v 419.505n 0.0v 429.495n 0.0v 429.505n 0.0v 439.495n 0.0v 439.505n 0.0v 449.495n 0.0v 449.505n 0.0v 459.495n 0.0v 459.505n 0.0v 469.495n 0.0v 469.505n 0.0v 479.495n 0.0v 479.505n 0.0v 489.495n 0.0v 489.505n 0.0v 499.495n 0.0v 499.505n 0.0v 509.495n 0.0v 509.505n 0.0v 519.495n 0.0v 519.505n 0.0v 529.495n 0.0v 529.505n 0.0v 539.495n 0.0v 539.505n 0.0v 549.495n 0.0v 549.505n 0.0v 559.495n 0.0v 559.505n 0.0v 569.495n 0.0v 569.505n 0.0v 579.495n 0.0v 579.505n 0.0v 589.495n 0.0v 589.505n 0.0v 599.495n 0.0v 599.505n 0.0v 609.495n 0.0v 609.505n 0.0v 619.495n 0.0v 619.505n 0.0v 629.495n 0.0v 629.505n 0.0v 639.495n 0.0v 639.505n 0.0v 649.495n 0.0v 649.505n 0.0v 659.495n 0.0v 659.505n 0.0v 669.495n 0.0v 669.505n 0.0v 679.495n 0.0v 679.505n 0.0v 689.495n 0.0v 689.505n 0.0v 699.495n 0.0v 699.505n 0.0v 709.495n 0.0v 709.505n 0.0v 719.495n 0.0v 719.505n 0.0v 729.495n 0.0v 729.505n 0.0v 739.495n 0.0v 739.505n 0.0v 749.495n 0.0v 749.505n 0.0v 759.495n 0.0v 759.505n 0.0v 769.495n 0.0v 769.505n 0.0v 779.495n 0.0v 779.505n 0.0v 789.495n 0.0v 789.505n 0.0v 799.495n 0.0v 799.505n 0.0v 809.495n 0.0v 809.505n 0.0v 819.495n 0.0v 819.505n 0.0v 829.495n 0.0v 829.505n 0.0v 839.495n 0.0v 839.505n 0.0v 849.495n 0.0v 849.505n 0.0v 859.495n 0.0v 859.505n 0.0v 869.495n 0.0v 869.505n 0.0v 879.495n 0.0v 879.505n 0.0v 889.495n 0.0v 889.505n 0.0v 899.495n 0.0v 899.505n 0.0v 909.495n 0.0v 909.505n 0.0v 919.495n 0.0v 919.505n 0.0v 929.495n 0.0v 929.505n 0.0v 939.495n 0.0v 939.505n 0.0v 949.495n 0.0v 949.505n 0.0v 959.495n 0.0v 959.505n 0.0v 969.495n 0.0v 969.505n 0.0v 979.495n 0.0v 979.505n 0.0v 989.495n 0.0v 989.505n 0.0v 999.495n 0.0v 999.505n 0.0v 1009.495n 0.0v 1009.505n 0.0v 1019.495n 0.0v 1019.505n 0.0v 1029.495n 0.0v 1029.505n 0.0v 1039.495n 0.0v 1039.505n 0.0v 1049.495n 0.0v 1049.505n 0.0v 1059.495n 0.0v 1059.505n 0.0v 1069.495n 0.0v 1069.505n 0.0v 1079.495n 0.0v 1079.505n 0.0v 1089.495n 0.0v 1089.505n 0.0v 1099.495n 0.0v 1099.505n 0.0v 1109.495n 0.0v 1109.505n 0.0v 1119.495n 0.0v 1119.505n 0.0v 1129.495n 0.0v 1129.505n 0.0v 1139.495n 0.0v 1139.505n 0.0v 1149.495n 0.0v 1149.505n 0.0v 1159.495n 0.0v 1159.505n 0.0v 1169.495n 0.0v 1169.505n 0.0v 1179.495n 0.0v 1179.505n 0.0v 1189.495n 0.0v 1189.505n 0.0v 1199.495n 0.0v 1199.505n 0.0v 1209.495n 0.0v 1209.505n 0.0v 1219.495n 0.0v 1219.505n 0.0v 1229.495n 0.0v 1229.505n 0.0v 1239.495n 0.0v 1239.505n 0.0v 1249.495n 0.0v 1249.505n 0.0v 1259.495n 0.0v 1259.505n 0.0v 1269.495n 0.0v 1269.505n 0.0v 1279.495n 0.0v 1279.505n 0.0v 1289.495n 0.0v 1289.505n 0.0v 1299.495n 0.0v 1299.505n 0.0v 1309.495n 0.0v 1309.505n 0.0v 1319.495n 0.0v 1319.505n 0.0v 1329.495n 0.0v 1329.505n 0.0v 1339.495n 0.0v 1339.505n 0.0v 1349.495n 0.0v 1349.505n 0.0v 1359.495n 0.0v 1359.505n 0.0v 1369.495n 0.0v 1369.505n 0.0v 1379.495n 0.0v 1379.505n 0.0v 1389.495n 0.0v 1389.505n 0.0v 1399.495n 0.0v 1399.505n 0.0v 1409.495n 0.0v 1409.505n 0.0v 1419.495n 0.0v 1419.505n 0.0v 1429.495n 0.0v 1429.505n 0.0v 1439.495n 0.0v 1439.505n 0.0v 1449.495n 0.0v 1449.505n 0.0v 1459.495n 0.0v 1459.505n 0.0v 1469.495n 0.0v 1469.505n 0.0v 1479.495n 0.0v 1479.505n 0.0v 1489.495n 0.0v 1489.505n 0.0v 1499.495n 0.0v 1499.505n 0.0v 1509.495n 0.0v 1509.505n 0.0v 1519.495n 0.0v 1519.505n 0.0v 1529.495n 0.0v 1529.505n 0.0v 1539.495n 0.0v 1539.505n 0.0v 1549.495n 0.0v 1549.505n 0.0v 1559.495n 0.0v 1559.505n 0.0v 1569.495n 0.0v 1569.505n 0.0v 1579.495n 0.0v 1579.505n 0.0v 1589.495n 0.0v 1589.505n 0.0v 1599.495n 0.0v 1599.505n 0.0v 1609.495n 0.0v 1609.505n 0.0v 1619.495n 0.0v 1619.505n 0.0v 1629.495n 0.0v 1629.505n 0.0v 1639.495n 0.0v 1639.505n 0.0v 1649.495n 0.0v 1649.505n 0.0v 1659.495n 0.0v 1659.505n 0.0v 1669.495n 0.0v 1669.505n 0.0v 1679.495n 0.0v 1679.505n 0.0v 1689.495n 0.0v 1689.505n 0.0v 1699.495n 0.0v 1699.505n 0.0v 1709.495n 0.0v 1709.505n 0.0v 1719.495n 0.0v 1719.505n 0.0v 1729.495n 0.0v 1729.505n 0.0v 1739.495n 0.0v 1739.505n 0.0v 1749.495n 0.0v 1749.505n 0.0v 1759.495n 0.0v 1759.505n 0.0v 1769.495n 0.0v 1769.505n 0.0v 1779.495n 0.0v 1779.505n 0.0v 1789.495n 0.0v 1789.505n 0.0v 1799.495n 0.0v 1799.505n 0.0v 1809.495n 0.0v 1809.505n 0.0v 1819.495n 0.0v 1819.505n 0.0v 1829.495n 0.0v 1829.505n 0.0v 1839.495n 0.0v 1839.505n 0.0v 1849.495n 0.0v 1849.505n 0.0v 1859.495n 0.0v 1859.505n 0.0v 1869.495n 0.0v 1869.505n 0.0v 1879.495n 0.0v 1879.505n 0.0v 1889.495n 0.0v 1889.505n 0.0v 1899.495n 0.0v 1899.505n 0.0v 1909.495n 0.0v 1909.505n 0.0v 1919.495n 0.0v 1919.505n 0.0v 1929.495n 0.0v 1929.505n 0.0v 1939.495n 0.0v 1939.505n 0.0v 1949.495n 0.0v 1949.505n 0.0v 1959.495n 0.0v 1959.505n 0.0v 1969.495n 0.0v 1969.505n 0.0v 1979.495n 0.0v 1979.505n 0.0v 1989.495n 0.0v 1989.505n 0.0v 1999.495n 0.0v 1999.505n 0.0v 2009.495n 0.0v 2009.505n 0.0v 2019.495n 0.0v 2019.505n 0.0v 2029.495n 0.0v 2029.505n 0.0v 2039.495n 0.0v 2039.505n 0.0v 2049.495n 0.0v 2049.505n 0.0v )
* (time, data): [(0, 0), (10, 1), (20, 0), (30, 0), (40, 1), (50, 1), (60, 0), (70, 0), (80, 1), (90, 0), (100, 0), (110, 1), (120, 1), (130, 1), (140, 1), (150, 0), (160, 0), (170, 0), (180, 1), (190, 1), (200, 1), (210, 1), (220, 1), (230, 1), (240, 1), (250, 1), (260, 0), (270, 0), (280, 0), (290, 1), (300, 0), (310, 0), (320, 0), (330, 0), (340, 0), (350, 0), (360, 0), (370, 0), (380, 0), (390, 1), (400, 1), (410, 1), (420, 1), (430, 1), (440, 1), (450, 1), (460, 0), (470, 0), (480, 0), (490, 1), (500, 1), (510, 1), (520, 1), (530, 1), (540, 1), (550, 1), (560, 1), (570, 1), (580, 1), (590, 1), (600, 1), (610, 1), (620, 1), (630, 1), (640, 1), (650, 1), (660, 0), (670, 0), (680, 0), (690, 0), (700, 1), (710, 1), (720, 1), (730, 1), (740, 1), (750, 1), (760, 1), (770, 1), (780, 1), (790, 0), (800, 0), (810, 1), (820, 1), (830, 1), (840, 1), (850, 1), (860, 1), (870, 1), (880, 1), (890, 1), (900, 1), (910, 0), (920, 1), (930, 1), (940, 0), (950, 0), (960, 0), (970, 0), (980, 0), (990, 0), (1000, 0), (1010, 1), (1020, 1), (1030, 0), (1040, 0), (1050, 0), (1060, 0), (1070, 0), (1080, 0), (1090, 1), (1100, 1), (1110, 1), (1120, 0), (1130, 0), (1140, 1), (1150, 1), (1160, 1), (1170, 1), (1180, 1), (1190, 1), (1200, 1), (1210, 1), (1220, 1), (1230, 0), (1240, 0), (1250, 0), (1260, 0), (1270, 1), (1280, 1), (1290, 1), (1300, 1), (1310, 1), (1320, 1), (1330, 1), (1340, 1), (1350, 0), (1360, 1), (1370, 1), (1380, 1), (1390, 1), (1400, 1), (1410, 1), (1420, 1), (1430, 1), (1440, 1), (1450, 0), (1460, 0), (1470, 0), (1480, 0), (1490, 0), (1500, 1), (1510, 1), (1520, 1), (1530, 0), (1540, 0), (1550, 1), (1560, 0), (1570, 0), (1580, 0), (1590, 1), (1600, 1), (1610, 1), (1620, 1), (1630, 0), (1640, 0), (1650, 0), (1660, 0), (1670, 1), (1680, 0), (1690, 1), (1700, 1), (1710, 0), (1720, 1), (1730, 0), (1740, 0), (1750, 0), (1760, 0), (1770, 0), (1780, 0), (1790, 0), (1800, 0), (1810, 0), (1820, 0), (1830, 0), (1840, 1), (1850, 1), (1860, 0), (1870, 0), (1880, 1), (1890, 1), (1900, 1), (1910, 0), (1920, 0), (1930, 1), (1940, 0), (1950, 0), (1960, 0), (1970, 0), (1980, 0), (1990, 0), (2000, 1), (2010, 0), (2020, 1), (2030, 1), (2040, 1), (2050, 1)]
Va1_1  a1_1  0 PWL (0n 0.0v 9.495n 0.0v 9.505n 3.3v 19.495n 3.3v 19.505n 0.0v 29.495n 0.0v 29.505n 0.0v 39.495n 0.0v 39.505n 3.3v 49.495n 3.3v 49.505n 3.3v 59.495n 3.3v 59.505n 0.0v 69.495n 0.0v 69.505n 0.0v 79.495n 0.0v 79.505n 3.3v 89.495n 3.3v 89.505n 0.0v 99.495n 0.0v 99.505n 0.0v 109.495n 0.0v 109.505n 3.3v 119.495n 3.3v 119.505n 3.3v 129.495n 3.3v 129.505n 3.3v 139.495n 3.3v 139.505n 3.3v 149.495n 3.3v 149.505n 0.0v 159.495n 0.0v 159.505n 0.0v 169.495n 0.0v 169.505n 0.0v 179.495n 0.0v 179.505n 3.3v 189.495n 3.3v 189.505n 3.3v 199.495n 3.3v 199.505n 3.3v 209.495n 3.3v 209.505n 3.3v 219.495n 3.3v 219.505n 3.3v 229.495n 3.3v 229.505n 3.3v 239.495n 3.3v 239.505n 3.3v 249.495n 3.3v 249.505n 3.3v 259.495n 3.3v 259.505n 0.0v 269.495n 0.0v 269.505n 0.0v 279.495n 0.0v 279.505n 0.0v 289.495n 0.0v 289.505n 3.3v 299.495n 3.3v 299.505n 0.0v 309.495n 0.0v 309.505n 0.0v 319.495n 0.0v 319.505n 0.0v 329.495n 0.0v 329.505n 0.0v 339.495n 0.0v 339.505n 0.0v 349.495n 0.0v 349.505n 0.0v 359.495n 0.0v 359.505n 0.0v 369.495n 0.0v 369.505n 0.0v 379.495n 0.0v 379.505n 0.0v 389.495n 0.0v 389.505n 3.3v 399.495n 3.3v 399.505n 3.3v 409.495n 3.3v 409.505n 3.3v 419.495n 3.3v 419.505n 3.3v 429.495n 3.3v 429.505n 3.3v 439.495n 3.3v 439.505n 3.3v 449.495n 3.3v 449.505n 3.3v 459.495n 3.3v 459.505n 0.0v 469.495n 0.0v 469.505n 0.0v 479.495n 0.0v 479.505n 0.0v 489.495n 0.0v 489.505n 3.3v 499.495n 3.3v 499.505n 3.3v 509.495n 3.3v 509.505n 3.3v 519.495n 3.3v 519.505n 3.3v 529.495n 3.3v 529.505n 3.3v 539.495n 3.3v 539.505n 3.3v 549.495n 3.3v 549.505n 3.3v 559.495n 3.3v 559.505n 3.3v 569.495n 3.3v 569.505n 3.3v 579.495n 3.3v 579.505n 3.3v 589.495n 3.3v 589.505n 3.3v 599.495n 3.3v 599.505n 3.3v 609.495n 3.3v 609.505n 3.3v 619.495n 3.3v 619.505n 3.3v 629.495n 3.3v 629.505n 3.3v 639.495n 3.3v 639.505n 3.3v 649.495n 3.3v 649.505n 3.3v 659.495n 3.3v 659.505n 0.0v 669.495n 0.0v 669.505n 0.0v 679.495n 0.0v 679.505n 0.0v 689.495n 0.0v 689.505n 0.0v 699.495n 0.0v 699.505n 3.3v 709.495n 3.3v 709.505n 3.3v 719.495n 3.3v 719.505n 3.3v 729.495n 3.3v 729.505n 3.3v 739.495n 3.3v 739.505n 3.3v 749.495n 3.3v 749.505n 3.3v 759.495n 3.3v 759.505n 3.3v 769.495n 3.3v 769.505n 3.3v 779.495n 3.3v 779.505n 3.3v 789.495n 3.3v 789.505n 0.0v 799.495n 0.0v 799.505n 0.0v 809.495n 0.0v 809.505n 3.3v 819.495n 3.3v 819.505n 3.3v 829.495n 3.3v 829.505n 3.3v 839.495n 3.3v 839.505n 3.3v 849.495n 3.3v 849.505n 3.3v 859.495n 3.3v 859.505n 3.3v 869.495n 3.3v 869.505n 3.3v 879.495n 3.3v 879.505n 3.3v 889.495n 3.3v 889.505n 3.3v 899.495n 3.3v 899.505n 3.3v 909.495n 3.3v 909.505n 0.0v 919.495n 0.0v 919.505n 3.3v 929.495n 3.3v 929.505n 3.3v 939.495n 3.3v 939.505n 0.0v 949.495n 0.0v 949.505n 0.0v 959.495n 0.0v 959.505n 0.0v 969.495n 0.0v 969.505n 0.0v 979.495n 0.0v 979.505n 0.0v 989.495n 0.0v 989.505n 0.0v 999.495n 0.0v 999.505n 0.0v 1009.495n 0.0v 1009.505n 3.3v 1019.495n 3.3v 1019.505n 3.3v 1029.495n 3.3v 1029.505n 0.0v 1039.495n 0.0v 1039.505n 0.0v 1049.495n 0.0v 1049.505n 0.0v 1059.495n 0.0v 1059.505n 0.0v 1069.495n 0.0v 1069.505n 0.0v 1079.495n 0.0v 1079.505n 0.0v 1089.495n 0.0v 1089.505n 3.3v 1099.495n 3.3v 1099.505n 3.3v 1109.495n 3.3v 1109.505n 3.3v 1119.495n 3.3v 1119.505n 0.0v 1129.495n 0.0v 1129.505n 0.0v 1139.495n 0.0v 1139.505n 3.3v 1149.495n 3.3v 1149.505n 3.3v 1159.495n 3.3v 1159.505n 3.3v 1169.495n 3.3v 1169.505n 3.3v 1179.495n 3.3v 1179.505n 3.3v 1189.495n 3.3v 1189.505n 3.3v 1199.495n 3.3v 1199.505n 3.3v 1209.495n 3.3v 1209.505n 3.3v 1219.495n 3.3v 1219.505n 3.3v 1229.495n 3.3v 1229.505n 0.0v 1239.495n 0.0v 1239.505n 0.0v 1249.495n 0.0v 1249.505n 0.0v 1259.495n 0.0v 1259.505n 0.0v 1269.495n 0.0v 1269.505n 3.3v 1279.495n 3.3v 1279.505n 3.3v 1289.495n 3.3v 1289.505n 3.3v 1299.495n 3.3v 1299.505n 3.3v 1309.495n 3.3v 1309.505n 3.3v 1319.495n 3.3v 1319.505n 3.3v 1329.495n 3.3v 1329.505n 3.3v 1339.495n 3.3v 1339.505n 3.3v 1349.495n 3.3v 1349.505n 0.0v 1359.495n 0.0v 1359.505n 3.3v 1369.495n 3.3v 1369.505n 3.3v 1379.495n 3.3v 1379.505n 3.3v 1389.495n 3.3v 1389.505n 3.3v 1399.495n 3.3v 1399.505n 3.3v 1409.495n 3.3v 1409.505n 3.3v 1419.495n 3.3v 1419.505n 3.3v 1429.495n 3.3v 1429.505n 3.3v 1439.495n 3.3v 1439.505n 3.3v 1449.495n 3.3v 1449.505n 0.0v 1459.495n 0.0v 1459.505n 0.0v 1469.495n 0.0v 1469.505n 0.0v 1479.495n 0.0v 1479.505n 0.0v 1489.495n 0.0v 1489.505n 0.0v 1499.495n 0.0v 1499.505n 3.3v 1509.495n 3.3v 1509.505n 3.3v 1519.495n 3.3v 1519.505n 3.3v 1529.495n 3.3v 1529.505n 0.0v 1539.495n 0.0v 1539.505n 0.0v 1549.495n 0.0v 1549.505n 3.3v 1559.495n 3.3v 1559.505n 0.0v 1569.495n 0.0v 1569.505n 0.0v 1579.495n 0.0v 1579.505n 0.0v 1589.495n 0.0v 1589.505n 3.3v 1599.495n 3.3v 1599.505n 3.3v 1609.495n 3.3v 1609.505n 3.3v 1619.495n 3.3v 1619.505n 3.3v 1629.495n 3.3v 1629.505n 0.0v 1639.495n 0.0v 1639.505n 0.0v 1649.495n 0.0v 1649.505n 0.0v 1659.495n 0.0v 1659.505n 0.0v 1669.495n 0.0v 1669.505n 3.3v 1679.495n 3.3v 1679.505n 0.0v 1689.495n 0.0v 1689.505n 3.3v 1699.495n 3.3v 1699.505n 3.3v 1709.495n 3.3v 1709.505n 0.0v 1719.495n 0.0v 1719.505n 3.3v 1729.495n 3.3v 1729.505n 0.0v 1739.495n 0.0v 1739.505n 0.0v 1749.495n 0.0v 1749.505n 0.0v 1759.495n 0.0v 1759.505n 0.0v 1769.495n 0.0v 1769.505n 0.0v 1779.495n 0.0v 1779.505n 0.0v 1789.495n 0.0v 1789.505n 0.0v 1799.495n 0.0v 1799.505n 0.0v 1809.495n 0.0v 1809.505n 0.0v 1819.495n 0.0v 1819.505n 0.0v 1829.495n 0.0v 1829.505n 0.0v 1839.495n 0.0v 1839.505n 3.3v 1849.495n 3.3v 1849.505n 3.3v 1859.495n 3.3v 1859.505n 0.0v 1869.495n 0.0v 1869.505n 0.0v 1879.495n 0.0v 1879.505n 3.3v 1889.495n 3.3v 1889.505n 3.3v 1899.495n 3.3v 1899.505n 3.3v 1909.495n 3.3v 1909.505n 0.0v 1919.495n 0.0v 1919.505n 0.0v 1929.495n 0.0v 1929.505n 3.3v 1939.495n 3.3v 1939.505n 0.0v 1949.495n 0.0v 1949.505n 0.0v 1959.495n 0.0v 1959.505n 0.0v 1969.495n 0.0v 1969.505n 0.0v 1979.495n 0.0v 1979.505n 0.0v 1989.495n 0.0v 1989.505n 0.0v 1999.495n 0.0v 1999.505n 3.3v 2009.495n 3.3v 2009.505n 0.0v 2019.495n 0.0v 2019.505n 3.3v 2029.495n 3.3v 2029.505n 3.3v 2039.495n 3.3v 2039.505n 3.3v 2049.495n 3.3v 2049.505n 3.3v )
* (time, data): [(0, 0), (10, 1), (20, 0), (30, 0), (40, 1), (50, 1), (60, 0), (70, 0), (80, 1), (90, 0), (100, 0), (110, 1), (120, 1), (130, 1), (140, 1), (150, 0), (160, 0), (170, 0), (180, 1), (190, 1), (200, 1), (210, 1), (220, 1), (230, 1), (240, 1), (250, 1), (260, 0), (270, 0), (280, 0), (290, 1), (300, 0), (310, 0), (320, 0), (330, 0), (340, 0), (350, 0), (360, 0), (370, 0), (380, 0), (390, 1), (400, 1), (410, 1), (420, 1), (430, 1), (440, 1), (450, 1), (460, 0), (470, 0), (480, 0), (490, 1), (500, 1), (510, 1), (520, 1), (530, 1), (540, 1), (550, 1), (560, 1), (570, 1), (580, 1), (590, 1), (600, 1), (610, 1), (620, 1), (630, 1), (640, 1), (650, 1), (660, 0), (670, 0), (680, 0), (690, 0), (700, 1), (710, 1), (720, 1), (730, 1), (740, 1), (750, 1), (760, 1), (770, 1), (780, 1), (790, 0), (800, 0), (810, 1), (820, 1), (830, 1), (840, 1), (850, 1), (860, 1), (870, 1), (880, 1), (890, 1), (900, 1), (910, 0), (920, 1), (930, 1), (940, 0), (950, 0), (960, 0), (970, 0), (980, 0), (990, 0), (1000, 0), (1010, 1), (1020, 1), (1030, 0), (1040, 0), (1050, 0), (1060, 0), (1070, 0), (1080, 0), (1090, 1), (1100, 1), (1110, 1), (1120, 0), (1130, 0), (1140, 1), (1150, 1), (1160, 1), (1170, 1), (1180, 1), (1190, 1), (1200, 1), (1210, 1), (1220, 1), (1230, 0), (1240, 0), (1250, 0), (1260, 0), (1270, 1), (1280, 1), (1290, 1), (1300, 1), (1310, 1), (1320, 1), (1330, 1), (1340, 1), (1350, 0), (1360, 1), (1370, 1), (1380, 1), (1390, 1), (1400, 1), (1410, 1), (1420, 1), (1430, 1), (1440, 1), (1450, 0), (1460, 0), (1470, 0), (1480, 0), (1490, 0), (1500, 1), (1510, 1), (1520, 1), (1530, 0), (1540, 0), (1550, 1), (1560, 0), (1570, 0), (1580, 0), (1590, 1), (1600, 1), (1610, 1), (1620, 1), (1630, 0), (1640, 0), (1650, 0), (1660, 0), (1670, 1), (1680, 0), (1690, 1), (1700, 1), (1710, 0), (1720, 1), (1730, 0), (1740, 0), (1750, 0), (1760, 0), (1770, 0), (1780, 0), (1790, 0), (1800, 0), (1810, 0), (1820, 0), (1830, 0), (1840, 1), (1850, 1), (1860, 0), (1870, 0), (1880, 1), (1890, 1), (1900, 1), (1910, 0), (1920, 0), (1930, 1), (1940, 0), (1950, 0), (1960, 0), (1970, 0), (1980, 0), (1990, 0), (2000, 1), (2010, 0), (2020, 1), (2030, 1), (2040, 1), (2050, 1)]
Va1_2  a1_2  0 PWL (0n 0.0v 9.495n 0.0v 9.505n 3.3v 19.495n 3.3v 19.505n 0.0v 29.495n 0.0v 29.505n 0.0v 39.495n 0.0v 39.505n 3.3v 49.495n 3.3v 49.505n 3.3v 59.495n 3.3v 59.505n 0.0v 69.495n 0.0v 69.505n 0.0v 79.495n 0.0v 79.505n 3.3v 89.495n 3.3v 89.505n 0.0v 99.495n 0.0v 99.505n 0.0v 109.495n 0.0v 109.505n 3.3v 119.495n 3.3v 119.505n 3.3v 129.495n 3.3v 129.505n 3.3v 139.495n 3.3v 139.505n 3.3v 149.495n 3.3v 149.505n 0.0v 159.495n 0.0v 159.505n 0.0v 169.495n 0.0v 169.505n 0.0v 179.495n 0.0v 179.505n 3.3v 189.495n 3.3v 189.505n 3.3v 199.495n 3.3v 199.505n 3.3v 209.495n 3.3v 209.505n 3.3v 219.495n 3.3v 219.505n 3.3v 229.495n 3.3v 229.505n 3.3v 239.495n 3.3v 239.505n 3.3v 249.495n 3.3v 249.505n 3.3v 259.495n 3.3v 259.505n 0.0v 269.495n 0.0v 269.505n 0.0v 279.495n 0.0v 279.505n 0.0v 289.495n 0.0v 289.505n 3.3v 299.495n 3.3v 299.505n 0.0v 309.495n 0.0v 309.505n 0.0v 319.495n 0.0v 319.505n 0.0v 329.495n 0.0v 329.505n 0.0v 339.495n 0.0v 339.505n 0.0v 349.495n 0.0v 349.505n 0.0v 359.495n 0.0v 359.505n 0.0v 369.495n 0.0v 369.505n 0.0v 379.495n 0.0v 379.505n 0.0v 389.495n 0.0v 389.505n 3.3v 399.495n 3.3v 399.505n 3.3v 409.495n 3.3v 409.505n 3.3v 419.495n 3.3v 419.505n 3.3v 429.495n 3.3v 429.505n 3.3v 439.495n 3.3v 439.505n 3.3v 449.495n 3.3v 449.505n 3.3v 459.495n 3.3v 459.505n 0.0v 469.495n 0.0v 469.505n 0.0v 479.495n 0.0v 479.505n 0.0v 489.495n 0.0v 489.505n 3.3v 499.495n 3.3v 499.505n 3.3v 509.495n 3.3v 509.505n 3.3v 519.495n 3.3v 519.505n 3.3v 529.495n 3.3v 529.505n 3.3v 539.495n 3.3v 539.505n 3.3v 549.495n 3.3v 549.505n 3.3v 559.495n 3.3v 559.505n 3.3v 569.495n 3.3v 569.505n 3.3v 579.495n 3.3v 579.505n 3.3v 589.495n 3.3v 589.505n 3.3v 599.495n 3.3v 599.505n 3.3v 609.495n 3.3v 609.505n 3.3v 619.495n 3.3v 619.505n 3.3v 629.495n 3.3v 629.505n 3.3v 639.495n 3.3v 639.505n 3.3v 649.495n 3.3v 649.505n 3.3v 659.495n 3.3v 659.505n 0.0v 669.495n 0.0v 669.505n 0.0v 679.495n 0.0v 679.505n 0.0v 689.495n 0.0v 689.505n 0.0v 699.495n 0.0v 699.505n 3.3v 709.495n 3.3v 709.505n 3.3v 719.495n 3.3v 719.505n 3.3v 729.495n 3.3v 729.505n 3.3v 739.495n 3.3v 739.505n 3.3v 749.495n 3.3v 749.505n 3.3v 759.495n 3.3v 759.505n 3.3v 769.495n 3.3v 769.505n 3.3v 779.495n 3.3v 779.505n 3.3v 789.495n 3.3v 789.505n 0.0v 799.495n 0.0v 799.505n 0.0v 809.495n 0.0v 809.505n 3.3v 819.495n 3.3v 819.505n 3.3v 829.495n 3.3v 829.505n 3.3v 839.495n 3.3v 839.505n 3.3v 849.495n 3.3v 849.505n 3.3v 859.495n 3.3v 859.505n 3.3v 869.495n 3.3v 869.505n 3.3v 879.495n 3.3v 879.505n 3.3v 889.495n 3.3v 889.505n 3.3v 899.495n 3.3v 899.505n 3.3v 909.495n 3.3v 909.505n 0.0v 919.495n 0.0v 919.505n 3.3v 929.495n 3.3v 929.505n 3.3v 939.495n 3.3v 939.505n 0.0v 949.495n 0.0v 949.505n 0.0v 959.495n 0.0v 959.505n 0.0v 969.495n 0.0v 969.505n 0.0v 979.495n 0.0v 979.505n 0.0v 989.495n 0.0v 989.505n 0.0v 999.495n 0.0v 999.505n 0.0v 1009.495n 0.0v 1009.505n 3.3v 1019.495n 3.3v 1019.505n 3.3v 1029.495n 3.3v 1029.505n 0.0v 1039.495n 0.0v 1039.505n 0.0v 1049.495n 0.0v 1049.505n 0.0v 1059.495n 0.0v 1059.505n 0.0v 1069.495n 0.0v 1069.505n 0.0v 1079.495n 0.0v 1079.505n 0.0v 1089.495n 0.0v 1089.505n 3.3v 1099.495n 3.3v 1099.505n 3.3v 1109.495n 3.3v 1109.505n 3.3v 1119.495n 3.3v 1119.505n 0.0v 1129.495n 0.0v 1129.505n 0.0v 1139.495n 0.0v 1139.505n 3.3v 1149.495n 3.3v 1149.505n 3.3v 1159.495n 3.3v 1159.505n 3.3v 1169.495n 3.3v 1169.505n 3.3v 1179.495n 3.3v 1179.505n 3.3v 1189.495n 3.3v 1189.505n 3.3v 1199.495n 3.3v 1199.505n 3.3v 1209.495n 3.3v 1209.505n 3.3v 1219.495n 3.3v 1219.505n 3.3v 1229.495n 3.3v 1229.505n 0.0v 1239.495n 0.0v 1239.505n 0.0v 1249.495n 0.0v 1249.505n 0.0v 1259.495n 0.0v 1259.505n 0.0v 1269.495n 0.0v 1269.505n 3.3v 1279.495n 3.3v 1279.505n 3.3v 1289.495n 3.3v 1289.505n 3.3v 1299.495n 3.3v 1299.505n 3.3v 1309.495n 3.3v 1309.505n 3.3v 1319.495n 3.3v 1319.505n 3.3v 1329.495n 3.3v 1329.505n 3.3v 1339.495n 3.3v 1339.505n 3.3v 1349.495n 3.3v 1349.505n 0.0v 1359.495n 0.0v 1359.505n 3.3v 1369.495n 3.3v 1369.505n 3.3v 1379.495n 3.3v 1379.505n 3.3v 1389.495n 3.3v 1389.505n 3.3v 1399.495n 3.3v 1399.505n 3.3v 1409.495n 3.3v 1409.505n 3.3v 1419.495n 3.3v 1419.505n 3.3v 1429.495n 3.3v 1429.505n 3.3v 1439.495n 3.3v 1439.505n 3.3v 1449.495n 3.3v 1449.505n 0.0v 1459.495n 0.0v 1459.505n 0.0v 1469.495n 0.0v 1469.505n 0.0v 1479.495n 0.0v 1479.505n 0.0v 1489.495n 0.0v 1489.505n 0.0v 1499.495n 0.0v 1499.505n 3.3v 1509.495n 3.3v 1509.505n 3.3v 1519.495n 3.3v 1519.505n 3.3v 1529.495n 3.3v 1529.505n 0.0v 1539.495n 0.0v 1539.505n 0.0v 1549.495n 0.0v 1549.505n 3.3v 1559.495n 3.3v 1559.505n 0.0v 1569.495n 0.0v 1569.505n 0.0v 1579.495n 0.0v 1579.505n 0.0v 1589.495n 0.0v 1589.505n 3.3v 1599.495n 3.3v 1599.505n 3.3v 1609.495n 3.3v 1609.505n 3.3v 1619.495n 3.3v 1619.505n 3.3v 1629.495n 3.3v 1629.505n 0.0v 1639.495n 0.0v 1639.505n 0.0v 1649.495n 0.0v 1649.505n 0.0v 1659.495n 0.0v 1659.505n 0.0v 1669.495n 0.0v 1669.505n 3.3v 1679.495n 3.3v 1679.505n 0.0v 1689.495n 0.0v 1689.505n 3.3v 1699.495n 3.3v 1699.505n 3.3v 1709.495n 3.3v 1709.505n 0.0v 1719.495n 0.0v 1719.505n 3.3v 1729.495n 3.3v 1729.505n 0.0v 1739.495n 0.0v 1739.505n 0.0v 1749.495n 0.0v 1749.505n 0.0v 1759.495n 0.0v 1759.505n 0.0v 1769.495n 0.0v 1769.505n 0.0v 1779.495n 0.0v 1779.505n 0.0v 1789.495n 0.0v 1789.505n 0.0v 1799.495n 0.0v 1799.505n 0.0v 1809.495n 0.0v 1809.505n 0.0v 1819.495n 0.0v 1819.505n 0.0v 1829.495n 0.0v 1829.505n 0.0v 1839.495n 0.0v 1839.505n 3.3v 1849.495n 3.3v 1849.505n 3.3v 1859.495n 3.3v 1859.505n 0.0v 1869.495n 0.0v 1869.505n 0.0v 1879.495n 0.0v 1879.505n 3.3v 1889.495n 3.3v 1889.505n 3.3v 1899.495n 3.3v 1899.505n 3.3v 1909.495n 3.3v 1909.505n 0.0v 1919.495n 0.0v 1919.505n 0.0v 1929.495n 0.0v 1929.505n 3.3v 1939.495n 3.3v 1939.505n 0.0v 1949.495n 0.0v 1949.505n 0.0v 1959.495n 0.0v 1959.505n 0.0v 1969.495n 0.0v 1969.505n 0.0v 1979.495n 0.0v 1979.505n 0.0v 1989.495n 0.0v 1989.505n 0.0v 1999.495n 0.0v 1999.505n 3.3v 2009.495n 3.3v 2009.505n 0.0v 2019.495n 0.0v 2019.505n 3.3v 2029.495n 3.3v 2029.505n 3.3v 2039.495n 3.3v 2039.505n 3.3v 2049.495n 3.3v 2049.505n 3.3v )
* (time, data): [(0, 0), (10, 1), (20, 0), (30, 0), (40, 1), (50, 1), (60, 0), (70, 0), (80, 1), (90, 0), (100, 0), (110, 1), (120, 1), (130, 1), (140, 1), (150, 0), (160, 0), (170, 0), (180, 1), (190, 1), (200, 1), (210, 1), (220, 1), (230, 1), (240, 1), (250, 1), (260, 0), (270, 0), (280, 0), (290, 1), (300, 0), (310, 0), (320, 0), (330, 0), (340, 0), (350, 0), (360, 0), (370, 0), (380, 0), (390, 1), (400, 1), (410, 1), (420, 1), (430, 1), (440, 1), (450, 1), (460, 0), (470, 0), (480, 0), (490, 1), (500, 1), (510, 1), (520, 1), (530, 1), (540, 1), (550, 1), (560, 1), (570, 1), (580, 1), (590, 1), (600, 1), (610, 1), (620, 1), (630, 1), (640, 1), (650, 1), (660, 0), (670, 0), (680, 0), (690, 0), (700, 1), (710, 1), (720, 1), (730, 1), (740, 1), (750, 1), (760, 1), (770, 1), (780, 1), (790, 0), (800, 0), (810, 1), (820, 1), (830, 1), (840, 1), (850, 1), (860, 1), (870, 1), (880, 1), (890, 1), (900, 1), (910, 0), (920, 1), (930, 1), (940, 0), (950, 0), (960, 0), (970, 0), (980, 0), (990, 0), (1000, 0), (1010, 1), (1020, 1), (1030, 0), (1040, 0), (1050, 0), (1060, 0), (1070, 0), (1080, 0), (1090, 1), (1100, 1), (1110, 1), (1120, 0), (1130, 0), (1140, 1), (1150, 1), (1160, 1), (1170, 1), (1180, 1), (1190, 1), (1200, 1), (1210, 1), (1220, 1), (1230, 0), (1240, 0), (1250, 0), (1260, 0), (1270, 1), (1280, 1), (1290, 1), (1300, 1), (1310, 1), (1320, 1), (1330, 1), (1340, 1), (1350, 0), (1360, 1), (1370, 1), (1380, 1), (1390, 1), (1400, 1), (1410, 1), (1420, 1), (1430, 1), (1440, 1), (1450, 0), (1460, 0), (1470, 0), (1480, 0), (1490, 0), (1500, 1), (1510, 1), (1520, 1), (1530, 0), (1540, 0), (1550, 1), (1560, 0), (1570, 0), (1580, 0), (1590, 1), (1600, 1), (1610, 1), (1620, 1), (1630, 0), (1640, 0), (1650, 0), (1660, 0), (1670, 1), (1680, 0), (1690, 1), (1700, 1), (1710, 0), (1720, 1), (1730, 0), (1740, 0), (1750, 0), (1760, 0), (1770, 0), (1780, 0), (1790, 0), (1800, 0), (1810, 0), (1820, 0), (1830, 0), (1840, 1), (1850, 1), (1860, 0), (1870, 0), (1880, 1), (1890, 1), (1900, 1), (1910, 0), (1920, 0), (1930, 1), (1940, 0), (1950, 0), (1960, 0), (1970, 0), (1980, 0), (1990, 0), (2000, 1), (2010, 0), (2020, 1), (2030, 1), (2040, 1), (2050, 1)]
Va1_3  a1_3  0 PWL (0n 0.0v 9.495n 0.0v 9.505n 3.3v 19.495n 3.3v 19.505n 0.0v 29.495n 0.0v 29.505n 0.0v 39.495n 0.0v 39.505n 3.3v 49.495n 3.3v 49.505n 3.3v 59.495n 3.3v 59.505n 0.0v 69.495n 0.0v 69.505n 0.0v 79.495n 0.0v 79.505n 3.3v 89.495n 3.3v 89.505n 0.0v 99.495n 0.0v 99.505n 0.0v 109.495n 0.0v 109.505n 3.3v 119.495n 3.3v 119.505n 3.3v 129.495n 3.3v 129.505n 3.3v 139.495n 3.3v 139.505n 3.3v 149.495n 3.3v 149.505n 0.0v 159.495n 0.0v 159.505n 0.0v 169.495n 0.0v 169.505n 0.0v 179.495n 0.0v 179.505n 3.3v 189.495n 3.3v 189.505n 3.3v 199.495n 3.3v 199.505n 3.3v 209.495n 3.3v 209.505n 3.3v 219.495n 3.3v 219.505n 3.3v 229.495n 3.3v 229.505n 3.3v 239.495n 3.3v 239.505n 3.3v 249.495n 3.3v 249.505n 3.3v 259.495n 3.3v 259.505n 0.0v 269.495n 0.0v 269.505n 0.0v 279.495n 0.0v 279.505n 0.0v 289.495n 0.0v 289.505n 3.3v 299.495n 3.3v 299.505n 0.0v 309.495n 0.0v 309.505n 0.0v 319.495n 0.0v 319.505n 0.0v 329.495n 0.0v 329.505n 0.0v 339.495n 0.0v 339.505n 0.0v 349.495n 0.0v 349.505n 0.0v 359.495n 0.0v 359.505n 0.0v 369.495n 0.0v 369.505n 0.0v 379.495n 0.0v 379.505n 0.0v 389.495n 0.0v 389.505n 3.3v 399.495n 3.3v 399.505n 3.3v 409.495n 3.3v 409.505n 3.3v 419.495n 3.3v 419.505n 3.3v 429.495n 3.3v 429.505n 3.3v 439.495n 3.3v 439.505n 3.3v 449.495n 3.3v 449.505n 3.3v 459.495n 3.3v 459.505n 0.0v 469.495n 0.0v 469.505n 0.0v 479.495n 0.0v 479.505n 0.0v 489.495n 0.0v 489.505n 3.3v 499.495n 3.3v 499.505n 3.3v 509.495n 3.3v 509.505n 3.3v 519.495n 3.3v 519.505n 3.3v 529.495n 3.3v 529.505n 3.3v 539.495n 3.3v 539.505n 3.3v 549.495n 3.3v 549.505n 3.3v 559.495n 3.3v 559.505n 3.3v 569.495n 3.3v 569.505n 3.3v 579.495n 3.3v 579.505n 3.3v 589.495n 3.3v 589.505n 3.3v 599.495n 3.3v 599.505n 3.3v 609.495n 3.3v 609.505n 3.3v 619.495n 3.3v 619.505n 3.3v 629.495n 3.3v 629.505n 3.3v 639.495n 3.3v 639.505n 3.3v 649.495n 3.3v 649.505n 3.3v 659.495n 3.3v 659.505n 0.0v 669.495n 0.0v 669.505n 0.0v 679.495n 0.0v 679.505n 0.0v 689.495n 0.0v 689.505n 0.0v 699.495n 0.0v 699.505n 3.3v 709.495n 3.3v 709.505n 3.3v 719.495n 3.3v 719.505n 3.3v 729.495n 3.3v 729.505n 3.3v 739.495n 3.3v 739.505n 3.3v 749.495n 3.3v 749.505n 3.3v 759.495n 3.3v 759.505n 3.3v 769.495n 3.3v 769.505n 3.3v 779.495n 3.3v 779.505n 3.3v 789.495n 3.3v 789.505n 0.0v 799.495n 0.0v 799.505n 0.0v 809.495n 0.0v 809.505n 3.3v 819.495n 3.3v 819.505n 3.3v 829.495n 3.3v 829.505n 3.3v 839.495n 3.3v 839.505n 3.3v 849.495n 3.3v 849.505n 3.3v 859.495n 3.3v 859.505n 3.3v 869.495n 3.3v 869.505n 3.3v 879.495n 3.3v 879.505n 3.3v 889.495n 3.3v 889.505n 3.3v 899.495n 3.3v 899.505n 3.3v 909.495n 3.3v 909.505n 0.0v 919.495n 0.0v 919.505n 3.3v 929.495n 3.3v 929.505n 3.3v 939.495n 3.3v 939.505n 0.0v 949.495n 0.0v 949.505n 0.0v 959.495n 0.0v 959.505n 0.0v 969.495n 0.0v 969.505n 0.0v 979.495n 0.0v 979.505n 0.0v 989.495n 0.0v 989.505n 0.0v 999.495n 0.0v 999.505n 0.0v 1009.495n 0.0v 1009.505n 3.3v 1019.495n 3.3v 1019.505n 3.3v 1029.495n 3.3v 1029.505n 0.0v 1039.495n 0.0v 1039.505n 0.0v 1049.495n 0.0v 1049.505n 0.0v 1059.495n 0.0v 1059.505n 0.0v 1069.495n 0.0v 1069.505n 0.0v 1079.495n 0.0v 1079.505n 0.0v 1089.495n 0.0v 1089.505n 3.3v 1099.495n 3.3v 1099.505n 3.3v 1109.495n 3.3v 1109.505n 3.3v 1119.495n 3.3v 1119.505n 0.0v 1129.495n 0.0v 1129.505n 0.0v 1139.495n 0.0v 1139.505n 3.3v 1149.495n 3.3v 1149.505n 3.3v 1159.495n 3.3v 1159.505n 3.3v 1169.495n 3.3v 1169.505n 3.3v 1179.495n 3.3v 1179.505n 3.3v 1189.495n 3.3v 1189.505n 3.3v 1199.495n 3.3v 1199.505n 3.3v 1209.495n 3.3v 1209.505n 3.3v 1219.495n 3.3v 1219.505n 3.3v 1229.495n 3.3v 1229.505n 0.0v 1239.495n 0.0v 1239.505n 0.0v 1249.495n 0.0v 1249.505n 0.0v 1259.495n 0.0v 1259.505n 0.0v 1269.495n 0.0v 1269.505n 3.3v 1279.495n 3.3v 1279.505n 3.3v 1289.495n 3.3v 1289.505n 3.3v 1299.495n 3.3v 1299.505n 3.3v 1309.495n 3.3v 1309.505n 3.3v 1319.495n 3.3v 1319.505n 3.3v 1329.495n 3.3v 1329.505n 3.3v 1339.495n 3.3v 1339.505n 3.3v 1349.495n 3.3v 1349.505n 0.0v 1359.495n 0.0v 1359.505n 3.3v 1369.495n 3.3v 1369.505n 3.3v 1379.495n 3.3v 1379.505n 3.3v 1389.495n 3.3v 1389.505n 3.3v 1399.495n 3.3v 1399.505n 3.3v 1409.495n 3.3v 1409.505n 3.3v 1419.495n 3.3v 1419.505n 3.3v 1429.495n 3.3v 1429.505n 3.3v 1439.495n 3.3v 1439.505n 3.3v 1449.495n 3.3v 1449.505n 0.0v 1459.495n 0.0v 1459.505n 0.0v 1469.495n 0.0v 1469.505n 0.0v 1479.495n 0.0v 1479.505n 0.0v 1489.495n 0.0v 1489.505n 0.0v 1499.495n 0.0v 1499.505n 3.3v 1509.495n 3.3v 1509.505n 3.3v 1519.495n 3.3v 1519.505n 3.3v 1529.495n 3.3v 1529.505n 0.0v 1539.495n 0.0v 1539.505n 0.0v 1549.495n 0.0v 1549.505n 3.3v 1559.495n 3.3v 1559.505n 0.0v 1569.495n 0.0v 1569.505n 0.0v 1579.495n 0.0v 1579.505n 0.0v 1589.495n 0.0v 1589.505n 3.3v 1599.495n 3.3v 1599.505n 3.3v 1609.495n 3.3v 1609.505n 3.3v 1619.495n 3.3v 1619.505n 3.3v 1629.495n 3.3v 1629.505n 0.0v 1639.495n 0.0v 1639.505n 0.0v 1649.495n 0.0v 1649.505n 0.0v 1659.495n 0.0v 1659.505n 0.0v 1669.495n 0.0v 1669.505n 3.3v 1679.495n 3.3v 1679.505n 0.0v 1689.495n 0.0v 1689.505n 3.3v 1699.495n 3.3v 1699.505n 3.3v 1709.495n 3.3v 1709.505n 0.0v 1719.495n 0.0v 1719.505n 3.3v 1729.495n 3.3v 1729.505n 0.0v 1739.495n 0.0v 1739.505n 0.0v 1749.495n 0.0v 1749.505n 0.0v 1759.495n 0.0v 1759.505n 0.0v 1769.495n 0.0v 1769.505n 0.0v 1779.495n 0.0v 1779.505n 0.0v 1789.495n 0.0v 1789.505n 0.0v 1799.495n 0.0v 1799.505n 0.0v 1809.495n 0.0v 1809.505n 0.0v 1819.495n 0.0v 1819.505n 0.0v 1829.495n 0.0v 1829.505n 0.0v 1839.495n 0.0v 1839.505n 3.3v 1849.495n 3.3v 1849.505n 3.3v 1859.495n 3.3v 1859.505n 0.0v 1869.495n 0.0v 1869.505n 0.0v 1879.495n 0.0v 1879.505n 3.3v 1889.495n 3.3v 1889.505n 3.3v 1899.495n 3.3v 1899.505n 3.3v 1909.495n 3.3v 1909.505n 0.0v 1919.495n 0.0v 1919.505n 0.0v 1929.495n 0.0v 1929.505n 3.3v 1939.495n 3.3v 1939.505n 0.0v 1949.495n 0.0v 1949.505n 0.0v 1959.495n 0.0v 1959.505n 0.0v 1969.495n 0.0v 1969.505n 0.0v 1979.495n 0.0v 1979.505n 0.0v 1989.495n 0.0v 1989.505n 0.0v 1999.495n 0.0v 1999.505n 3.3v 2009.495n 3.3v 2009.505n 0.0v 2019.495n 0.0v 2019.505n 3.3v 2029.495n 3.3v 2029.505n 3.3v 2039.495n 3.3v 2039.505n 3.3v 2049.495n 3.3v 2049.505n 3.3v )

 * Generation of control signals
* (time, data): [(0, 1), (10, 0), (20, 0), (30, 0), (40, 0), (50, 1), (60, 0), (70, 1), (80, 0), (90, 1), (100, 0), (110, 0), (120, 0), (130, 0), (140, 1), (150, 0), (160, 1), (170, 0), (180, 1), (190, 1), (200, 1), (210, 0), (220, 0), (230, 0), (240, 0), (250, 0), (260, 1), (270, 0), (280, 1), (290, 0), (300, 0), (310, 1), (320, 1), (330, 1), (340, 0), (350, 0), (360, 0), (370, 0), (380, 0), (390, 0), (400, 0), (410, 0), (420, 0), (430, 0), (440, 1), (450, 0), (460, 0), (470, 0), (480, 0), (490, 0), (500, 1), (510, 1), (520, 0), (530, 1), (540, 0), (550, 0), (560, 0), (570, 0), (580, 0), (590, 0), (600, 0), (610, 0), (620, 0), (630, 0), (640, 0), (650, 0), (660, 0), (670, 0), (680, 0), (690, 0), (700, 1), (710, 0), (720, 0), (730, 0), (740, 0), (750, 0), (760, 0), (770, 0), (780, 0), (790, 0), (800, 0), (810, 0), (820, 0), (830, 0), (840, 0), (850, 0), (860, 1), (870, 0), (880, 0), (890, 0), (900, 1), (910, 0), (920, 0), (930, 1), (940, 1), (950, 0), (960, 1), (970, 1), (980, 1), (990, 1), (1000, 1), (1010, 0), (1020, 0), (1030, 0), (1040, 0), (1050, 0), (1060, 1), (1070, 0), (1080, 0), (1090, 0), (1100, 0), (1110, 0), (1120, 1), (1130, 1), (1140, 1), (1150, 0), (1160, 0), (1170, 0), (1180, 0), (1190, 0), (1200, 1), (1210, 0), (1220, 0), (1230, 0), (1240, 0), (1250, 1), (1260, 0), (1270, 0), (1280, 0), (1290, 0), (1300, 0), (1310, 0), (1320, 0), (1330, 0), (1340, 0), (1350, 0), (1360, 0), (1370, 0), (1380, 1), (1390, 0), (1400, 0), (1410, 1), (1420, 0), (1430, 1), (1440, 1), (1450, 0), (1460, 1), (1470, 0), (1480, 0), (1490, 0), (1500, 0), (1510, 1), (1520, 0), (1530, 1), (1540, 1), (1550, 0), (1560, 0), (1570, 0), (1580, 0), (1590, 0), (1600, 0), (1610, 0), (1620, 0), (1630, 1), (1640, 0), (1650, 0), (1660, 0), (1670, 1), (1680, 0), (1690, 0), (1700, 0), (1710, 1), (1720, 0), (1730, 1), (1740, 0), (1750, 0), (1760, 0), (1770, 0), (1780, 0), (1790, 0), (1800, 0), (1810, 0), (1820, 0), (1830, 0), (1840, 0), (1850, 0), (1860, 0), (1870, 0), (1880, 0), (1890, 0), (1900, 1), (1910, 0), (1920, 0), (1930, 0), (1940, 0), (1950, 0), (1960, 0), (1970, 1), (1980, 0), (1990, 0), (2000, 1), (2010, 1), (2020, 1), (2030, 0), (2040, 0), (2050, 1)]
VCSB0 CSB0 0 PWL (0n 3.3v 9.495n 3.3v 9.505n 0.0v 19.495n 0.0v 19.505n 0.0v 29.495n 0.0v 29.505n 0.0v 39.495n 0.0v 39.505n 0.0v 49.495n 0.0v 49.505n 3.3v 59.495n 3.3v 59.505n 0.0v 69.495n 0.0v 69.505n 3.3v 79.495n 3.3v 79.505n 0.0v 89.495n 0.0v 89.505n 3.3v 99.495n 3.3v 99.505n 0.0v 109.495n 0.0v 109.505n 0.0v 119.495n 0.0v 119.505n 0.0v 129.495n 0.0v 129.505n 0.0v 139.495n 0.0v 139.505n 3.3v 149.495n 3.3v 149.505n 0.0v 159.495n 0.0v 159.505n 3.3v 169.495n 3.3v 169.505n 0.0v 179.495n 0.0v 179.505n 3.3v 189.495n 3.3v 189.505n 3.3v 199.495n 3.3v 199.505n 3.3v 209.495n 3.3v 209.505n 0.0v 219.495n 0.0v 219.505n 0.0v 229.495n 0.0v 229.505n 0.0v 239.495n 0.0v 239.505n 0.0v 249.495n 0.0v 249.505n 0.0v 259.495n 0.0v 259.505n 3.3v 269.495n 3.3v 269.505n 0.0v 279.495n 0.0v 279.505n 3.3v 289.495n 3.3v 289.505n 0.0v 299.495n 0.0v 299.505n 0.0v 309.495n 0.0v 309.505n 3.3v 319.495n 3.3v 319.505n 3.3v 329.495n 3.3v 329.505n 3.3v 339.495n 3.3v 339.505n 0.0v 349.495n 0.0v 349.505n 0.0v 359.495n 0.0v 359.505n 0.0v 369.495n 0.0v 369.505n 0.0v 379.495n 0.0v 379.505n 0.0v 389.495n 0.0v 389.505n 0.0v 399.495n 0.0v 399.505n 0.0v 409.495n 0.0v 409.505n 0.0v 419.495n 0.0v 419.505n 0.0v 429.495n 0.0v 429.505n 0.0v 439.495n 0.0v 439.505n 3.3v 449.495n 3.3v 449.505n 0.0v 459.495n 0.0v 459.505n 0.0v 469.495n 0.0v 469.505n 0.0v 479.495n 0.0v 479.505n 0.0v 489.495n 0.0v 489.505n 0.0v 499.495n 0.0v 499.505n 3.3v 509.495n 3.3v 509.505n 3.3v 519.495n 3.3v 519.505n 0.0v 529.495n 0.0v 529.505n 3.3v 539.495n 3.3v 539.505n 0.0v 549.495n 0.0v 549.505n 0.0v 559.495n 0.0v 559.505n 0.0v 569.495n 0.0v 569.505n 0.0v 579.495n 0.0v 579.505n 0.0v 589.495n 0.0v 589.505n 0.0v 599.495n 0.0v 599.505n 0.0v 609.495n 0.0v 609.505n 0.0v 619.495n 0.0v 619.505n 0.0v 629.495n 0.0v 629.505n 0.0v 639.495n 0.0v 639.505n 0.0v 649.495n 0.0v 649.505n 0.0v 659.495n 0.0v 659.505n 0.0v 669.495n 0.0v 669.505n 0.0v 679.495n 0.0v 679.505n 0.0v 689.495n 0.0v 689.505n 0.0v 699.495n 0.0v 699.505n 3.3v 709.495n 3.3v 709.505n 0.0v 719.495n 0.0v 719.505n 0.0v 729.495n 0.0v 729.505n 0.0v 739.495n 0.0v 739.505n 0.0v 749.495n 0.0v 749.505n 0.0v 759.495n 0.0v 759.505n 0.0v 769.495n 0.0v 769.505n 0.0v 779.495n 0.0v 779.505n 0.0v 789.495n 0.0v 789.505n 0.0v 799.495n 0.0v 799.505n 0.0v 809.495n 0.0v 809.505n 0.0v 819.495n 0.0v 819.505n 0.0v 829.495n 0.0v 829.505n 0.0v 839.495n 0.0v 839.505n 0.0v 849.495n 0.0v 849.505n 0.0v 859.495n 0.0v 859.505n 3.3v 869.495n 3.3v 869.505n 0.0v 879.495n 0.0v 879.505n 0.0v 889.495n 0.0v 889.505n 0.0v 899.495n 0.0v 899.505n 3.3v 909.495n 3.3v 909.505n 0.0v 919.495n 0.0v 919.505n 0.0v 929.495n 0.0v 929.505n 3.3v 939.495n 3.3v 939.505n 3.3v 949.495n 3.3v 949.505n 0.0v 959.495n 0.0v 959.505n 3.3v 969.495n 3.3v 969.505n 3.3v 979.495n 3.3v 979.505n 3.3v 989.495n 3.3v 989.505n 3.3v 999.495n 3.3v 999.505n 3.3v 1009.495n 3.3v 1009.505n 0.0v 1019.495n 0.0v 1019.505n 0.0v 1029.495n 0.0v 1029.505n 0.0v 1039.495n 0.0v 1039.505n 0.0v 1049.495n 0.0v 1049.505n 0.0v 1059.495n 0.0v 1059.505n 3.3v 1069.495n 3.3v 1069.505n 0.0v 1079.495n 0.0v 1079.505n 0.0v 1089.495n 0.0v 1089.505n 0.0v 1099.495n 0.0v 1099.505n 0.0v 1109.495n 0.0v 1109.505n 0.0v 1119.495n 0.0v 1119.505n 3.3v 1129.495n 3.3v 1129.505n 3.3v 1139.495n 3.3v 1139.505n 3.3v 1149.495n 3.3v 1149.505n 0.0v 1159.495n 0.0v 1159.505n 0.0v 1169.495n 0.0v 1169.505n 0.0v 1179.495n 0.0v 1179.505n 0.0v 1189.495n 0.0v 1189.505n 0.0v 1199.495n 0.0v 1199.505n 3.3v 1209.495n 3.3v 1209.505n 0.0v 1219.495n 0.0v 1219.505n 0.0v 1229.495n 0.0v 1229.505n 0.0v 1239.495n 0.0v 1239.505n 0.0v 1249.495n 0.0v 1249.505n 3.3v 1259.495n 3.3v 1259.505n 0.0v 1269.495n 0.0v 1269.505n 0.0v 1279.495n 0.0v 1279.505n 0.0v 1289.495n 0.0v 1289.505n 0.0v 1299.495n 0.0v 1299.505n 0.0v 1309.495n 0.0v 1309.505n 0.0v 1319.495n 0.0v 1319.505n 0.0v 1329.495n 0.0v 1329.505n 0.0v 1339.495n 0.0v 1339.505n 0.0v 1349.495n 0.0v 1349.505n 0.0v 1359.495n 0.0v 1359.505n 0.0v 1369.495n 0.0v 1369.505n 0.0v 1379.495n 0.0v 1379.505n 3.3v 1389.495n 3.3v 1389.505n 0.0v 1399.495n 0.0v 1399.505n 0.0v 1409.495n 0.0v 1409.505n 3.3v 1419.495n 3.3v 1419.505n 0.0v 1429.495n 0.0v 1429.505n 3.3v 1439.495n 3.3v 1439.505n 3.3v 1449.495n 3.3v 1449.505n 0.0v 1459.495n 0.0v 1459.505n 3.3v 1469.495n 3.3v 1469.505n 0.0v 1479.495n 0.0v 1479.505n 0.0v 1489.495n 0.0v 1489.505n 0.0v 1499.495n 0.0v 1499.505n 0.0v 1509.495n 0.0v 1509.505n 3.3v 1519.495n 3.3v 1519.505n 0.0v 1529.495n 0.0v 1529.505n 3.3v 1539.495n 3.3v 1539.505n 3.3v 1549.495n 3.3v 1549.505n 0.0v 1559.495n 0.0v 1559.505n 0.0v 1569.495n 0.0v 1569.505n 0.0v 1579.495n 0.0v 1579.505n 0.0v 1589.495n 0.0v 1589.505n 0.0v 1599.495n 0.0v 1599.505n 0.0v 1609.495n 0.0v 1609.505n 0.0v 1619.495n 0.0v 1619.505n 0.0v 1629.495n 0.0v 1629.505n 3.3v 1639.495n 3.3v 1639.505n 0.0v 1649.495n 0.0v 1649.505n 0.0v 1659.495n 0.0v 1659.505n 0.0v 1669.495n 0.0v 1669.505n 3.3v 1679.495n 3.3v 1679.505n 0.0v 1689.495n 0.0v 1689.505n 0.0v 1699.495n 0.0v 1699.505n 0.0v 1709.495n 0.0v 1709.505n 3.3v 1719.495n 3.3v 1719.505n 0.0v 1729.495n 0.0v 1729.505n 3.3v 1739.495n 3.3v 1739.505n 0.0v 1749.495n 0.0v 1749.505n 0.0v 1759.495n 0.0v 1759.505n 0.0v 1769.495n 0.0v 1769.505n 0.0v 1779.495n 0.0v 1779.505n 0.0v 1789.495n 0.0v 1789.505n 0.0v 1799.495n 0.0v 1799.505n 0.0v 1809.495n 0.0v 1809.505n 0.0v 1819.495n 0.0v 1819.505n 0.0v 1829.495n 0.0v 1829.505n 0.0v 1839.495n 0.0v 1839.505n 0.0v 1849.495n 0.0v 1849.505n 0.0v 1859.495n 0.0v 1859.505n 0.0v 1869.495n 0.0v 1869.505n 0.0v 1879.495n 0.0v 1879.505n 0.0v 1889.495n 0.0v 1889.505n 0.0v 1899.495n 0.0v 1899.505n 3.3v 1909.495n 3.3v 1909.505n 0.0v 1919.495n 0.0v 1919.505n 0.0v 1929.495n 0.0v 1929.505n 0.0v 1939.495n 0.0v 1939.505n 0.0v 1949.495n 0.0v 1949.505n 0.0v 1959.495n 0.0v 1959.505n 0.0v 1969.495n 0.0v 1969.505n 3.3v 1979.495n 3.3v 1979.505n 0.0v 1989.495n 0.0v 1989.505n 0.0v 1999.495n 0.0v 1999.505n 3.3v 2009.495n 3.3v 2009.505n 3.3v 2019.495n 3.3v 2019.505n 3.3v 2029.495n 3.3v 2029.505n 0.0v 2039.495n 0.0v 2039.505n 0.0v 2049.495n 0.0v 2049.505n 3.3v )
* (time, data): [(0, 1), (10, 0), (20, 0), (30, 0), (40, 0), (50, 1), (60, 0), (70, 0), (80, 0), (90, 0), (100, 0), (110, 0), (120, 0), (130, 0), (140, 1), (150, 0), (160, 1), (170, 1), (180, 0), (190, 1), (200, 0), (210, 1), (220, 1), (230, 0), (240, 1), (250, 1), (260, 0), (270, 1), (280, 0), (290, 0), (300, 0), (310, 0), (320, 0), (330, 1), (340, 0), (350, 0), (360, 1), (370, 0), (380, 1), (390, 0), (400, 1), (410, 1), (420, 0), (430, 0), (440, 0), (450, 1), (460, 0), (470, 0), (480, 0), (490, 0), (500, 0), (510, 0), (520, 1), (530, 1), (540, 1), (550, 1), (560, 1), (570, 0), (580, 1), (590, 1), (600, 1), (610, 0), (620, 0), (630, 0), (640, 0), (650, 0), (660, 0), (670, 0), (680, 1), (690, 1), (700, 0), (710, 1), (720, 0), (730, 1), (740, 0), (750, 1), (760, 1), (770, 1), (780, 0), (790, 0), (800, 0), (810, 0), (820, 0), (830, 1), (840, 0), (850, 0), (860, 0), (870, 1), (880, 0), (890, 1), (900, 0), (910, 0), (920, 0), (930, 1), (940, 0), (950, 0), (960, 1), (970, 0), (980, 0), (990, 1), (1000, 0), (1010, 0), (1020, 1), (1030, 0), (1040, 0), (1050, 1), (1060, 0), (1070, 1), (1080, 0), (1090, 0), (1100, 1), (1110, 1), (1120, 0), (1130, 0), (1140, 0), (1150, 0), (1160, 0), (1170, 1), (1180, 0), (1190, 1), (1200, 1), (1210, 1), (1220, 1), (1230, 0), (1240, 1), (1250, 0), (1260, 1), (1270, 0), (1280, 1), (1290, 0), (1300, 0), (1310, 1), (1320, 1), (1330, 0), (1340, 0), (1350, 0), (1360, 0), (1370, 1), (1380, 0), (1390, 1), (1400, 1), (1410, 0), (1420, 0), (1430, 0), (1440, 0), (1450, 0), (1460, 1), (1470, 0), (1480, 1), (1490, 0), (1500, 0), (1510, 0), (1520, 1), (1530, 0), (1540, 0), (1550, 0), (1560, 0), (1570, 1), (1580, 0), (1590, 0), (1600, 0), (1610, 1), (1620, 1), (1630, 0), (1640, 1), (1650, 0), (1660, 1), (1670, 0), (1680, 0), (1690, 0), (1700, 0), (1710, 0), (1720, 0), (1730, 0), (1740, 1), (1750, 0), (1760, 0), (1770, 0), (1780, 0), (1790, 0), (1800, 0), (1810, 1), (1820, 1), (1830, 1), (1840, 0), (1850, 1), (1860, 0), (1870, 0), (1880, 0), (1890, 1), (1900, 1), (1910, 0), (1920, 0), (1930, 0), (1940, 0), (1950, 1), (1960, 1), (1970, 1), (1980, 0), (1990, 1), (2000, 0), (2010, 0), (2020, 0), (2030, 1), (2040, 0), (2050, 1)]
VCSB1 CSB1 0 PWL (0n 3.3v 9.495n 3.3v 9.505n 0.0v 19.495n 0.0v 19.505n 0.0v 29.495n 0.0v 29.505n 0.0v 39.495n 0.0v 39.505n 0.0v 49.495n 0.0v 49.505n 3.3v 59.495n 3.3v 59.505n 0.0v 69.495n 0.0v 69.505n 0.0v 79.495n 0.0v 79.505n 0.0v 89.495n 0.0v 89.505n 0.0v 99.495n 0.0v 99.505n 0.0v 109.495n 0.0v 109.505n 0.0v 119.495n 0.0v 119.505n 0.0v 129.495n 0.0v 129.505n 0.0v 139.495n 0.0v 139.505n 3.3v 149.495n 3.3v 149.505n 0.0v 159.495n 0.0v 159.505n 3.3v 169.495n 3.3v 169.505n 3.3v 179.495n 3.3v 179.505n 0.0v 189.495n 0.0v 189.505n 3.3v 199.495n 3.3v 199.505n 0.0v 209.495n 0.0v 209.505n 3.3v 219.495n 3.3v 219.505n 3.3v 229.495n 3.3v 229.505n 0.0v 239.495n 0.0v 239.505n 3.3v 249.495n 3.3v 249.505n 3.3v 259.495n 3.3v 259.505n 0.0v 269.495n 0.0v 269.505n 3.3v 279.495n 3.3v 279.505n 0.0v 289.495n 0.0v 289.505n 0.0v 299.495n 0.0v 299.505n 0.0v 309.495n 0.0v 309.505n 0.0v 319.495n 0.0v 319.505n 0.0v 329.495n 0.0v 329.505n 3.3v 339.495n 3.3v 339.505n 0.0v 349.495n 0.0v 349.505n 0.0v 359.495n 0.0v 359.505n 3.3v 369.495n 3.3v 369.505n 0.0v 379.495n 0.0v 379.505n 3.3v 389.495n 3.3v 389.505n 0.0v 399.495n 0.0v 399.505n 3.3v 409.495n 3.3v 409.505n 3.3v 419.495n 3.3v 419.505n 0.0v 429.495n 0.0v 429.505n 0.0v 439.495n 0.0v 439.505n 0.0v 449.495n 0.0v 449.505n 3.3v 459.495n 3.3v 459.505n 0.0v 469.495n 0.0v 469.505n 0.0v 479.495n 0.0v 479.505n 0.0v 489.495n 0.0v 489.505n 0.0v 499.495n 0.0v 499.505n 0.0v 509.495n 0.0v 509.505n 0.0v 519.495n 0.0v 519.505n 3.3v 529.495n 3.3v 529.505n 3.3v 539.495n 3.3v 539.505n 3.3v 549.495n 3.3v 549.505n 3.3v 559.495n 3.3v 559.505n 3.3v 569.495n 3.3v 569.505n 0.0v 579.495n 0.0v 579.505n 3.3v 589.495n 3.3v 589.505n 3.3v 599.495n 3.3v 599.505n 3.3v 609.495n 3.3v 609.505n 0.0v 619.495n 0.0v 619.505n 0.0v 629.495n 0.0v 629.505n 0.0v 639.495n 0.0v 639.505n 0.0v 649.495n 0.0v 649.505n 0.0v 659.495n 0.0v 659.505n 0.0v 669.495n 0.0v 669.505n 0.0v 679.495n 0.0v 679.505n 3.3v 689.495n 3.3v 689.505n 3.3v 699.495n 3.3v 699.505n 0.0v 709.495n 0.0v 709.505n 3.3v 719.495n 3.3v 719.505n 0.0v 729.495n 0.0v 729.505n 3.3v 739.495n 3.3v 739.505n 0.0v 749.495n 0.0v 749.505n 3.3v 759.495n 3.3v 759.505n 3.3v 769.495n 3.3v 769.505n 3.3v 779.495n 3.3v 779.505n 0.0v 789.495n 0.0v 789.505n 0.0v 799.495n 0.0v 799.505n 0.0v 809.495n 0.0v 809.505n 0.0v 819.495n 0.0v 819.505n 0.0v 829.495n 0.0v 829.505n 3.3v 839.495n 3.3v 839.505n 0.0v 849.495n 0.0v 849.505n 0.0v 859.495n 0.0v 859.505n 0.0v 869.495n 0.0v 869.505n 3.3v 879.495n 3.3v 879.505n 0.0v 889.495n 0.0v 889.505n 3.3v 899.495n 3.3v 899.505n 0.0v 909.495n 0.0v 909.505n 0.0v 919.495n 0.0v 919.505n 0.0v 929.495n 0.0v 929.505n 3.3v 939.495n 3.3v 939.505n 0.0v 949.495n 0.0v 949.505n 0.0v 959.495n 0.0v 959.505n 3.3v 969.495n 3.3v 969.505n 0.0v 979.495n 0.0v 979.505n 0.0v 989.495n 0.0v 989.505n 3.3v 999.495n 3.3v 999.505n 0.0v 1009.495n 0.0v 1009.505n 0.0v 1019.495n 0.0v 1019.505n 3.3v 1029.495n 3.3v 1029.505n 0.0v 1039.495n 0.0v 1039.505n 0.0v 1049.495n 0.0v 1049.505n 3.3v 1059.495n 3.3v 1059.505n 0.0v 1069.495n 0.0v 1069.505n 3.3v 1079.495n 3.3v 1079.505n 0.0v 1089.495n 0.0v 1089.505n 0.0v 1099.495n 0.0v 1099.505n 3.3v 1109.495n 3.3v 1109.505n 3.3v 1119.495n 3.3v 1119.505n 0.0v 1129.495n 0.0v 1129.505n 0.0v 1139.495n 0.0v 1139.505n 0.0v 1149.495n 0.0v 1149.505n 0.0v 1159.495n 0.0v 1159.505n 0.0v 1169.495n 0.0v 1169.505n 3.3v 1179.495n 3.3v 1179.505n 0.0v 1189.495n 0.0v 1189.505n 3.3v 1199.495n 3.3v 1199.505n 3.3v 1209.495n 3.3v 1209.505n 3.3v 1219.495n 3.3v 1219.505n 3.3v 1229.495n 3.3v 1229.505n 0.0v 1239.495n 0.0v 1239.505n 3.3v 1249.495n 3.3v 1249.505n 0.0v 1259.495n 0.0v 1259.505n 3.3v 1269.495n 3.3v 1269.505n 0.0v 1279.495n 0.0v 1279.505n 3.3v 1289.495n 3.3v 1289.505n 0.0v 1299.495n 0.0v 1299.505n 0.0v 1309.495n 0.0v 1309.505n 3.3v 1319.495n 3.3v 1319.505n 3.3v 1329.495n 3.3v 1329.505n 0.0v 1339.495n 0.0v 1339.505n 0.0v 1349.495n 0.0v 1349.505n 0.0v 1359.495n 0.0v 1359.505n 0.0v 1369.495n 0.0v 1369.505n 3.3v 1379.495n 3.3v 1379.505n 0.0v 1389.495n 0.0v 1389.505n 3.3v 1399.495n 3.3v 1399.505n 3.3v 1409.495n 3.3v 1409.505n 0.0v 1419.495n 0.0v 1419.505n 0.0v 1429.495n 0.0v 1429.505n 0.0v 1439.495n 0.0v 1439.505n 0.0v 1449.495n 0.0v 1449.505n 0.0v 1459.495n 0.0v 1459.505n 3.3v 1469.495n 3.3v 1469.505n 0.0v 1479.495n 0.0v 1479.505n 3.3v 1489.495n 3.3v 1489.505n 0.0v 1499.495n 0.0v 1499.505n 0.0v 1509.495n 0.0v 1509.505n 0.0v 1519.495n 0.0v 1519.505n 3.3v 1529.495n 3.3v 1529.505n 0.0v 1539.495n 0.0v 1539.505n 0.0v 1549.495n 0.0v 1549.505n 0.0v 1559.495n 0.0v 1559.505n 0.0v 1569.495n 0.0v 1569.505n 3.3v 1579.495n 3.3v 1579.505n 0.0v 1589.495n 0.0v 1589.505n 0.0v 1599.495n 0.0v 1599.505n 0.0v 1609.495n 0.0v 1609.505n 3.3v 1619.495n 3.3v 1619.505n 3.3v 1629.495n 3.3v 1629.505n 0.0v 1639.495n 0.0v 1639.505n 3.3v 1649.495n 3.3v 1649.505n 0.0v 1659.495n 0.0v 1659.505n 3.3v 1669.495n 3.3v 1669.505n 0.0v 1679.495n 0.0v 1679.505n 0.0v 1689.495n 0.0v 1689.505n 0.0v 1699.495n 0.0v 1699.505n 0.0v 1709.495n 0.0v 1709.505n 0.0v 1719.495n 0.0v 1719.505n 0.0v 1729.495n 0.0v 1729.505n 0.0v 1739.495n 0.0v 1739.505n 3.3v 1749.495n 3.3v 1749.505n 0.0v 1759.495n 0.0v 1759.505n 0.0v 1769.495n 0.0v 1769.505n 0.0v 1779.495n 0.0v 1779.505n 0.0v 1789.495n 0.0v 1789.505n 0.0v 1799.495n 0.0v 1799.505n 0.0v 1809.495n 0.0v 1809.505n 3.3v 1819.495n 3.3v 1819.505n 3.3v 1829.495n 3.3v 1829.505n 3.3v 1839.495n 3.3v 1839.505n 0.0v 1849.495n 0.0v 1849.505n 3.3v 1859.495n 3.3v 1859.505n 0.0v 1869.495n 0.0v 1869.505n 0.0v 1879.495n 0.0v 1879.505n 0.0v 1889.495n 0.0v 1889.505n 3.3v 1899.495n 3.3v 1899.505n 3.3v 1909.495n 3.3v 1909.505n 0.0v 1919.495n 0.0v 1919.505n 0.0v 1929.495n 0.0v 1929.505n 0.0v 1939.495n 0.0v 1939.505n 0.0v 1949.495n 0.0v 1949.505n 3.3v 1959.495n 3.3v 1959.505n 3.3v 1969.495n 3.3v 1969.505n 3.3v 1979.495n 3.3v 1979.505n 0.0v 1989.495n 0.0v 1989.505n 3.3v 1999.495n 3.3v 1999.505n 0.0v 2009.495n 0.0v 2009.505n 0.0v 2019.495n 0.0v 2019.505n 0.0v 2029.495n 0.0v 2029.505n 3.3v 2039.495n 3.3v 2039.505n 0.0v 2049.495n 0.0v 2049.505n 3.3v )
* (time, data): [(0, 1), (10, 0), (20, 0), (30, 0), (40, 1), (50, 1), (60, 1), (70, 1), (80, 1), (90, 1), (100, 1), (110, 0), (120, 1), (130, 0), (140, 1), (150, 0), (160, 1), (170, 1), (180, 1), (190, 1), (200, 1), (210, 1), (220, 0), (230, 1), (240, 1), (250, 0), (260, 1), (270, 1), (280, 1), (290, 1), (300, 1), (310, 1), (320, 1), (330, 1), (340, 1), (350, 0), (360, 1), (370, 1), (380, 0), (390, 1), (400, 0), (410, 1), (420, 1), (430, 1), (440, 1), (450, 0), (460, 1), (470, 1), (480, 1), (490, 1), (500, 1), (510, 1), (520, 1), (530, 1), (540, 0), (550, 0), (560, 0), (570, 0), (580, 1), (590, 1), (600, 1), (610, 0), (620, 1), (630, 1), (640, 1), (650, 1), (660, 1), (670, 1), (680, 1), (690, 0), (700, 1), (710, 1), (720, 1), (730, 1), (740, 0), (750, 1), (760, 0), (770, 1), (780, 1), (790, 0), (800, 1), (810, 1), (820, 1), (830, 1), (840, 0), (850, 1), (860, 1), (870, 0), (880, 1), (890, 1), (900, 1), (910, 1), (920, 1), (930, 1), (940, 1), (950, 0), (960, 1), (970, 1), (980, 1), (990, 1), (1000, 1), (1010, 1), (1020, 0), (1030, 0), (1040, 1), (1050, 1), (1060, 1), (1070, 1), (1080, 1), (1090, 1), (1100, 0), (1110, 1), (1120, 1), (1130, 1), (1140, 1), (1150, 1), (1160, 0), (1170, 1), (1180, 0), (1190, 1), (1200, 1), (1210, 0), (1220, 0), (1230, 0), (1240, 1), (1250, 1), (1260, 1), (1270, 1), (1280, 1), (1290, 1), (1300, 1), (1310, 1), (1320, 0), (1330, 1), (1340, 1), (1350, 1), (1360, 1), (1370, 0), (1380, 1), (1390, 0), (1400, 0), (1410, 1), (1420, 1), (1430, 1), (1440, 1), (1450, 0), (1460, 1), (1470, 1), (1480, 1), (1490, 0), (1500, 0), (1510, 1), (1520, 0), (1530, 1), (1540, 1), (1550, 0), (1560, 1), (1570, 0), (1580, 0), (1590, 1), (1600, 1), (1610, 1), (1620, 0), (1630, 1), (1640, 1), (1650, 1), (1660, 1), (1670, 1), (1680, 1), (1690, 1), (1700, 1), (1710, 1), (1720, 1), (1730, 1), (1740, 0), (1750, 1), (1760, 1), (1770, 1), (1780, 1), (1790, 1), (1800, 1), (1810, 1), (1820, 1), (1830, 1), (1840, 1), (1850, 0), (1860, 1), (1870, 0), (1880, 1), (1890, 0), (1900, 1), (1910, 0), (1920, 0), (1930, 0), (1940, 1), (1950, 0), (1960, 0), (1970, 1), (1980, 1), (1990, 0), (2000, 1), (2010, 1), (2020, 1), (2030, 1), (2040, 0), (2050, 1)]
VWEB0 WEB0 0 PWL (0n 3.3v 9.495n 3.3v 9.505n 0.0v 19.495n 0.0v 19.505n 0.0v 29.495n 0.0v 29.505n 0.0v 39.495n 0.0v 39.505n 3.3v 49.495n 3.3v 49.505n 3.3v 59.495n 3.3v 59.505n 3.3v 69.495n 3.3v 69.505n 3.3v 79.495n 3.3v 79.505n 3.3v 89.495n 3.3v 89.505n 3.3v 99.495n 3.3v 99.505n 3.3v 109.495n 3.3v 109.505n 0.0v 119.495n 0.0v 119.505n 3.3v 129.495n 3.3v 129.505n 0.0v 139.495n 0.0v 139.505n 3.3v 149.495n 3.3v 149.505n 0.0v 159.495n 0.0v 159.505n 3.3v 169.495n 3.3v 169.505n 3.3v 179.495n 3.3v 179.505n 3.3v 189.495n 3.3v 189.505n 3.3v 199.495n 3.3v 199.505n 3.3v 209.495n 3.3v 209.505n 3.3v 219.495n 3.3v 219.505n 0.0v 229.495n 0.0v 229.505n 3.3v 239.495n 3.3v 239.505n 3.3v 249.495n 3.3v 249.505n 0.0v 259.495n 0.0v 259.505n 3.3v 269.495n 3.3v 269.505n 3.3v 279.495n 3.3v 279.505n 3.3v 289.495n 3.3v 289.505n 3.3v 299.495n 3.3v 299.505n 3.3v 309.495n 3.3v 309.505n 3.3v 319.495n 3.3v 319.505n 3.3v 329.495n 3.3v 329.505n 3.3v 339.495n 3.3v 339.505n 3.3v 349.495n 3.3v 349.505n 0.0v 359.495n 0.0v 359.505n 3.3v 369.495n 3.3v 369.505n 3.3v 379.495n 3.3v 379.505n 0.0v 389.495n 0.0v 389.505n 3.3v 399.495n 3.3v 399.505n 0.0v 409.495n 0.0v 409.505n 3.3v 419.495n 3.3v 419.505n 3.3v 429.495n 3.3v 429.505n 3.3v 439.495n 3.3v 439.505n 3.3v 449.495n 3.3v 449.505n 0.0v 459.495n 0.0v 459.505n 3.3v 469.495n 3.3v 469.505n 3.3v 479.495n 3.3v 479.505n 3.3v 489.495n 3.3v 489.505n 3.3v 499.495n 3.3v 499.505n 3.3v 509.495n 3.3v 509.505n 3.3v 519.495n 3.3v 519.505n 3.3v 529.495n 3.3v 529.505n 3.3v 539.495n 3.3v 539.505n 0.0v 549.495n 0.0v 549.505n 0.0v 559.495n 0.0v 559.505n 0.0v 569.495n 0.0v 569.505n 0.0v 579.495n 0.0v 579.505n 3.3v 589.495n 3.3v 589.505n 3.3v 599.495n 3.3v 599.505n 3.3v 609.495n 3.3v 609.505n 0.0v 619.495n 0.0v 619.505n 3.3v 629.495n 3.3v 629.505n 3.3v 639.495n 3.3v 639.505n 3.3v 649.495n 3.3v 649.505n 3.3v 659.495n 3.3v 659.505n 3.3v 669.495n 3.3v 669.505n 3.3v 679.495n 3.3v 679.505n 3.3v 689.495n 3.3v 689.505n 0.0v 699.495n 0.0v 699.505n 3.3v 709.495n 3.3v 709.505n 3.3v 719.495n 3.3v 719.505n 3.3v 729.495n 3.3v 729.505n 3.3v 739.495n 3.3v 739.505n 0.0v 749.495n 0.0v 749.505n 3.3v 759.495n 3.3v 759.505n 0.0v 769.495n 0.0v 769.505n 3.3v 779.495n 3.3v 779.505n 3.3v 789.495n 3.3v 789.505n 0.0v 799.495n 0.0v 799.505n 3.3v 809.495n 3.3v 809.505n 3.3v 819.495n 3.3v 819.505n 3.3v 829.495n 3.3v 829.505n 3.3v 839.495n 3.3v 839.505n 0.0v 849.495n 0.0v 849.505n 3.3v 859.495n 3.3v 859.505n 3.3v 869.495n 3.3v 869.505n 0.0v 879.495n 0.0v 879.505n 3.3v 889.495n 3.3v 889.505n 3.3v 899.495n 3.3v 899.505n 3.3v 909.495n 3.3v 909.505n 3.3v 919.495n 3.3v 919.505n 3.3v 929.495n 3.3v 929.505n 3.3v 939.495n 3.3v 939.505n 3.3v 949.495n 3.3v 949.505n 0.0v 959.495n 0.0v 959.505n 3.3v 969.495n 3.3v 969.505n 3.3v 979.495n 3.3v 979.505n 3.3v 989.495n 3.3v 989.505n 3.3v 999.495n 3.3v 999.505n 3.3v 1009.495n 3.3v 1009.505n 3.3v 1019.495n 3.3v 1019.505n 0.0v 1029.495n 0.0v 1029.505n 0.0v 1039.495n 0.0v 1039.505n 3.3v 1049.495n 3.3v 1049.505n 3.3v 1059.495n 3.3v 1059.505n 3.3v 1069.495n 3.3v 1069.505n 3.3v 1079.495n 3.3v 1079.505n 3.3v 1089.495n 3.3v 1089.505n 3.3v 1099.495n 3.3v 1099.505n 0.0v 1109.495n 0.0v 1109.505n 3.3v 1119.495n 3.3v 1119.505n 3.3v 1129.495n 3.3v 1129.505n 3.3v 1139.495n 3.3v 1139.505n 3.3v 1149.495n 3.3v 1149.505n 3.3v 1159.495n 3.3v 1159.505n 0.0v 1169.495n 0.0v 1169.505n 3.3v 1179.495n 3.3v 1179.505n 0.0v 1189.495n 0.0v 1189.505n 3.3v 1199.495n 3.3v 1199.505n 3.3v 1209.495n 3.3v 1209.505n 0.0v 1219.495n 0.0v 1219.505n 0.0v 1229.495n 0.0v 1229.505n 0.0v 1239.495n 0.0v 1239.505n 3.3v 1249.495n 3.3v 1249.505n 3.3v 1259.495n 3.3v 1259.505n 3.3v 1269.495n 3.3v 1269.505n 3.3v 1279.495n 3.3v 1279.505n 3.3v 1289.495n 3.3v 1289.505n 3.3v 1299.495n 3.3v 1299.505n 3.3v 1309.495n 3.3v 1309.505n 3.3v 1319.495n 3.3v 1319.505n 0.0v 1329.495n 0.0v 1329.505n 3.3v 1339.495n 3.3v 1339.505n 3.3v 1349.495n 3.3v 1349.505n 3.3v 1359.495n 3.3v 1359.505n 3.3v 1369.495n 3.3v 1369.505n 0.0v 1379.495n 0.0v 1379.505n 3.3v 1389.495n 3.3v 1389.505n 0.0v 1399.495n 0.0v 1399.505n 0.0v 1409.495n 0.0v 1409.505n 3.3v 1419.495n 3.3v 1419.505n 3.3v 1429.495n 3.3v 1429.505n 3.3v 1439.495n 3.3v 1439.505n 3.3v 1449.495n 3.3v 1449.505n 0.0v 1459.495n 0.0v 1459.505n 3.3v 1469.495n 3.3v 1469.505n 3.3v 1479.495n 3.3v 1479.505n 3.3v 1489.495n 3.3v 1489.505n 0.0v 1499.495n 0.0v 1499.505n 0.0v 1509.495n 0.0v 1509.505n 3.3v 1519.495n 3.3v 1519.505n 0.0v 1529.495n 0.0v 1529.505n 3.3v 1539.495n 3.3v 1539.505n 3.3v 1549.495n 3.3v 1549.505n 0.0v 1559.495n 0.0v 1559.505n 3.3v 1569.495n 3.3v 1569.505n 0.0v 1579.495n 0.0v 1579.505n 0.0v 1589.495n 0.0v 1589.505n 3.3v 1599.495n 3.3v 1599.505n 3.3v 1609.495n 3.3v 1609.505n 3.3v 1619.495n 3.3v 1619.505n 0.0v 1629.495n 0.0v 1629.505n 3.3v 1639.495n 3.3v 1639.505n 3.3v 1649.495n 3.3v 1649.505n 3.3v 1659.495n 3.3v 1659.505n 3.3v 1669.495n 3.3v 1669.505n 3.3v 1679.495n 3.3v 1679.505n 3.3v 1689.495n 3.3v 1689.505n 3.3v 1699.495n 3.3v 1699.505n 3.3v 1709.495n 3.3v 1709.505n 3.3v 1719.495n 3.3v 1719.505n 3.3v 1729.495n 3.3v 1729.505n 3.3v 1739.495n 3.3v 1739.505n 0.0v 1749.495n 0.0v 1749.505n 3.3v 1759.495n 3.3v 1759.505n 3.3v 1769.495n 3.3v 1769.505n 3.3v 1779.495n 3.3v 1779.505n 3.3v 1789.495n 3.3v 1789.505n 3.3v 1799.495n 3.3v 1799.505n 3.3v 1809.495n 3.3v 1809.505n 3.3v 1819.495n 3.3v 1819.505n 3.3v 1829.495n 3.3v 1829.505n 3.3v 1839.495n 3.3v 1839.505n 3.3v 1849.495n 3.3v 1849.505n 0.0v 1859.495n 0.0v 1859.505n 3.3v 1869.495n 3.3v 1869.505n 0.0v 1879.495n 0.0v 1879.505n 3.3v 1889.495n 3.3v 1889.505n 0.0v 1899.495n 0.0v 1899.505n 3.3v 1909.495n 3.3v 1909.505n 0.0v 1919.495n 0.0v 1919.505n 0.0v 1929.495n 0.0v 1929.505n 0.0v 1939.495n 0.0v 1939.505n 3.3v 1949.495n 3.3v 1949.505n 0.0v 1959.495n 0.0v 1959.505n 0.0v 1969.495n 0.0v 1969.505n 3.3v 1979.495n 3.3v 1979.505n 3.3v 1989.495n 3.3v 1989.505n 0.0v 1999.495n 0.0v 1999.505n 3.3v 2009.495n 3.3v 2009.505n 3.3v 2019.495n 3.3v 2019.505n 3.3v 2029.495n 3.3v 2029.505n 3.3v 2039.495n 3.3v 2039.505n 0.0v 2049.495n 0.0v 2049.505n 3.3v )
* (time, data): [(0, 1), (10, 0), (20, 0), (30, 0), (40, 1), (50, 1), (60, 1), (70, 0), (80, 1), (90, 1), (100, 1), (110, 0), (120, 1), (130, 1), (140, 1), (150, 1), (160, 1), (170, 1), (180, 1), (190, 1), (200, 0), (210, 1), (220, 1), (230, 1), (240, 1), (250, 1), (260, 1), (270, 1), (280, 0), (290, 1), (300, 0), (310, 1), (320, 1), (330, 1), (340, 0), (350, 0), (360, 1), (370, 0), (380, 1), (390, 0), (400, 1), (410, 1), (420, 1), (430, 0), (440, 1), (450, 1), (460, 1), (470, 1), (480, 0), (490, 1), (500, 1), (510, 0), (520, 1), (530, 1), (540, 1), (550, 1), (560, 1), (570, 0), (580, 1), (590, 1), (600, 1), (610, 1), (620, 1), (630, 1), (640, 0), (650, 0), (660, 0), (670, 0), (680, 1), (690, 1), (700, 1), (710, 1), (720, 0), (730, 1), (740, 0), (750, 1), (760, 1), (770, 1), (780, 1), (790, 1), (800, 1), (810, 1), (820, 0), (830, 1), (840, 1), (850, 0), (860, 1), (870, 1), (880, 1), (890, 1), (900, 1), (910, 1), (920, 1), (930, 1), (940, 1), (950, 1), (960, 1), (970, 1), (980, 1), (990, 1), (1000, 0), (1010, 1), (1020, 1), (1030, 1), (1040, 1), (1050, 1), (1060, 0), (1070, 1), (1080, 1), (1090, 1), (1100, 1), (1110, 1), (1120, 1), (1130, 1), (1140, 0), (1150, 0), (1160, 0), (1170, 1), (1180, 0), (1190, 1), (1200, 1), (1210, 1), (1220, 1), (1230, 0), (1240, 1), (1250, 1), (1260, 1), (1270, 1), (1280, 1), (1290, 1), (1300, 0), (1310, 1), (1320, 1), (1330, 1), (1340, 1), (1350, 0), (1360, 0), (1370, 1), (1380, 0), (1390, 1), (1400, 1), (1410, 1), (1420, 0), (1430, 1), (1440, 1), (1450, 1), (1460, 1), (1470, 1), (1480, 1), (1490, 0), (1500, 0), (1510, 1), (1520, 1), (1530, 0), (1540, 1), (1550, 1), (1560, 0), (1570, 1), (1580, 0), (1590, 1), (1600, 1), (1610, 1), (1620, 1), (1630, 0), (1640, 1), (1650, 1), (1660, 1), (1670, 0), (1680, 1), (1690, 0), (1700, 0), (1710, 1), (1720, 1), (1730, 1), (1740, 1), (1750, 1), (1760, 1), (1770, 1), (1780, 1), (1790, 0), (1800, 1), (1810, 1), (1820, 1), (1830, 1), (1840, 1), (1850, 1), (1860, 0), (1870, 1), (1880, 1), (1890, 1), (1900, 1), (1910, 1), (1920, 1), (1930, 0), (1940, 0), (1950, 1), (1960, 1), (1970, 1), (1980, 1), (1990, 1), (2000, 1), (2010, 1), (2020, 1), (2030, 1), (2040, 0), (2050, 1)]
VWEB1 WEB1 0 PWL (0n 3.3v 9.495n 3.3v 9.505n 0.0v 19.495n 0.0v 19.505n 0.0v 29.495n 0.0v 29.505n 0.0v 39.495n 0.0v 39.505n 3.3v 49.495n 3.3v 49.505n 3.3v 59.495n 3.3v 59.505n 3.3v 69.495n 3.3v 69.505n 0.0v 79.495n 0.0v 79.505n 3.3v 89.495n 3.3v 89.505n 3.3v 99.495n 3.3v 99.505n 3.3v 109.495n 3.3v 109.505n 0.0v 119.495n 0.0v 119.505n 3.3v 129.495n 3.3v 129.505n 3.3v 139.495n 3.3v 139.505n 3.3v 149.495n 3.3v 149.505n 3.3v 159.495n 3.3v 159.505n 3.3v 169.495n 3.3v 169.505n 3.3v 179.495n 3.3v 179.505n 3.3v 189.495n 3.3v 189.505n 3.3v 199.495n 3.3v 199.505n 0.0v 209.495n 0.0v 209.505n 3.3v 219.495n 3.3v 219.505n 3.3v 229.495n 3.3v 229.505n 3.3v 239.495n 3.3v 239.505n 3.3v 249.495n 3.3v 249.505n 3.3v 259.495n 3.3v 259.505n 3.3v 269.495n 3.3v 269.505n 3.3v 279.495n 3.3v 279.505n 0.0v 289.495n 0.0v 289.505n 3.3v 299.495n 3.3v 299.505n 0.0v 309.495n 0.0v 309.505n 3.3v 319.495n 3.3v 319.505n 3.3v 329.495n 3.3v 329.505n 3.3v 339.495n 3.3v 339.505n 0.0v 349.495n 0.0v 349.505n 0.0v 359.495n 0.0v 359.505n 3.3v 369.495n 3.3v 369.505n 0.0v 379.495n 0.0v 379.505n 3.3v 389.495n 3.3v 389.505n 0.0v 399.495n 0.0v 399.505n 3.3v 409.495n 3.3v 409.505n 3.3v 419.495n 3.3v 419.505n 3.3v 429.495n 3.3v 429.505n 0.0v 439.495n 0.0v 439.505n 3.3v 449.495n 3.3v 449.505n 3.3v 459.495n 3.3v 459.505n 3.3v 469.495n 3.3v 469.505n 3.3v 479.495n 3.3v 479.505n 0.0v 489.495n 0.0v 489.505n 3.3v 499.495n 3.3v 499.505n 3.3v 509.495n 3.3v 509.505n 0.0v 519.495n 0.0v 519.505n 3.3v 529.495n 3.3v 529.505n 3.3v 539.495n 3.3v 539.505n 3.3v 549.495n 3.3v 549.505n 3.3v 559.495n 3.3v 559.505n 3.3v 569.495n 3.3v 569.505n 0.0v 579.495n 0.0v 579.505n 3.3v 589.495n 3.3v 589.505n 3.3v 599.495n 3.3v 599.505n 3.3v 609.495n 3.3v 609.505n 3.3v 619.495n 3.3v 619.505n 3.3v 629.495n 3.3v 629.505n 3.3v 639.495n 3.3v 639.505n 0.0v 649.495n 0.0v 649.505n 0.0v 659.495n 0.0v 659.505n 0.0v 669.495n 0.0v 669.505n 0.0v 679.495n 0.0v 679.505n 3.3v 689.495n 3.3v 689.505n 3.3v 699.495n 3.3v 699.505n 3.3v 709.495n 3.3v 709.505n 3.3v 719.495n 3.3v 719.505n 0.0v 729.495n 0.0v 729.505n 3.3v 739.495n 3.3v 739.505n 0.0v 749.495n 0.0v 749.505n 3.3v 759.495n 3.3v 759.505n 3.3v 769.495n 3.3v 769.505n 3.3v 779.495n 3.3v 779.505n 3.3v 789.495n 3.3v 789.505n 3.3v 799.495n 3.3v 799.505n 3.3v 809.495n 3.3v 809.505n 3.3v 819.495n 3.3v 819.505n 0.0v 829.495n 0.0v 829.505n 3.3v 839.495n 3.3v 839.505n 3.3v 849.495n 3.3v 849.505n 0.0v 859.495n 0.0v 859.505n 3.3v 869.495n 3.3v 869.505n 3.3v 879.495n 3.3v 879.505n 3.3v 889.495n 3.3v 889.505n 3.3v 899.495n 3.3v 899.505n 3.3v 909.495n 3.3v 909.505n 3.3v 919.495n 3.3v 919.505n 3.3v 929.495n 3.3v 929.505n 3.3v 939.495n 3.3v 939.505n 3.3v 949.495n 3.3v 949.505n 3.3v 959.495n 3.3v 959.505n 3.3v 969.495n 3.3v 969.505n 3.3v 979.495n 3.3v 979.505n 3.3v 989.495n 3.3v 989.505n 3.3v 999.495n 3.3v 999.505n 0.0v 1009.495n 0.0v 1009.505n 3.3v 1019.495n 3.3v 1019.505n 3.3v 1029.495n 3.3v 1029.505n 3.3v 1039.495n 3.3v 1039.505n 3.3v 1049.495n 3.3v 1049.505n 3.3v 1059.495n 3.3v 1059.505n 0.0v 1069.495n 0.0v 1069.505n 3.3v 1079.495n 3.3v 1079.505n 3.3v 1089.495n 3.3v 1089.505n 3.3v 1099.495n 3.3v 1099.505n 3.3v 1109.495n 3.3v 1109.505n 3.3v 1119.495n 3.3v 1119.505n 3.3v 1129.495n 3.3v 1129.505n 3.3v 1139.495n 3.3v 1139.505n 0.0v 1149.495n 0.0v 1149.505n 0.0v 1159.495n 0.0v 1159.505n 0.0v 1169.495n 0.0v 1169.505n 3.3v 1179.495n 3.3v 1179.505n 0.0v 1189.495n 0.0v 1189.505n 3.3v 1199.495n 3.3v 1199.505n 3.3v 1209.495n 3.3v 1209.505n 3.3v 1219.495n 3.3v 1219.505n 3.3v 1229.495n 3.3v 1229.505n 0.0v 1239.495n 0.0v 1239.505n 3.3v 1249.495n 3.3v 1249.505n 3.3v 1259.495n 3.3v 1259.505n 3.3v 1269.495n 3.3v 1269.505n 3.3v 1279.495n 3.3v 1279.505n 3.3v 1289.495n 3.3v 1289.505n 3.3v 1299.495n 3.3v 1299.505n 0.0v 1309.495n 0.0v 1309.505n 3.3v 1319.495n 3.3v 1319.505n 3.3v 1329.495n 3.3v 1329.505n 3.3v 1339.495n 3.3v 1339.505n 3.3v 1349.495n 3.3v 1349.505n 0.0v 1359.495n 0.0v 1359.505n 0.0v 1369.495n 0.0v 1369.505n 3.3v 1379.495n 3.3v 1379.505n 0.0v 1389.495n 0.0v 1389.505n 3.3v 1399.495n 3.3v 1399.505n 3.3v 1409.495n 3.3v 1409.505n 3.3v 1419.495n 3.3v 1419.505n 0.0v 1429.495n 0.0v 1429.505n 3.3v 1439.495n 3.3v 1439.505n 3.3v 1449.495n 3.3v 1449.505n 3.3v 1459.495n 3.3v 1459.505n 3.3v 1469.495n 3.3v 1469.505n 3.3v 1479.495n 3.3v 1479.505n 3.3v 1489.495n 3.3v 1489.505n 0.0v 1499.495n 0.0v 1499.505n 0.0v 1509.495n 0.0v 1509.505n 3.3v 1519.495n 3.3v 1519.505n 3.3v 1529.495n 3.3v 1529.505n 0.0v 1539.495n 0.0v 1539.505n 3.3v 1549.495n 3.3v 1549.505n 3.3v 1559.495n 3.3v 1559.505n 0.0v 1569.495n 0.0v 1569.505n 3.3v 1579.495n 3.3v 1579.505n 0.0v 1589.495n 0.0v 1589.505n 3.3v 1599.495n 3.3v 1599.505n 3.3v 1609.495n 3.3v 1609.505n 3.3v 1619.495n 3.3v 1619.505n 3.3v 1629.495n 3.3v 1629.505n 0.0v 1639.495n 0.0v 1639.505n 3.3v 1649.495n 3.3v 1649.505n 3.3v 1659.495n 3.3v 1659.505n 3.3v 1669.495n 3.3v 1669.505n 0.0v 1679.495n 0.0v 1679.505n 3.3v 1689.495n 3.3v 1689.505n 0.0v 1699.495n 0.0v 1699.505n 0.0v 1709.495n 0.0v 1709.505n 3.3v 1719.495n 3.3v 1719.505n 3.3v 1729.495n 3.3v 1729.505n 3.3v 1739.495n 3.3v 1739.505n 3.3v 1749.495n 3.3v 1749.505n 3.3v 1759.495n 3.3v 1759.505n 3.3v 1769.495n 3.3v 1769.505n 3.3v 1779.495n 3.3v 1779.505n 3.3v 1789.495n 3.3v 1789.505n 0.0v 1799.495n 0.0v 1799.505n 3.3v 1809.495n 3.3v 1809.505n 3.3v 1819.495n 3.3v 1819.505n 3.3v 1829.495n 3.3v 1829.505n 3.3v 1839.495n 3.3v 1839.505n 3.3v 1849.495n 3.3v 1849.505n 3.3v 1859.495n 3.3v 1859.505n 0.0v 1869.495n 0.0v 1869.505n 3.3v 1879.495n 3.3v 1879.505n 3.3v 1889.495n 3.3v 1889.505n 3.3v 1899.495n 3.3v 1899.505n 3.3v 1909.495n 3.3v 1909.505n 3.3v 1919.495n 3.3v 1919.505n 3.3v 1929.495n 3.3v 1929.505n 0.0v 1939.495n 0.0v 1939.505n 0.0v 1949.495n 0.0v 1949.505n 3.3v 1959.495n 3.3v 1959.505n 3.3v 1969.495n 3.3v 1969.505n 3.3v 1979.495n 3.3v 1979.505n 3.3v 1989.495n 3.3v 1989.505n 3.3v 1999.495n 3.3v 1999.505n 3.3v 2009.495n 3.3v 2009.505n 3.3v 2019.495n 3.3v 2019.505n 3.3v 2029.495n 3.3v 2029.505n 3.3v 2039.495n 3.3v 2039.505n 0.0v 2049.495n 0.0v 2049.505n 3.3v )
* PULSE: period=10
Vclk0 clk0 0 PULSE (0 3.3 9.995n 0.01n 0.01n 4.99n 10n)
* PULSE: period=10
Vclk1 clk1 0 PULSE (0 3.3 9.995n 0.01n 0.01n 4.99n 10n)

 * Generation of dout measurements
* CHECK dout0_0 vdout0_0ck4 = 3.3 time = 50
* CHECK dout0_1 vdout0_1ck4 = 0 time = 50
* CHECK dout1_0 vdout1_0ck4 = 0 time = 50
* CHECK dout1_1 vdout1_1ck4 = 3.3 time = 50
* CHECK dout0_0 vdout0_0ck6 = 3.3 time = 70
* CHECK dout0_1 vdout0_1ck6 = 0 time = 70
* CHECK dout1_0 vdout1_0ck6 = 3.3 time = 70
* CHECK dout1_1 vdout1_1ck6 = 0 time = 70
* CHECK dout0_0 vdout0_0ck8 = 3.3 time = 90
* CHECK dout0_1 vdout0_1ck8 = 0 time = 90
* CHECK dout1_0 vdout1_0ck8 = 0 time = 90
* CHECK dout1_1 vdout1_1ck8 = 3.3 time = 90
* CHECK dout1_0 vdout1_0ck9 = 3.3 time = 100
* CHECK dout1_1 vdout1_1ck9 = 0 time = 100
* CHECK dout0_0 vdout0_0ck10 = 3.3 time = 110
* CHECK dout0_1 vdout0_1ck10 = 0 time = 110
* CHECK dout1_0 vdout1_0ck10 = 3.3 time = 110
* CHECK dout1_1 vdout1_1ck10 = 0 time = 110
* CHECK dout0_0 vdout0_0ck12 = 3.3 time = 130
* CHECK dout0_1 vdout0_1ck12 = 3.3 time = 130
* CHECK dout1_0 vdout1_0ck12 = 3.3 time = 130
* CHECK dout1_1 vdout1_1ck12 = 3.3 time = 130
* CHECK dout1_0 vdout1_0ck13 = 3.3 time = 140
* CHECK dout1_1 vdout1_1ck13 = 3.3 time = 140
* CHECK dout1_0 vdout1_0ck15 = 3.3 time = 160
* CHECK dout1_1 vdout1_1ck15 = 3.3 time = 160
* CHECK dout0_0 vdout0_0ck17 = 3.3 time = 180
* CHECK dout0_1 vdout0_1ck17 = 3.3 time = 180
* CHECK dout1_0 vdout1_0ck18 = 3.3 time = 190
* CHECK dout1_1 vdout1_1ck18 = 3.3 time = 190
* CHECK dout0_0 vdout0_0ck21 = 3.3 time = 220
* CHECK dout0_1 vdout0_1ck21 = 0 time = 220
* CHECK dout0_0 vdout0_0ck23 = 3.3 time = 240
* CHECK dout0_1 vdout0_1ck23 = 0 time = 240
* CHECK dout1_0 vdout1_0ck23 = 3.3 time = 240
* CHECK dout1_1 vdout1_1ck23 = 0 time = 240
* CHECK dout0_0 vdout0_0ck24 = 3.3 time = 250
* CHECK dout0_1 vdout0_1ck24 = 3.3 time = 250
* CHECK dout1_0 vdout1_0ck26 = 3.3 time = 270
* CHECK dout1_1 vdout1_1ck26 = 3.3 time = 270
* CHECK dout0_0 vdout0_0ck27 = 0 time = 280
* CHECK dout0_1 vdout0_1ck27 = 3.3 time = 280
* CHECK dout0_0 vdout0_0ck29 = 3.3 time = 300
* CHECK dout0_1 vdout0_1ck29 = 0 time = 300
* CHECK dout1_0 vdout1_0ck29 = 0 time = 300
* CHECK dout1_1 vdout1_1ck29 = 3.3 time = 300
* CHECK dout0_0 vdout0_0ck30 = 0 time = 310
* CHECK dout0_1 vdout0_1ck30 = 3.3 time = 310
* CHECK dout1_0 vdout1_0ck31 = 0 time = 320
* CHECK dout1_1 vdout1_1ck31 = 3.3 time = 320
* CHECK dout1_0 vdout1_0ck32 = 0 time = 330
* CHECK dout1_1 vdout1_1ck32 = 3.3 time = 330
* CHECK dout0_0 vdout0_0ck34 = 0 time = 350
* CHECK dout0_1 vdout0_1ck34 = 3.3 time = 350
* CHECK dout0_0 vdout0_0ck36 = 0 time = 370
* CHECK dout0_1 vdout0_1ck36 = 3.3 time = 370
* CHECK dout0_0 vdout0_0ck37 = 0 time = 380
* CHECK dout0_1 vdout0_1ck37 = 3.3 time = 380
* CHECK dout0_0 vdout0_0ck39 = 3.3 time = 400
* CHECK dout0_1 vdout0_1ck39 = 3.3 time = 400
* CHECK dout0_0 vdout0_0ck41 = 0 time = 420
* CHECK dout0_1 vdout0_1ck41 = 3.3 time = 420
* CHECK dout0_0 vdout0_0ck42 = 0 time = 430
* CHECK dout0_1 vdout0_1ck42 = 3.3 time = 430
* CHECK dout1_0 vdout1_0ck42 = 0 time = 430
* CHECK dout1_1 vdout1_1ck42 = 3.3 time = 430
* CHECK dout0_0 vdout0_0ck43 = 0 time = 440
* CHECK dout0_1 vdout0_1ck43 = 3.3 time = 440
* CHECK dout1_0 vdout1_0ck44 = 3.3 time = 450
* CHECK dout1_1 vdout1_1ck44 = 0 time = 450
* CHECK dout0_0 vdout0_0ck46 = 3.3 time = 470
* CHECK dout0_1 vdout0_1ck46 = 0 time = 470
* CHECK dout1_0 vdout1_0ck46 = 3.3 time = 470
* CHECK dout1_1 vdout1_1ck46 = 3.3 time = 470
* CHECK dout0_0 vdout0_0ck47 = 3.3 time = 480
* CHECK dout0_1 vdout0_1ck47 = 0 time = 480
* CHECK dout1_0 vdout1_0ck47 = 3.3 time = 480
* CHECK dout1_1 vdout1_1ck47 = 3.3 time = 480
* CHECK dout0_0 vdout0_0ck48 = 3.3 time = 490
* CHECK dout0_1 vdout0_1ck48 = 3.3 time = 490
* CHECK dout0_0 vdout0_0ck49 = 3.3 time = 500
* CHECK dout0_1 vdout0_1ck49 = 0 time = 500
* CHECK dout1_0 vdout1_0ck49 = 3.3 time = 500
* CHECK dout1_1 vdout1_1ck49 = 0 time = 500
* CHECK dout1_0 vdout1_0ck50 = 3.3 time = 510
* CHECK dout1_1 vdout1_1ck50 = 0 time = 510
* CHECK dout0_0 vdout0_0ck52 = 3.3 time = 530
* CHECK dout0_1 vdout0_1ck52 = 3.3 time = 530
* CHECK dout0_0 vdout0_0ck58 = 0 time = 590
* CHECK dout0_1 vdout0_1ck58 = 3.3 time = 590
* CHECK dout0_0 vdout0_0ck59 = 0 time = 600
* CHECK dout0_1 vdout0_1ck59 = 3.3 time = 600
* CHECK dout0_0 vdout0_0ck60 = 0 time = 610
* CHECK dout0_1 vdout0_1ck60 = 3.3 time = 610
* CHECK dout1_0 vdout1_0ck61 = 0 time = 620
* CHECK dout1_1 vdout1_1ck61 = 3.3 time = 620
* CHECK dout0_0 vdout0_0ck62 = 0 time = 630
* CHECK dout0_1 vdout0_1ck62 = 3.3 time = 630
* CHECK dout1_0 vdout1_0ck62 = 0 time = 630
* CHECK dout1_1 vdout1_1ck62 = 3.3 time = 630
* CHECK dout0_0 vdout0_0ck63 = 0 time = 640
* CHECK dout0_1 vdout0_1ck63 = 3.3 time = 640
* CHECK dout1_0 vdout1_0ck63 = 0 time = 640
* CHECK dout1_1 vdout1_1ck63 = 3.3 time = 640
* CHECK dout0_0 vdout0_0ck64 = 0 time = 650
* CHECK dout0_1 vdout0_1ck64 = 3.3 time = 650
* CHECK dout0_0 vdout0_0ck65 = 0 time = 660
* CHECK dout0_1 vdout0_1ck65 = 3.3 time = 660
* CHECK dout0_0 vdout0_0ck66 = 0 time = 670
* CHECK dout0_1 vdout0_1ck66 = 3.3 time = 670
* CHECK dout0_0 vdout0_0ck67 = 0 time = 680
* CHECK dout0_1 vdout0_1ck67 = 3.3 time = 680
* CHECK dout0_0 vdout0_0ck68 = 0 time = 690
* CHECK dout0_1 vdout0_1ck68 = 3.3 time = 690
* CHECK dout1_0 vdout1_0ck70 = 0 time = 710
* CHECK dout1_1 vdout1_1ck70 = 3.3 time = 710
* CHECK dout0_0 vdout0_0ck71 = 0 time = 720
* CHECK dout0_1 vdout0_1ck71 = 3.3 time = 720
* CHECK dout0_0 vdout0_0ck72 = 0 time = 730
* CHECK dout0_1 vdout0_1ck72 = 3.3 time = 730
* CHECK dout0_0 vdout0_0ck73 = 0 time = 740
* CHECK dout0_1 vdout0_1ck73 = 3.3 time = 740
* CHECK dout0_0 vdout0_0ck75 = 0 time = 760
* CHECK dout0_1 vdout0_1ck75 = 3.3 time = 760
* CHECK dout0_0 vdout0_0ck77 = 0 time = 780
* CHECK dout0_1 vdout0_1ck77 = 3.3 time = 780
* CHECK dout0_0 vdout0_0ck78 = 0 time = 790
* CHECK dout0_1 vdout0_1ck78 = 3.3 time = 790
* CHECK dout1_0 vdout1_0ck78 = 0 time = 790
* CHECK dout1_1 vdout1_1ck78 = 3.3 time = 790
* CHECK dout1_0 vdout1_0ck79 = 3.3 time = 800
* CHECK dout1_1 vdout1_1ck79 = 0 time = 800
* CHECK dout0_0 vdout0_0ck80 = 0 time = 810
* CHECK dout0_1 vdout0_1ck80 = 3.3 time = 810
* CHECK dout1_0 vdout1_0ck80 = 3.3 time = 810
* CHECK dout1_1 vdout1_1ck80 = 0 time = 810
* CHECK dout0_0 vdout0_0ck81 = 0 time = 820
* CHECK dout0_1 vdout0_1ck81 = 3.3 time = 820
* CHECK dout1_0 vdout1_0ck81 = 0 time = 820
* CHECK dout1_1 vdout1_1ck81 = 3.3 time = 820
* CHECK dout0_0 vdout0_0ck82 = 3.3 time = 830
* CHECK dout0_1 vdout0_1ck82 = 0 time = 830
* CHECK dout0_0 vdout0_0ck83 = 0 time = 840
* CHECK dout0_1 vdout0_1ck83 = 3.3 time = 840
* CHECK dout1_0 vdout1_0ck84 = 0 time = 850
* CHECK dout1_1 vdout1_1ck84 = 3.3 time = 850
* CHECK dout0_0 vdout0_0ck85 = 3.3 time = 860
* CHECK dout0_1 vdout0_1ck85 = 3.3 time = 860
* CHECK dout1_0 vdout1_0ck86 = 3.3 time = 870
* CHECK dout1_1 vdout1_1ck86 = 3.3 time = 870
* CHECK dout0_0 vdout0_0ck88 = 3.3 time = 890
* CHECK dout0_1 vdout0_1ck88 = 3.3 time = 890
* CHECK dout1_0 vdout1_0ck88 = 3.3 time = 890
* CHECK dout1_1 vdout1_1ck88 = 3.3 time = 890
* CHECK dout0_0 vdout0_0ck89 = 3.3 time = 900
* CHECK dout0_1 vdout0_1ck89 = 3.3 time = 900
* CHECK dout1_0 vdout1_0ck90 = 3.3 time = 910
* CHECK dout1_1 vdout1_1ck90 = 3.3 time = 910
* CHECK dout0_0 vdout0_0ck91 = 3.3 time = 920
* CHECK dout0_1 vdout0_1ck91 = 3.3 time = 920
* CHECK dout1_0 vdout1_0ck91 = 3.3 time = 920
* CHECK dout1_1 vdout1_1ck91 = 3.3 time = 920
* CHECK dout0_0 vdout0_0ck92 = 3.3 time = 930
* CHECK dout0_1 vdout0_1ck92 = 3.3 time = 930
* CHECK dout1_0 vdout1_0ck92 = 3.3 time = 930
* CHECK dout1_1 vdout1_1ck92 = 3.3 time = 930
* CHECK dout1_0 vdout1_0ck94 = 3.3 time = 950
* CHECK dout1_1 vdout1_1ck94 = 3.3 time = 950
* CHECK dout1_0 vdout1_0ck95 = 3.3 time = 960
* CHECK dout1_1 vdout1_1ck95 = 3.3 time = 960
* CHECK dout1_0 vdout1_0ck97 = 3.3 time = 980
* CHECK dout1_1 vdout1_1ck97 = 3.3 time = 980
* CHECK dout1_0 vdout1_0ck98 = 3.3 time = 990
* CHECK dout1_1 vdout1_1ck98 = 3.3 time = 990
* CHECK dout0_0 vdout0_0ck101 = 3.3 time = 1020
* CHECK dout0_1 vdout0_1ck101 = 0 time = 1020
* CHECK dout1_0 vdout1_0ck101 = 3.3 time = 1020
* CHECK dout1_1 vdout1_1ck101 = 0 time = 1020
* CHECK dout1_0 vdout1_0ck103 = 3.3 time = 1040
* CHECK dout1_1 vdout1_1ck103 = 3.3 time = 1040
* CHECK dout0_0 vdout0_0ck104 = 3.3 time = 1050
* CHECK dout0_1 vdout0_1ck104 = 3.3 time = 1050
* CHECK dout1_0 vdout1_0ck104 = 3.3 time = 1050
* CHECK dout1_1 vdout1_1ck104 = 3.3 time = 1050
* CHECK dout0_0 vdout0_0ck105 = 3.3 time = 1060
* CHECK dout0_1 vdout0_1ck105 = 3.3 time = 1060
* CHECK dout0_0 vdout0_0ck107 = 3.3 time = 1080
* CHECK dout0_1 vdout0_1ck107 = 3.3 time = 1080
* CHECK dout0_0 vdout0_0ck108 = 3.3 time = 1090
* CHECK dout0_1 vdout0_1ck108 = 3.3 time = 1090
* CHECK dout1_0 vdout1_0ck108 = 3.3 time = 1090
* CHECK dout1_1 vdout1_1ck108 = 3.3 time = 1090
* CHECK dout0_0 vdout0_0ck109 = 3.3 time = 1100
* CHECK dout0_1 vdout0_1ck109 = 3.3 time = 1100
* CHECK dout1_0 vdout1_0ck109 = 3.3 time = 1100
* CHECK dout1_1 vdout1_1ck109 = 3.3 time = 1100
* CHECK dout0_0 vdout0_0ck111 = 3.3 time = 1120
* CHECK dout0_1 vdout0_1ck111 = 3.3 time = 1120
* CHECK dout1_0 vdout1_0ck112 = 3.3 time = 1130
* CHECK dout1_1 vdout1_1ck112 = 3.3 time = 1130
* CHECK dout1_0 vdout1_0ck113 = 3.3 time = 1140
* CHECK dout1_1 vdout1_1ck113 = 3.3 time = 1140
* CHECK dout0_0 vdout0_0ck115 = 3.3 time = 1160
* CHECK dout0_1 vdout0_1ck115 = 3.3 time = 1160
* CHECK dout0_0 vdout0_0ck117 = 3.3 time = 1180
* CHECK dout0_1 vdout0_1ck117 = 0 time = 1180
* CHECK dout0_0 vdout0_0ck119 = 3.3 time = 1200
* CHECK dout0_1 vdout0_1ck119 = 3.3 time = 1200
* CHECK dout0_0 vdout0_0ck124 = 3.3 time = 1250
* CHECK dout0_1 vdout0_1ck124 = 0 time = 1250
* CHECK dout1_0 vdout1_0ck125 = 3.3 time = 1260
* CHECK dout1_1 vdout1_1ck125 = 3.3 time = 1260
* CHECK dout0_0 vdout0_0ck126 = 3.3 time = 1270
* CHECK dout0_1 vdout0_1ck126 = 0 time = 1270
* CHECK dout0_0 vdout0_0ck127 = 3.3 time = 1280
* CHECK dout0_1 vdout0_1ck127 = 0 time = 1280
* CHECK dout1_0 vdout1_0ck127 = 3.3 time = 1280
* CHECK dout1_1 vdout1_1ck127 = 0 time = 1280
* CHECK dout0_0 vdout0_0ck128 = 3.3 time = 1290
* CHECK dout0_1 vdout0_1ck128 = 0 time = 1290
* CHECK dout0_0 vdout0_0ck129 = 3.3 time = 1300
* CHECK dout0_1 vdout0_1ck129 = 3.3 time = 1300
* CHECK dout1_0 vdout1_0ck129 = 3.3 time = 1300
* CHECK dout1_1 vdout1_1ck129 = 0 time = 1300
* CHECK dout0_0 vdout0_0ck130 = 3.3 time = 1310
* CHECK dout0_1 vdout0_1ck130 = 0 time = 1310
* CHECK dout0_0 vdout0_0ck131 = 3.3 time = 1320
* CHECK dout0_1 vdout0_1ck131 = 3.3 time = 1320
* CHECK dout0_0 vdout0_0ck133 = 3.3 time = 1340
* CHECK dout0_1 vdout0_1ck133 = 3.3 time = 1340
* CHECK dout1_0 vdout1_0ck133 = 3.3 time = 1340
* CHECK dout1_1 vdout1_1ck133 = 3.3 time = 1340
* CHECK dout0_0 vdout0_0ck134 = 3.3 time = 1350
* CHECK dout0_1 vdout0_1ck134 = 3.3 time = 1350
* CHECK dout1_0 vdout1_0ck134 = 3.3 time = 1350
* CHECK dout1_1 vdout1_1ck134 = 3.3 time = 1350
* CHECK dout0_0 vdout0_0ck135 = 3.3 time = 1360
* CHECK dout0_1 vdout0_1ck135 = 3.3 time = 1360
* CHECK dout0_0 vdout0_0ck136 = 3.3 time = 1370
* CHECK dout0_1 vdout0_1ck136 = 3.3 time = 1370
* CHECK dout1_0 vdout1_0ck141 = 3.3 time = 1420
* CHECK dout1_1 vdout1_1ck141 = 3.3 time = 1420
* CHECK dout0_0 vdout0_0ck142 = 3.3 time = 1430
* CHECK dout0_1 vdout0_1ck142 = 0 time = 1430
* CHECK dout1_0 vdout1_0ck143 = 3.3 time = 1440
* CHECK dout1_1 vdout1_1ck143 = 0 time = 1440
* CHECK dout1_0 vdout1_0ck144 = 3.3 time = 1450
* CHECK dout1_1 vdout1_1ck144 = 0 time = 1450
* CHECK dout1_0 vdout1_0ck145 = 3.3 time = 1460
* CHECK dout1_1 vdout1_1ck145 = 0 time = 1460
* CHECK dout0_0 vdout0_0ck147 = 3.3 time = 1480
* CHECK dout0_1 vdout0_1ck147 = 0 time = 1480
* CHECK dout1_0 vdout1_0ck147 = 3.3 time = 1480
* CHECK dout1_1 vdout1_1ck147 = 0 time = 1480
* CHECK dout0_0 vdout0_0ck148 = 3.3 time = 1490
* CHECK dout0_1 vdout0_1ck148 = 0 time = 1490
* CHECK dout1_0 vdout1_0ck151 = 3.3 time = 1520
* CHECK dout1_1 vdout1_1ck151 = 0 time = 1520
* CHECK dout1_0 vdout1_0ck154 = 0 time = 1550
* CHECK dout1_1 vdout1_1ck154 = 3.3 time = 1550
* CHECK dout1_0 vdout1_0ck155 = 3.3 time = 1560
* CHECK dout1_1 vdout1_1ck155 = 0 time = 1560
* CHECK dout0_0 vdout0_0ck156 = 3.3 time = 1570
* CHECK dout0_1 vdout0_1ck156 = 0 time = 1570
* CHECK dout0_0 vdout0_0ck159 = 3.3 time = 1600
* CHECK dout0_1 vdout0_1ck159 = 3.3 time = 1600
* CHECK dout1_0 vdout1_0ck159 = 0 time = 1600
* CHECK dout1_1 vdout1_1ck159 = 3.3 time = 1600
* CHECK dout0_0 vdout0_0ck160 = 0 time = 1610
* CHECK dout0_1 vdout0_1ck160 = 3.3 time = 1610
* CHECK dout1_0 vdout1_0ck160 = 0 time = 1610
* CHECK dout1_1 vdout1_1ck160 = 3.3 time = 1610
* CHECK dout0_0 vdout0_0ck161 = 3.3 time = 1620
* CHECK dout0_1 vdout0_1ck161 = 3.3 time = 1620
* CHECK dout0_0 vdout0_0ck164 = 0 time = 1650
* CHECK dout0_1 vdout0_1ck164 = 3.3 time = 1650
* CHECK dout0_0 vdout0_0ck165 = 3.3 time = 1660
* CHECK dout0_1 vdout0_1ck165 = 0 time = 1660
* CHECK dout1_0 vdout1_0ck165 = 3.3 time = 1660
* CHECK dout1_1 vdout1_1ck165 = 0 time = 1660
* CHECK dout0_0 vdout0_0ck166 = 0 time = 1670
* CHECK dout0_1 vdout0_1ck166 = 3.3 time = 1670
* CHECK dout0_0 vdout0_0ck168 = 3.3 time = 1690
* CHECK dout0_1 vdout0_1ck168 = 0 time = 1690
* CHECK dout1_0 vdout1_0ck168 = 3.3 time = 1690
* CHECK dout1_1 vdout1_1ck168 = 0 time = 1690
* CHECK dout0_0 vdout0_0ck169 = 3.3 time = 1700
* CHECK dout0_1 vdout0_1ck169 = 0 time = 1700
* CHECK dout0_0 vdout0_0ck170 = 3.3 time = 1710
* CHECK dout0_1 vdout0_1ck170 = 0 time = 1710
* CHECK dout1_0 vdout1_0ck171 = 3.3 time = 1720
* CHECK dout1_1 vdout1_1ck171 = 0 time = 1720
* CHECK dout0_0 vdout0_0ck172 = 3.3 time = 1730
* CHECK dout0_1 vdout0_1ck172 = 0 time = 1730
* CHECK dout1_0 vdout1_0ck172 = 3.3 time = 1730
* CHECK dout1_1 vdout1_1ck172 = 3.3 time = 1730
* CHECK dout1_0 vdout1_0ck173 = 3.3 time = 1740
* CHECK dout1_1 vdout1_1ck173 = 0 time = 1740
* CHECK dout0_0 vdout0_0ck175 = 3.3 time = 1760
* CHECK dout0_1 vdout0_1ck175 = 3.3 time = 1760
* CHECK dout1_0 vdout1_0ck175 = 3.3 time = 1760
* CHECK dout1_1 vdout1_1ck175 = 3.3 time = 1760
* CHECK dout0_0 vdout0_0ck176 = 3.3 time = 1770
* CHECK dout0_1 vdout0_1ck176 = 3.3 time = 1770
* CHECK dout1_0 vdout1_0ck176 = 3.3 time = 1770
* CHECK dout1_1 vdout1_1ck176 = 3.3 time = 1770
* CHECK dout0_0 vdout0_0ck177 = 3.3 time = 1780
* CHECK dout0_1 vdout0_1ck177 = 3.3 time = 1780
* CHECK dout1_0 vdout1_0ck177 = 3.3 time = 1780
* CHECK dout1_1 vdout1_1ck177 = 3.3 time = 1780
* CHECK dout0_0 vdout0_0ck178 = 3.3 time = 1790
* CHECK dout0_1 vdout0_1ck178 = 3.3 time = 1790
* CHECK dout1_0 vdout1_0ck178 = 3.3 time = 1790
* CHECK dout1_1 vdout1_1ck178 = 3.3 time = 1790
* CHECK dout0_0 vdout0_0ck179 = 3.3 time = 1800
* CHECK dout0_1 vdout0_1ck179 = 3.3 time = 1800
* CHECK dout0_0 vdout0_0ck180 = 0 time = 1810
* CHECK dout0_1 vdout0_1ck180 = 3.3 time = 1810
* CHECK dout1_0 vdout1_0ck180 = 0 time = 1810
* CHECK dout1_1 vdout1_1ck180 = 3.3 time = 1810
* CHECK dout0_0 vdout0_0ck181 = 3.3 time = 1820
* CHECK dout0_1 vdout0_1ck181 = 3.3 time = 1820
* CHECK dout0_0 vdout0_0ck182 = 3.3 time = 1830
* CHECK dout0_1 vdout0_1ck182 = 3.3 time = 1830
* CHECK dout0_0 vdout0_0ck183 = 3.3 time = 1840
* CHECK dout0_1 vdout0_1ck183 = 3.3 time = 1840
* CHECK dout0_0 vdout0_0ck184 = 3.3 time = 1850
* CHECK dout0_1 vdout0_1ck184 = 3.3 time = 1850
* CHECK dout1_0 vdout1_0ck184 = 3.3 time = 1850
* CHECK dout1_1 vdout1_1ck184 = 3.3 time = 1850
* CHECK dout0_0 vdout0_0ck186 = 3.3 time = 1870
* CHECK dout0_1 vdout0_1ck186 = 3.3 time = 1870
* CHECK dout1_0 vdout1_0ck187 = 3.3 time = 1880
* CHECK dout1_1 vdout1_1ck187 = 0 time = 1880
* CHECK dout0_0 vdout0_0ck188 = 0 time = 1890
* CHECK dout0_1 vdout0_1ck188 = 3.3 time = 1890
* CHECK dout1_0 vdout1_0ck188 = 0 time = 1890
* CHECK dout1_1 vdout1_1ck188 = 3.3 time = 1890
* CHECK dout1_0 vdout1_0ck191 = 3.3 time = 1920
* CHECK dout1_1 vdout1_1ck191 = 3.3 time = 1920
* CHECK dout1_0 vdout1_0ck192 = 3.3 time = 1930
* CHECK dout1_1 vdout1_1ck192 = 3.3 time = 1930
* CHECK dout0_0 vdout0_0ck194 = 0 time = 1950
* CHECK dout0_1 vdout0_1ck194 = 3.3 time = 1950
* CHECK dout0_0 vdout0_0ck198 = 3.3 time = 1990
* CHECK dout0_1 vdout0_1ck198 = 3.3 time = 1990
* CHECK dout1_0 vdout1_0ck198 = 3.3 time = 1990
* CHECK dout1_1 vdout1_1ck198 = 3.3 time = 1990
* CHECK dout1_0 vdout1_0ck200 = 0 time = 2010
* CHECK dout1_1 vdout1_1ck200 = 3.3 time = 2010
* CHECK dout1_0 vdout1_0ck201 = 3.3 time = 2020
* CHECK dout1_1 vdout1_1ck201 = 3.3 time = 2020
* CHECK dout1_0 vdout1_0ck202 = 0 time = 2030
* CHECK dout1_1 vdout1_1ck202 = 3.3 time = 2030
* CHECK dout0_0 vdout0_0ck203 = 0 time = 2040
* CHECK dout0_1 vdout0_1ck203 = 3.3 time = 2040
.include /lscratch/fanals/asic-data-operation/OpenRAM/temp/functional_meas.sp
* probe is used for hspice/xa, while plot is used in ngspice
*.probe V(*)
*.plot V(*)
.end
