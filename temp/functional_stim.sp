* Functional test stimulus file for 10ns period

* TT process corner
.lib "/u1/fanals/asic-data-operation/OpenRAM/sky130A/libs.tech/ngspice/sky130.lib.spice" tt
.include "/tmp/openram_fanals_4169293_temp/sram.sp"

* Global Power Supplies
Vvdd vdd 0 3.3

*Nodes gnd and 0 are the same global ground node in ngspice/hspice/xa. Otherwise, this source may be needed.
*Vgnd gnd 0 0.0

* Instantiation of the SRAM
Xsram_16x2 din0_0 din0_1 din0_2 din0_3 din0_4 din0_5 din0_6 din0_7 din0_8 din0_9 din0_10 din0_11 din0_12 din0_13 din0_14 din0_15 din0_16 din0_17 din0_18 din0_19 din0_20 din0_21 din0_22 din0_23 din0_24 din0_25 din0_26 din0_27 din0_28 din0_29 din0_30 din0_31 din1_0 din1_1 din1_2 din1_3 din1_4 din1_5 din1_6 din1_7 din1_8 din1_9 din1_10 din1_11 din1_12 din1_13 din1_14 din1_15 din1_16 din1_17 din1_18 din1_19 din1_20 din1_21 din1_22 din1_23 din1_24 din1_25 din1_26 din1_27 din1_28 din1_29 din1_30 din1_31 a0_0 a0_1 a0_2 a0_3 a1_0 a1_1 a1_2 a1_3 CSB0 CSB1 WEB0 WEB1 clk0 clk1 dout0_0 dout0_1 dout0_2 dout0_3 dout0_4 dout0_5 dout0_6 dout0_7 dout0_8 dout0_9 dout0_10 dout0_11 dout0_12 dout0_13 dout0_14 dout0_15 dout0_16 dout0_17 dout0_18 dout0_19 dout0_20 dout0_21 dout0_22 dout0_23 dout0_24 dout0_25 dout0_26 dout0_27 dout0_28 dout0_29 dout0_30 dout0_31 dout1_0 dout1_1 dout1_2 dout1_3 dout1_4 dout1_5 dout1_6 dout1_7 dout1_8 dout1_9 dout1_10 dout1_11 dout1_12 dout1_13 dout1_14 dout1_15 dout1_16 dout1_17 dout1_18 dout1_19 dout1_20 dout1_21 dout1_22 dout1_23 dout1_24 dout1_25 dout1_26 dout1_27 dout1_28 dout1_29 dout1_30 dout1_31 vdd gnd sram_16x2

* SRAM output loads
CD00 dout0_0  0 27.56f
CD01 dout0_1  0 27.56f
CD02 dout0_2  0 27.56f
CD03 dout0_3  0 27.56f
CD04 dout0_4  0 27.56f
CD05 dout0_5  0 27.56f
CD06 dout0_6  0 27.56f
CD07 dout0_7  0 27.56f
CD08 dout0_8  0 27.56f
CD09 dout0_9  0 27.56f
CD010 dout0_10  0 27.56f
CD011 dout0_11  0 27.56f
CD012 dout0_12  0 27.56f
CD013 dout0_13  0 27.56f
CD014 dout0_14  0 27.56f
CD015 dout0_15  0 27.56f
CD016 dout0_16  0 27.56f
CD017 dout0_17  0 27.56f
CD018 dout0_18  0 27.56f
CD019 dout0_19  0 27.56f
CD020 dout0_20  0 27.56f
CD021 dout0_21  0 27.56f
CD022 dout0_22  0 27.56f
CD023 dout0_23  0 27.56f
CD024 dout0_24  0 27.56f
CD025 dout0_25  0 27.56f
CD026 dout0_26  0 27.56f
CD027 dout0_27  0 27.56f
CD028 dout0_28  0 27.56f
CD029 dout0_29  0 27.56f
CD030 dout0_30  0 27.56f
CD031 dout0_31  0 27.56f
CD10 dout1_0  0 27.56f
CD11 dout1_1  0 27.56f
CD12 dout1_2  0 27.56f
CD13 dout1_3  0 27.56f
CD14 dout1_4  0 27.56f
CD15 dout1_5  0 27.56f
CD16 dout1_6  0 27.56f
CD17 dout1_7  0 27.56f
CD18 dout1_8  0 27.56f
CD19 dout1_9  0 27.56f
CD110 dout1_10  0 27.56f
CD111 dout1_11  0 27.56f
CD112 dout1_12  0 27.56f
CD113 dout1_13  0 27.56f
CD114 dout1_14  0 27.56f
CD115 dout1_15  0 27.56f
CD116 dout1_16  0 27.56f
CD117 dout1_17  0 27.56f
CD118 dout1_18  0 27.56f
CD119 dout1_19  0 27.56f
CD120 dout1_20  0 27.56f
CD121 dout1_21  0 27.56f
CD122 dout1_22  0 27.56f
CD123 dout1_23  0 27.56f
CD124 dout1_24  0 27.56f
CD125 dout1_25  0 27.56f
CD126 dout1_26  0 27.56f
CD127 dout1_27  0 27.56f
CD128 dout1_28  0 27.56f
CD129 dout1_29  0 27.56f
CD130 dout1_30  0 27.56f
CD131 dout1_31  0 27.56f

* Important signals for debug
* bl:	xsram:xbank0:bl_0_1
* br:	xsram:xbank0:br_0_1
* s_en:	xsram:s_en
* q:	xsram:xbank0:xbitcell_array:xbitcell_array:xbit_r0_c0.Q
* qbar:	xsram:xbank0:xbitcell_array:xbitcell_array:xbit_r0_c0.Q_bar

* Sequence of operations
*	Idle during cycle 0 (0ns - 10ns)
*	Writing 01101011010111000011000011000001  to  address 1110 (from port 0) during cycle 1 (10ns - 20ns)
*	Writing 11001000100010010001000100100101  to  address 0000 (from port 1) during cycle 1 (10ns - 20ns)
*	Writing 10000010100001111001001101110011  to  address 1110 (from port 0) during cycle 2 (20ns - 30ns)
*	Writing 10101110111000000010011100111010  to  address 0000 (from port 1) during cycle 2 (20ns - 30ns)
*	Writing 11011010000010010111010111010101  to  address 0000 (from port 0) during cycle 3 (30ns - 40ns)
*	Writing 10110100111111100000011001010011  to  address 0000 (from port 1) during cycle 3 (30ns - 40ns)
*	Reading 10000010100001111001001101110011 from address 1110 (from port 0) during cycle 4 (40ns - 50ns)
*	Reading 10000010100001111001001101110011 from address 1110 (from port 1) during cycle 4 (40ns - 50ns)
*	Reading 10000010100001111001001101110011 from address 1110 (from port 0) during cycle 5 (50ns - 60ns)
*	Writing 11011011001110101011000001000011  to  address 0000 (from port 1) during cycle 5 (50ns - 60ns)
*	Reading 11011011001110101011000001000011 from address 0000 (from port 0) during cycle 6 (60ns - 70ns)
*	Writing 00001101110110101110011101001011  to  address 0000 (from port 1) during cycle 6 (60ns - 70ns)
*	Writing 01111010010100011000101100011010  to  address 0000 (from port 1) during cycle 7 (70ns - 80ns)
*	Reading 10000010100001111001001101110011 from address 1110 (from port 1) during cycle 8 (80ns - 90ns)
*	Reading 01111010010100011000101100011010 from address 0000 (from port 0) during cycle 9 (90ns - 100ns)
*	Reading 10000010100001111001001101110011 from address 1110 (from port 0) during cycle 10 (100ns - 110ns)
*	Writing 10110110000011110010100110010000  to  address 1110 (from port 1) during cycle 10 (100ns - 110ns)
*	Reading 01111010010100011000101100011010 from address 0000 (from port 0) during cycle 11 (110ns - 120ns)
*	Writing 00101011110111110110100100011011  to  address 1110 (from port 0) during cycle 12 (120ns - 130ns)
*	Reading 01111010010100011000101100011010 from address 0000 (from port 1) during cycle 12 (120ns - 130ns)
*	Reading 01111010010100011000101100011010 from address 0000 (from port 0) during cycle 13 (130ns - 140ns)
*	Reading 01111010010100011000101100011010 from address 0000 (from port 1) during cycle 13 (130ns - 140ns)
*	Writing 10100001111111010101001000000010  to  address 0000 (from port 0) during cycle 14 (140ns - 150ns)
*	Writing 01011001011110100011000101000010  to  address 1110 (from port 0) during cycle 15 (150ns - 160ns)
*	Writing 00101111001011001001000010101101  to  address 0000 (from port 1) during cycle 15 (150ns - 160ns)
*	Reading 00101111001011001001000010101101 from address 0000 (from port 0) during cycle 16 (160ns - 170ns)
*	Writing 01001111111100101001010011101000  to  address 0000 (from port 1) during cycle 16 (160ns - 170ns)
*	Writing 10000011000111011110001001001010  to  address 0000 (from port 0) during cycle 17 (170ns - 180ns)
*	Writing 10111011000110110100111011110010  to  address 0000 (from port 0) during cycle 18 (180ns - 190ns)
*	Writing 01100111100100111111110011111101  to  address 1110 (from port 1) during cycle 18 (180ns - 190ns)
*	Writing 00101100111111110101101110001111  to  address 0000 (from port 0) during cycle 19 (190ns - 200ns)
*	Writing 00100001010001001011101001010000  to  address 1110 (from port 0) during cycle 20 (200ns - 210ns)
*	Writing 11101101110100001111011010001110  to  address 1110 (from port 0) during cycle 21 (210ns - 220ns)
*	Writing 00100011011000100110011100100000  to  address 1110 (from port 0) during cycle 22 (220ns - 230ns)
*	Reading 00101100111111110101101110001111 from address 0000 (from port 1) during cycle 22 (220ns - 230ns)
*	Writing 10000111110111000100000010000110  to  address 0000 (from port 1) during cycle 23 (230ns - 240ns)
*	Writing 01001110010001010010011110100010  to  address 0000 (from port 0) during cycle 24 (240ns - 250ns)
*	Writing 00111111011100010110000111011101  to  address 1110 (from port 0) during cycle 25 (250ns - 260ns)
*	Reading 00111111011100010110000111011101 from address 1110 (from port 0) during cycle 26 (260ns - 270ns)
*	Writing 11001100001111111100000001010010  to  address 1110 (from port 0) during cycle 27 (270ns - 280ns)
*	Reading 01001110010001010010011110100010 from address 0000 (from port 1) during cycle 27 (270ns - 280ns)
*	Reading 01001110010001010010011110100010 from address 0000 (from port 0) during cycle 28 (280ns - 290ns)
*	Reading 11001100001111111100000001010010 from address 1110 (from port 0) during cycle 29 (290ns - 300ns)
*	Reading 11001100001111111100000001010010 from address 1110 (from port 1) during cycle 29 (290ns - 300ns)
*	Reading 11001100001111111100000001010010 from address 1110 (from port 0) during cycle 30 (300ns - 310ns)
*	Reading 11001100001111111100000001010010 from address 1110 (from port 1) during cycle 30 (300ns - 310ns)
*	Writing 00101010001000110011101100110111  to  address 0000 (from port 0) during cycle 31 (310ns - 320ns)
*	Reading 11001100001111111100000001010010 from address 1110 (from port 1) during cycle 31 (310ns - 320ns)
*	Writing 00110001101100100100111111110100  to  address 0000 (from port 0) during cycle 32 (320ns - 330ns)
*	Writing 00110001011010100010001101101100  to  address 0000 (from port 1) during cycle 33 (330ns - 340ns)
*	Reading 11001100001111111100000001010010 from address 1110 (from port 0) during cycle 34 (340ns - 350ns)
*	Writing 01100001000101100000000101000000  to  address 1110 (from port 0) during cycle 35 (350ns - 360ns)
*	Writing 11111001100000101110101010110001  to  address 0000 (from port 1) during cycle 36 (360ns - 370ns)
*	Reading 01100001000101100000000101000000 from address 1110 (from port 0) during cycle 37 (370ns - 380ns)
*	Reading 11111001100000101110101010110001 from address 0000 (from port 1) during cycle 38 (380ns - 390ns)
*	Reading 11111001100000101110101010110001 from address 0000 (from port 0) during cycle 39 (390ns - 400ns)
*	Reading 01100001000101100000000101000000 from address 1110 (from port 1) during cycle 39 (390ns - 400ns)
*	Reading 11111001100000101110101010110001 from address 0000 (from port 0) during cycle 40 (400ns - 410ns)
*	Reading 01100001000101100000000101000000 from address 1110 (from port 0) during cycle 41 (410ns - 420ns)
*	Reading 01100001000101100000000101000000 from address 1110 (from port 1) during cycle 41 (410ns - 420ns)
*	Writing 10100001101000011000001100111001  to  address 0000 (from port 0) during cycle 42 (420ns - 430ns)
*	Reading 01100001000101100000000101000000 from address 1110 (from port 1) during cycle 42 (420ns - 430ns)
*	Writing 00110111011101111100100000001000  to  address 0000 (from port 0) during cycle 43 (430ns - 440ns)
*	Reading 00110111011101111100100000001000 from address 0000 (from port 0) during cycle 44 (440ns - 450ns)
*	Writing 01000001001101111000000010111011  to  address 1110 (from port 1) during cycle 44 (440ns - 450ns)
*	Writing 00011000001101011111100010000001  to  address 1110 (from port 0) during cycle 45 (450ns - 460ns)
*	Reading 00110111011101111100100000001000 from address 0000 (from port 1) during cycle 45 (450ns - 460ns)
*	Reading 00110111011101111100100000001000 from address 0000 (from port 0) during cycle 46 (460ns - 470ns)
*	Reading 00011000001101011111100010000001 from address 1110 (from port 1) during cycle 46 (460ns - 470ns)
*	Reading 00110111011101111100100000001000 from address 0000 (from port 1) during cycle 47 (470ns - 480ns)
*	Reading 00110111011101111100100000001000 from address 0000 (from port 0) during cycle 48 (480ns - 490ns)
*	Reading 00011000001101011111100010000001 from address 1110 (from port 1) during cycle 48 (480ns - 490ns)
*	Writing 01110111101101001101010110110001  to  address 0000 (from port 0) during cycle 49 (490ns - 500ns)
*	Writing 11011111100100010100101011101101  to  address 0000 (from port 0) during cycle 50 (500ns - 510ns)
*	Reading 00011000001101011111100010000001 from address 1110 (from port 1) during cycle 50 (500ns - 510ns)
*	Writing 11011101000101100001100110101110  to  address 0000 (from port 0) during cycle 51 (510ns - 520ns)
*	Writing 10011011001010010110001011010011  to  address 1110 (from port 0) during cycle 52 (520ns - 530ns)
*	Reading 10011011001010010110001011010011 from address 1110 (from port 0) during cycle 53 (530ns - 540ns)
*	Reading 11011101000101100001100110101110 from address 0000 (from port 0) during cycle 54 (540ns - 550ns)
*	Writing 00010001101100011100110011001011  to  address 1110 (from port 1) during cycle 54 (540ns - 550ns)
*	Writing 11101100000101100100000101010101  to  address 1110 (from port 0) during cycle 55 (550ns - 560ns)
*	Writing 10001100110100000111110111000000  to  address 0000 (from port 0) during cycle 56 (560ns - 570ns)
*	Writing 11011101101100001100101101111101  to  address 1110 (from port 0) during cycle 57 (570ns - 580ns)
*	Reading 11011101101100001100101101111101 from address 1110 (from port 1) during cycle 58 (580ns - 590ns)
*	Reading 11011101101100001100101101111101 from address 1110 (from port 0) during cycle 59 (590ns - 600ns)
*	Reading 11011101101100001100101101111101 from address 1110 (from port 0) during cycle 61 (610ns - 620ns)
*	Writing 00010110011010101010000111000010  to  address 0000 (from port 1) during cycle 61 (610ns - 620ns)
*	Reading 00010110011010101010000111000010 from address 0000 (from port 0) during cycle 62 (620ns - 630ns)
*	Reading 00010110011010101010000111000010 from address 0000 (from port 1) during cycle 62 (620ns - 630ns)
*	Reading 00010110011010101010000111000010 from address 0000 (from port 0) during cycle 63 (630ns - 640ns)
*	Writing 10001110001010001100000010100001  to  address 0000 (from port 1) during cycle 63 (630ns - 640ns)
*	Reading 10001110001010001100000010100001 from address 0000 (from port 0) during cycle 64 (640ns - 650ns)
*	Reading 11011101101100001100101101111101 from address 1110 (from port 1) during cycle 64 (640ns - 650ns)
*	Writing 10001001100001100100110110000101  to  address 0000 (from port 0) during cycle 65 (650ns - 660ns)
*	Reading 11011101101100001100101101111101 from address 1110 (from port 0) during cycle 66 (660ns - 670ns)
*	Reading 11011101101100001100101101111101 from address 1110 (from port 1) during cycle 66 (660ns - 670ns)
*	Writing 10110010110101001001001001110101  to  address 0000 (from port 0) during cycle 67 (670ns - 680ns)
*	Reading 10110010110101001001001001110101 from address 0000 (from port 0) during cycle 68 (680ns - 690ns)
*	Reading 10110010110101001001001001110101 from address 0000 (from port 1) during cycle 68 (680ns - 690ns)
*	Reading 11011101101100001100101101111101 from address 1110 (from port 0) during cycle 69 (690ns - 700ns)
*	Writing 10010101101101000101011100110100  to  address 0000 (from port 1) during cycle 69 (690ns - 700ns)
*	Reading 10010101101101000101011100110100 from address 0000 (from port 1) during cycle 70 (700ns - 710ns)
*	Reading 11011101101100001100101101111101 from address 1110 (from port 1) during cycle 71 (710ns - 720ns)
*	Reading 10010101101101000101011100110100 from address 0000 (from port 0) during cycle 72 (720ns - 730ns)
*	Reading 10010101101101000101011100110100 from address 0000 (from port 1) during cycle 72 (720ns - 730ns)
*	Reading 11011101101100001100101101111101 from address 1110 (from port 1) during cycle 73 (730ns - 740ns)
*	Writing 11100010111111010000000010001100  to  address 1110 (from port 0) during cycle 74 (740ns - 750ns)
*	Writing 00101000101011101001111111101001  to  address 0000 (from port 1) during cycle 74 (740ns - 750ns)
*	Writing 01011110010100110101011101000100  to  address 0000 (from port 1) during cycle 75 (750ns - 760ns)
*	Reading 01011110010100110101011101000100 from address 0000 (from port 0) during cycle 76 (760ns - 770ns)
*	Reading 11100010111111010000000010001100 from address 1110 (from port 0) during cycle 77 (770ns - 780ns)
*	Writing 00011111000111010110010011001011  to  address 1110 (from port 1) during cycle 77 (770ns - 780ns)
*	Reading 00011111000111010110010011001011 from address 1110 (from port 0) during cycle 78 (780ns - 790ns)
*	Reading 01011110010100110101011101000100 from address 0000 (from port 1) during cycle 78 (780ns - 790ns)
*	Reading 01011110010100110101011101000100 from address 0000 (from port 0) during cycle 79 (790ns - 800ns)
*	Reading 00011111000111010110010011001011 from address 1110 (from port 1) during cycle 79 (790ns - 800ns)
*	Reading 00011111000111010110010011001011 from address 1110 (from port 0) during cycle 80 (800ns - 810ns)
*	Writing 11111001001111110000001010000010  to  address 0000 (from port 1) during cycle 80 (800ns - 810ns)
*	Reading 11111001001111110000001010000010 from address 0000 (from port 0) during cycle 81 (810ns - 820ns)
*	Reading 11111001001111110000001010000010 from address 0000 (from port 1) during cycle 81 (810ns - 820ns)
*	Reading 11111001001111110000001010000010 from address 0000 (from port 0) during cycle 82 (820ns - 830ns)
*	Writing 10110101001111100101100101000111  to  address 0000 (from port 1) during cycle 82 (820ns - 830ns)
*	Reading 00011111000111010110010011001011 from address 1110 (from port 0) during cycle 83 (830ns - 840ns)
*	Reading 10110101001111100101100101000111 from address 0000 (from port 1) during cycle 83 (830ns - 840ns)
*	Writing 10011100111001010101011111110010  to  address 0000 (from port 0) during cycle 84 (840ns - 850ns)
*	Writing 10100011001010100101111110101111  to  address 1110 (from port 1) during cycle 84 (840ns - 850ns)
*	Reading 10100011001010100101111110101111 from address 1110 (from port 1) during cycle 86 (860ns - 870ns)
*	Reading 10100011001010100101111110101111 from address 1110 (from port 0) during cycle 87 (870ns - 880ns)
*	Reading 10100011001010100101111110101111 from address 1110 (from port 1) during cycle 87 (870ns - 880ns)
*	Writing 11010000001100010101101000100011  to  address 1110 (from port 0) during cycle 88 (880ns - 890ns)
*	Writing 00111010000101011100111100010110  to  address 1110 (from port 0) during cycle 89 (890ns - 900ns)
*	Reading 00111010000101011100111100010110 from address 1110 (from port 1) during cycle 90 (900ns - 910ns)
*	Reading 10011100111001010101011111110010 from address 0000 (from port 0) during cycle 91 (910ns - 920ns)
*	Writing 00001001000111000101110010111001  to  address 1110 (from port 1) during cycle 91 (910ns - 920ns)
*	Writing 00000101111000100010101001111001  to  address 1110 (from port 0) during cycle 92 (920ns - 930ns)
*	Writing 11000111001001100010111111111101  to  address 0000 (from port 0) during cycle 93 (930ns - 940ns)
*	Reading 00000101111000100010101001111001 from address 1110 (from port 1) during cycle 93 (930ns - 940ns)
*	Reading 00000101111000100010101001111001 from address 1110 (from port 0) during cycle 94 (940ns - 950ns)
*	Writing 01011001001000110010100000100011  to  address 1110 (from port 1) during cycle 94 (940ns - 950ns)
*	Writing 11001111000101011111011000010000  to  address 1110 (from port 0) during cycle 95 (950ns - 960ns)
*	Reading 11000111001001100010111111111101 from address 0000 (from port 0) during cycle 96 (960ns - 970ns)
*	Writing 10101000000111110001110011001100  to  address 1110 (from port 1) during cycle 96 (960ns - 970ns)
*	Reading 10101000000111110001110011001100 from address 1110 (from port 0) during cycle 97 (970ns - 980ns)
*	Reading 11000111001001100010111111111101 from address 0000 (from port 1) during cycle 97 (970ns - 980ns)
*	Writing 10001001101000011110011110100110  to  address 1110 (from port 0) during cycle 98 (980ns - 990ns)
*	Reading 10001001101000011110011110100110 from address 1110 (from port 0) during cycle 99 (990ns - 1000ns)
*	Reading 10001001101000011110011110100110 from address 1110 (from port 1) during cycle 99 (990ns - 1000ns)
*	Reading 10001001101000011110011110100110 from address 1110 (from port 0) during cycle 100 (1000ns - 1010ns)
*	Writing 11011100001011111100101100000111  to  address 1110 (from port 1) during cycle 100 (1000ns - 1010ns)
*	Reading 11000111001001100010111111111101 from address 0000 (from port 1) during cycle 101 (1010ns - 1020ns)
*	Reading 11000111001001100010111111111101 from address 0000 (from port 0) during cycle 102 (1020ns - 1030ns)
*	Reading 11011100001011111100101100000111 from address 1110 (from port 1) during cycle 102 (1020ns - 1030ns)
*	Writing 01000000000110111101101110111101  to  address 1110 (from port 0) during cycle 103 (1030ns - 1040ns)
*	Writing 01111111111111101100111100011011  to  address 1110 (from port 0) during cycle 104 (1040ns - 1050ns)
*	Reading 11000111001001100010111111111101 from address 0000 (from port 0) during cycle 105 (1050ns - 1060ns)
*	Reading 11000111001001100010111111111101 from address 0000 (from port 1) during cycle 105 (1050ns - 1060ns)
*	Reading 01111111111111101100111100011011 from address 1110 (from port 0) during cycle 106 (1060ns - 1070ns)
*	Reading 01111111111111101100111100011011 from address 1110 (from port 0) during cycle 107 (1070ns - 1080ns)
*	Reading 01111111111111101100111100011011 from address 1110 (from port 1) during cycle 107 (1070ns - 1080ns)
*	Writing 10001110101101111011101110101111  to  address 0000 (from port 1) during cycle 108 (1080ns - 1090ns)
*	Reading 10001110101101111011101110101111 from address 0000 (from port 0) during cycle 109 (1090ns - 1100ns)
*	Writing 10101110101110001001100000001001  to  address 0000 (from port 1) during cycle 109 (1090ns - 1100ns)
*	Reading 10101110101110001001100000001001 from address 0000 (from port 0) during cycle 110 (1100ns - 1110ns)
*	Reading 10101110101110001001100000001001 from address 0000 (from port 1) during cycle 110 (1100ns - 1110ns)
*	Writing 00010011000000010100110110111000  to  address 1110 (from port 0) during cycle 111 (1110ns - 1120ns)
*	Reading 00010011000000010100110110111000 from address 1110 (from port 0) during cycle 112 (1120ns - 1130ns)
*	Reading 00010011000000010100110110111000 from address 1110 (from port 1) during cycle 112 (1120ns - 1130ns)
*	Reading 10101110101110001001100000001001 from address 0000 (from port 0) during cycle 113 (1130ns - 1140ns)
*	Reading 00010011000000010100110110111000 from address 1110 (from port 1) during cycle 113 (1130ns - 1140ns)
*	Reading 10101110101110001001100000001001 from address 0000 (from port 0) during cycle 114 (1140ns - 1150ns)
*	Reading 10101110101110001001100000001001 from address 0000 (from port 0) during cycle 115 (1150ns - 1160ns)
*	Reading 00010011000000010100110110111000 from address 1110 (from port 1) during cycle 115 (1150ns - 1160ns)
*	Reading 10101110101110001001100000001001 from address 0000 (from port 0) during cycle 116 (1160ns - 1170ns)
*	Writing 00000000010100110010101000101101  to  address 1110 (from port 0) during cycle 118 (1180ns - 1190ns)
*	Reading 10101110101110001001100000001001 from address 0000 (from port 1) during cycle 118 (1180ns - 1190ns)
*	Reading 10101110101110001001100000001001 from address 0000 (from port 1) during cycle 119 (1190ns - 1200ns)
*	Reading 00000000010100110010101000101101 from address 1110 (from port 1) during cycle 120 (1200ns - 1210ns)
*	Reading 10101110101110001001100000001001 from address 0000 (from port 0) during cycle 121 (1210ns - 1220ns)
*	Writing 01011110110101101000011010100010  to  address 1110 (from port 0) during cycle 122 (1220ns - 1230ns)
*	Reading 01011110110101101000011010100010 from address 1110 (from port 0) during cycle 123 (1230ns - 1240ns)
*	Reading 10101110101110001001100000001001 from address 0000 (from port 1) during cycle 123 (1230ns - 1240ns)
*	Reading 01011110110101101000011010100010 from address 1110 (from port 0) during cycle 124 (1240ns - 1250ns)
*	Writing 11000000100011010010010000010100  to  address 1110 (from port 1) during cycle 124 (1240ns - 1250ns)
*	Writing 11010010010001000101000010000000  to  address 0000 (from port 1) during cycle 125 (1250ns - 1260ns)
*	Writing 10001111000001000011100111010011  to  address 1110 (from port 0) during cycle 126 (1260ns - 1270ns)
*	Reading 11010010010001000101000010000000 from address 0000 (from port 1) during cycle 126 (1260ns - 1270ns)
*	Writing 10111111110111010110010011100001  to  address 1110 (from port 1) during cycle 128 (1280ns - 1290ns)
*	Reading 10111111110111010110010011100001 from address 1110 (from port 0) during cycle 129 (1290ns - 1300ns)
*	Reading 11010010010001000101000010000000 from address 0000 (from port 1) during cycle 129 (1290ns - 1300ns)
*	Reading 11010010010001000101000010000000 from address 0000 (from port 0) during cycle 130 (1300ns - 1310ns)
*	Reading 10111111110111010110010011100001 from address 1110 (from port 0) during cycle 131 (1310ns - 1320ns)
*	Reading 11010010010001000101000010000000 from address 0000 (from port 1) during cycle 131 (1310ns - 1320ns)
*	Reading 10111111110111010110010011100001 from address 1110 (from port 0) during cycle 132 (1320ns - 1330ns)
*	Writing 01110010101011011110111011100111  to  address 1110 (from port 1) during cycle 132 (1320ns - 1330ns)
*	Reading 11010010010001000101000010000000 from address 0000 (from port 1) during cycle 133 (1330ns - 1340ns)
*	Reading 01110010101011011110111011100111 from address 1110 (from port 0) during cycle 134 (1340ns - 1350ns)
*	Writing 00100100011000110000111010101100  to  address 1110 (from port 1) during cycle 134 (1340ns - 1350ns)
*	Reading 11010010010001000101000010000000 from address 0000 (from port 0) during cycle 135 (1350ns - 1360ns)
*	Reading 11010010010001000101000010000000 from address 0000 (from port 1) during cycle 135 (1350ns - 1360ns)
*	Writing 10001011100010000010010010001100  to  address 1110 (from port 0) during cycle 136 (1360ns - 1370ns)
*	Writing 10011111001101001100111010000000  to  address 0000 (from port 1) during cycle 136 (1360ns - 1370ns)
*	Writing 11010110000001101110101001100110  to  address 0000 (from port 0) during cycle 137 (1370ns - 1380ns)
*	Reading 10001011100010000010010010001100 from address 1110 (from port 1) during cycle 137 (1370ns - 1380ns)
*	Reading 10001011100010000010010010001100 from address 1110 (from port 0) during cycle 138 (1380ns - 1390ns)
*	Reading 11010110000001101110101001100110 from address 0000 (from port 0) during cycle 139 (1390ns - 1400ns)
*	Writing 10011010001100000010110111111101  to  address 1110 (from port 1) during cycle 139 (1390ns - 1400ns)
*	Reading 11010110000001101110101001100110 from address 0000 (from port 0) during cycle 140 (1400ns - 1410ns)
*	Reading 10011010001100000010110111111101 from address 1110 (from port 1) during cycle 140 (1400ns - 1410ns)
*	Reading 10011010001100000010110111111101 from address 1110 (from port 1) during cycle 141 (1410ns - 1420ns)
*	Reading 10011010001100000010110111111101 from address 1110 (from port 0) during cycle 142 (1420ns - 1430ns)
*	Reading 11010110000001101110101001100110 from address 0000 (from port 1) during cycle 142 (1420ns - 1430ns)
*	Reading 10011010001100000010110111111101 from address 1110 (from port 0) during cycle 143 (1430ns - 1440ns)
*	Writing 01111000000010000100101100000100  to  address 0000 (from port 1) during cycle 143 (1430ns - 1440ns)
*	Writing 00101110100100000111001001011101  to  address 0000 (from port 0) during cycle 144 (1440ns - 1450ns)
*	Writing 00111011001010101011100101101110  to  address 1110 (from port 1) during cycle 144 (1440ns - 1450ns)
*	Reading 00101110100100000111001001011101 from address 0000 (from port 0) during cycle 145 (1450ns - 1460ns)
*	Reading 00101110100100000111001001011101 from address 0000 (from port 1) during cycle 145 (1450ns - 1460ns)
*	Writing 10010101110011000100110100110111  to  address 0000 (from port 0) during cycle 146 (1460ns - 1470ns)
*	Reading 10010101110011000100110100110111 from address 0000 (from port 0) during cycle 147 (1470ns - 1480ns)
*	Writing 01111100010111110110011001000001  to  address 0000 (from port 1) during cycle 147 (1470ns - 1480ns)
*	Reading 01111100010111110110011001000001 from address 0000 (from port 0) during cycle 148 (1480ns - 1490ns)
*	Writing 00011001010000001001110011100001  to  address 1110 (from port 1) during cycle 148 (1480ns - 1490ns)
*	Reading 01111100010111110110011001000001 from address 0000 (from port 0) during cycle 149 (1490ns - 1500ns)
*	Reading 00011001010000001001110011100001 from address 1110 (from port 1) during cycle 149 (1490ns - 1500ns)
*	Writing 10110100101001100101001011010100  to  address 0000 (from port 0) during cycle 150 (1500ns - 1510ns)
*	Writing 01011101011001000110101010000010  to  address 0000 (from port 0) during cycle 151 (1510ns - 1520ns)
*	Reading 00011001010000001001110011100001 from address 1110 (from port 0) during cycle 152 (1520ns - 1530ns)
*	Writing 10000011110110111001001001000001  to  address 0000 (from port 0) during cycle 153 (1530ns - 1540ns)
*	Reading 00011001010000001001110011100001 from address 1110 (from port 1) during cycle 153 (1530ns - 1540ns)
*	Reading 00011001010000001001110011100001 from address 1110 (from port 0) during cycle 154 (1540ns - 1550ns)
*	Reading 00011001010000001001110011100001 from address 1110 (from port 1) during cycle 154 (1540ns - 1550ns)
*	Reading 00011001010000001001110011100001 from address 1110 (from port 0) during cycle 155 (1550ns - 1560ns)
*	Writing 11100001001111101001101111111101  to  address 1110 (from port 1) during cycle 155 (1550ns - 1560ns)
*	Reading 10000011110110111001001001000001 from address 0000 (from port 1) during cycle 156 (1560ns - 1570ns)
*	Reading 10000011110110111001001001000001 from address 0000 (from port 0) during cycle 157 (1570ns - 1580ns)
*	Writing 01010001001100001100001111110010  to  address 1110 (from port 1) during cycle 157 (1570ns - 1580ns)
*	Reading 10000011110110111001001001000001 from address 0000 (from port 1) during cycle 158 (1580ns - 1590ns)
*	Writing 10100111101110010110111010100101  to  address 0000 (from port 0) during cycle 159 (1590ns - 1600ns)
*	Reading 01010001001100001100001111110010 from address 1110 (from port 1) during cycle 159 (1590ns - 1600ns)
*	Reading 10100111101110010110111010100101 from address 0000 (from port 0) during cycle 160 (1600ns - 1610ns)
*	Reading 01010001001100001100001111110010 from address 1110 (from port 1) during cycle 160 (1600ns - 1610ns)
*	Reading 10100111101110010110111010100101 from address 0000 (from port 0) during cycle 161 (1610ns - 1620ns)
*	Writing 00100000000001100111001101111001  to  address 0000 (from port 1) during cycle 161 (1610ns - 1620ns)
*	Writing 00000100011011101100101100101000  to  address 0000 (from port 0) during cycle 162 (1620ns - 1630ns)
*	Writing 00000110000000010100110001100100  to  address 0000 (from port 1) during cycle 163 (1630ns - 1640ns)
*	Reading 01010001001100001100001111110010 from address 1110 (from port 0) during cycle 164 (1640ns - 1650ns)
*	Reading 00000110000000010100110001100100 from address 0000 (from port 1) during cycle 164 (1640ns - 1650ns)
*	Reading 01010001001100001100001111110010 from address 1110 (from port 0) during cycle 165 (1650ns - 1660ns)
*	Reading 00000110000000010100110001100100 from address 0000 (from port 1) during cycle 165 (1650ns - 1660ns)
*	Writing 10110011100100010110011000111011  to  address 1110 (from port 0) during cycle 166 (1660ns - 1670ns)
*	Writing 00001000100011010100011000000111  to  address 0000 (from port 1) during cycle 166 (1660ns - 1670ns)
*	Reading 10110011100100010110011000111011 from address 1110 (from port 0) during cycle 167 (1670ns - 1680ns)
*	Writing 01101011001100111101000011110000  to  address 0000 (from port 1) during cycle 168 (1680ns - 1690ns)
*	Reading 01101011001100111101000011110000 from address 0000 (from port 1) during cycle 169 (1690ns - 1700ns)
*	Writing 01110000011010100100100100111110  to  address 1110 (from port 0) during cycle 170 (1700ns - 1710ns)
*	Reading 01101011001100111101000011110000 from address 0000 (from port 1) during cycle 170 (1700ns - 1710ns)
*	Writing 11111101010110010011111010110110  to  address 1110 (from port 0) during cycle 171 (1710ns - 1720ns)
*	Writing 00010010011110011010111100011110  to  address 1110 (from port 0) during cycle 172 (1720ns - 1730ns)
*	Reading 00010010011110011010111100011110 from address 1110 (from port 0) during cycle 173 (1730ns - 1740ns)
*	Reading 00010010011110011010111100011110 from address 1110 (from port 1) during cycle 173 (1730ns - 1740ns)
*	Reading 01101011001100111101000011110000 from address 0000 (from port 0) during cycle 174 (1740ns - 1750ns)
*	Reading 01101011001100111101000011110000 from address 0000 (from port 1) during cycle 174 (1740ns - 1750ns)
*	Reading 00010010011110011010111100011110 from address 1110 (from port 1) during cycle 175 (1750ns - 1760ns)
*	Reading 01101011001100111101000011110000 from address 0000 (from port 0) during cycle 176 (1760ns - 1770ns)
*	Reading 01101011001100111101000011110000 from address 0000 (from port 1) during cycle 176 (1760ns - 1770ns)
*	Writing 10101110001000011111001010011101  to  address 0000 (from port 0) during cycle 177 (1770ns - 1780ns)
*	Writing 01011010101111111111010010010111  to  address 1110 (from port 1) during cycle 177 (1770ns - 1780ns)
*	Writing 11010110000100110011000111110001  to  address 1110 (from port 0) during cycle 178 (1780ns - 1790ns)
*	Reading 10101110001000011111001010011101 from address 0000 (from port 1) during cycle 178 (1780ns - 1790ns)
*	Reading 10101110001000011111001010011101 from address 0000 (from port 0) during cycle 179 (1790ns - 1800ns)
*	Writing 11000010001001110001001010100010  to  address 0000 (from port 1) during cycle 179 (1790ns - 1800ns)
*	Reading 11000010001001110001001010100010 from address 0000 (from port 0) during cycle 180 (1800ns - 1810ns)
*	Reading 11010110000100110011000111110001 from address 1110 (from port 1) during cycle 180 (1800ns - 1810ns)
*	Reading 11000010001001110001001010100010 from address 0000 (from port 0) during cycle 181 (1810ns - 1820ns)
*	Reading 11000010001001110001001010100010 from address 0000 (from port 1) during cycle 181 (1810ns - 1820ns)
*	Reading 11000010001001110001001010100010 from address 0000 (from port 0) during cycle 182 (1820ns - 1830ns)
*	Reading 11010110000100110011000111110001 from address 1110 (from port 1) during cycle 182 (1820ns - 1830ns)
*	Reading 11010110000100110011000111110001 from address 1110 (from port 1) during cycle 183 (1830ns - 1840ns)
*	Writing 11111111000010111111011010111001  to  address 1110 (from port 0) during cycle 184 (1840ns - 1850ns)
*	Writing 01101011011111010110110011110111  to  address 1110 (from port 0) during cycle 185 (1850ns - 1860ns)
*	Reading 11000010001001110001001010100010 from address 0000 (from port 1) during cycle 186 (1860ns - 1870ns)
*	Reading 01101011011111010110110011110111 from address 1110 (from port 0) during cycle 187 (1870ns - 1880ns)
*	Reading 01101011011111010110110011110111 from address 1110 (from port 1) during cycle 187 (1870ns - 1880ns)
*	Writing 11001100000011010001001111110001  to  address 1110 (from port 0) during cycle 188 (1880ns - 1890ns)
*	Writing 10101001100101100111100111100001  to  address 0000 (from port 0) during cycle 189 (1890ns - 1900ns)
*	Reading 10101001100101100111100111100001 from address 0000 (from port 0) during cycle 190 (1900ns - 1910ns)
*	Reading 10101001100101100111100111100001 from address 0000 (from port 1) during cycle 190 (1900ns - 1910ns)
*	Reading 11001100000011010001001111110001 from address 1110 (from port 0) during cycle 191 (1910ns - 1920ns)
*	Reading 10101001100101100111100111100001 from address 0000 (from port 1) during cycle 191 (1910ns - 1920ns)
*	Reading 11001100000011010001001111110001 from address 1110 (from port 0) during cycle 192 (1920ns - 1930ns)
*	Reading 10101001100101100111100111100001 from address 0000 (from port 1) during cycle 192 (1920ns - 1930ns)
*	Writing 11111100111111100011100101100110  to  address 1110 (from port 0) during cycle 193 (1930ns - 1940ns)
*	Reading 11111100111111100011100101100110 from address 1110 (from port 0) during cycle 194 (1940ns - 1950ns)
*	Reading 11111100111111100011100101100110 from address 1110 (from port 1) during cycle 194 (1940ns - 1950ns)
*	Reading 11111100111111100011100101100110 from address 1110 (from port 0) during cycle 195 (1950ns - 1960ns)
*	Writing 00001110011110010001111110001100  to  address 1110 (from port 1) during cycle 195 (1950ns - 1960ns)
*	Reading 10101001100101100111100111100001 from address 0000 (from port 0) during cycle 196 (1960ns - 1970ns)
*	Reading 10101001100101100111100111100001 from address 0000 (from port 0) during cycle 197 (1970ns - 1980ns)
*	Reading 10101001100101100111100111100001 from address 0000 (from port 1) during cycle 197 (1970ns - 1980ns)
*	Writing 00111011011110011001001001101010  to  address 0000 (from port 0) during cycle 198 (1980ns - 1990ns)
*	Writing 11010000001011010110111111010001  to  address 1110 (from port 1) during cycle 198 (1980ns - 1990ns)
*	Reading 11010000001011010110111111010001 from address 1110 (from port 0) during cycle 199 (1990ns - 2000ns)
*	Reading 11010000001011010110111111010001 from address 1110 (from port 1) during cycle 199 (1990ns - 2000ns)
*	Reading 11010000001011010110111111010001 from address 1110 (from port 0) during cycle 200 (2000ns - 2010ns)
*	Reading 00111011011110011001001001101010 from address 0000 (from port 1) during cycle 200 (2000ns - 2010ns)
*	Writing 01001010000001110110101100110000  to  address 0000 (from port 0) during cycle 201 (2010ns - 2020ns)
*	Reading 11010000001011010110111111010001 from address 1110 (from port 1) during cycle 201 (2010ns - 2020ns)
*	Reading 11010000001011010110111111010001 from address 1110 (from port 0) during cycle 202 (2020ns - 2030ns)
*	Writing 00110001100011101000000010111101  to  address 1110 (from port 1) during cycle 202 (2020ns - 2030ns)
*	Writing 10101011001011001101101010001111  to  address 0000 (from port 1) during cycle 203 (2030ns - 2040ns)
*	Reading 00110001100011101000000010111101 from address 1110 (from port 0) during cycle 204 (2040ns - 2050ns)
*	Idle during cycle 205 (2050ns - 2060ns)

* Generation of data and address signals
* (time, data): [(0, 0), (10, 1), (20, 1), (30, 1), (40, 1), (50, 1), (60, 1), (70, 1), (80, 1), (90, 1), (100, 1), (110, 1), (120, 1), (130, 1), (140, 0), (150, 0), (160, 0), (170, 0), (180, 0), (190, 1), (200, 0), (210, 0), (220, 0), (230, 0), (240, 0), (250, 1), (260, 1), (270, 0), (280, 0), (290, 0), (300, 0), (310, 1), (320, 0), (330, 0), (340, 0), (350, 0), (360, 0), (370, 0), (380, 0), (390, 0), (400, 0), (410, 0), (420, 1), (430, 0), (440, 0), (450, 1), (460, 1), (470, 1), (480, 1), (490, 1), (500, 1), (510, 0), (520, 1), (530, 1), (540, 1), (550, 1), (560, 0), (570, 1), (580, 1), (590, 1), (600, 1), (610, 1), (620, 1), (630, 1), (640, 1), (650, 1), (660, 1), (670, 1), (680, 1), (690, 1), (700, 1), (710, 1), (720, 1), (730, 1), (740, 0), (750, 0), (760, 0), (770, 0), (780, 0), (790, 0), (800, 0), (810, 0), (820, 0), (830, 0), (840, 0), (850, 0), (860, 0), (870, 0), (880, 1), (890, 0), (900, 0), (910, 0), (920, 1), (930, 1), (940, 1), (950, 0), (960, 0), (970, 0), (980, 0), (990, 0), (1000, 0), (1010, 0), (1020, 0), (1030, 1), (1040, 1), (1050, 1), (1060, 1), (1070, 1), (1080, 1), (1090, 1), (1100, 1), (1110, 0), (1120, 0), (1130, 0), (1140, 0), (1150, 0), (1160, 0), (1170, 0), (1180, 1), (1190, 1), (1200, 1), (1210, 1), (1220, 0), (1230, 0), (1240, 0), (1250, 0), (1260, 1), (1270, 1), (1280, 1), (1290, 1), (1300, 1), (1310, 1), (1320, 1), (1330, 1), (1340, 1), (1350, 1), (1360, 0), (1370, 0), (1380, 0), (1390, 0), (1400, 0), (1410, 0), (1420, 0), (1430, 0), (1440, 1), (1450, 1), (1460, 1), (1470, 1), (1480, 1), (1490, 1), (1500, 0), (1510, 0), (1520, 0), (1530, 1), (1540, 1), (1550, 1), (1560, 1), (1570, 1), (1580, 1), (1590, 1), (1600, 1), (1610, 1), (1620, 0), (1630, 0), (1640, 0), (1650, 0), (1660, 1), (1670, 1), (1680, 1), (1690, 1), (1700, 0), (1710, 0), (1720, 0), (1730, 0), (1740, 0), (1750, 0), (1760, 0), (1770, 1), (1780, 1), (1790, 1), (1800, 1), (1810, 1), (1820, 1), (1830, 1), (1840, 1), (1850, 1), (1860, 1), (1870, 1), (1880, 1), (1890, 1), (1900, 1), (1910, 1), (1920, 1), (1930, 0), (1940, 0), (1950, 0), (1960, 0), (1970, 0), (1980, 0), (1990, 0), (2000, 0), (2010, 0), (2020, 0), (2030, 0), (2040, 0), (2050, 0)]
Vdin0_0  din0_0  0 PWL (0n 0.0v 9.495n 0.0v 9.505n 3.3v 19.495n 3.3v 19.505n 3.3v 29.495n 3.3v 29.505n 3.3v 39.495n 3.3v 39.505n 3.3v 49.495n 3.3v 49.505n 3.3v 59.495n 3.3v 59.505n 3.3v 69.495n 3.3v 69.505n 3.3v 79.495n 3.3v 79.505n 3.3v 89.495n 3.3v 89.505n 3.3v 99.495n 3.3v 99.505n 3.3v 109.495n 3.3v 109.505n 3.3v 119.495n 3.3v 119.505n 3.3v 129.495n 3.3v 129.505n 3.3v 139.495n 3.3v 139.505n 0.0v 149.495n 0.0v 149.505n 0.0v 159.495n 0.0v 159.505n 0.0v 169.495n 0.0v 169.505n 0.0v 179.495n 0.0v 179.505n 0.0v 189.495n 0.0v 189.505n 3.3v 199.495n 3.3v 199.505n 0.0v 209.495n 0.0v 209.505n 0.0v 219.495n 0.0v 219.505n 0.0v 229.495n 0.0v 229.505n 0.0v 239.495n 0.0v 239.505n 0.0v 249.495n 0.0v 249.505n 3.3v 259.495n 3.3v 259.505n 3.3v 269.495n 3.3v 269.505n 0.0v 279.495n 0.0v 279.505n 0.0v 289.495n 0.0v 289.505n 0.0v 299.495n 0.0v 299.505n 0.0v 309.495n 0.0v 309.505n 3.3v 319.495n 3.3v 319.505n 0.0v 329.495n 0.0v 329.505n 0.0v 339.495n 0.0v 339.505n 0.0v 349.495n 0.0v 349.505n 0.0v 359.495n 0.0v 359.505n 0.0v 369.495n 0.0v 369.505n 0.0v 379.495n 0.0v 379.505n 0.0v 389.495n 0.0v 389.505n 0.0v 399.495n 0.0v 399.505n 0.0v 409.495n 0.0v 409.505n 0.0v 419.495n 0.0v 419.505n 3.3v 429.495n 3.3v 429.505n 0.0v 439.495n 0.0v 439.505n 0.0v 449.495n 0.0v 449.505n 3.3v 459.495n 3.3v 459.505n 3.3v 469.495n 3.3v 469.505n 3.3v 479.495n 3.3v 479.505n 3.3v 489.495n 3.3v 489.505n 3.3v 499.495n 3.3v 499.505n 3.3v 509.495n 3.3v 509.505n 0.0v 519.495n 0.0v 519.505n 3.3v 529.495n 3.3v 529.505n 3.3v 539.495n 3.3v 539.505n 3.3v 549.495n 3.3v 549.505n 3.3v 559.495n 3.3v 559.505n 0.0v 569.495n 0.0v 569.505n 3.3v 579.495n 3.3v 579.505n 3.3v 589.495n 3.3v 589.505n 3.3v 599.495n 3.3v 599.505n 3.3v 609.495n 3.3v 609.505n 3.3v 619.495n 3.3v 619.505n 3.3v 629.495n 3.3v 629.505n 3.3v 639.495n 3.3v 639.505n 3.3v 649.495n 3.3v 649.505n 3.3v 659.495n 3.3v 659.505n 3.3v 669.495n 3.3v 669.505n 3.3v 679.495n 3.3v 679.505n 3.3v 689.495n 3.3v 689.505n 3.3v 699.495n 3.3v 699.505n 3.3v 709.495n 3.3v 709.505n 3.3v 719.495n 3.3v 719.505n 3.3v 729.495n 3.3v 729.505n 3.3v 739.495n 3.3v 739.505n 0.0v 749.495n 0.0v 749.505n 0.0v 759.495n 0.0v 759.505n 0.0v 769.495n 0.0v 769.505n 0.0v 779.495n 0.0v 779.505n 0.0v 789.495n 0.0v 789.505n 0.0v 799.495n 0.0v 799.505n 0.0v 809.495n 0.0v 809.505n 0.0v 819.495n 0.0v 819.505n 0.0v 829.495n 0.0v 829.505n 0.0v 839.495n 0.0v 839.505n 0.0v 849.495n 0.0v 849.505n 0.0v 859.495n 0.0v 859.505n 0.0v 869.495n 0.0v 869.505n 0.0v 879.495n 0.0v 879.505n 3.3v 889.495n 3.3v 889.505n 0.0v 899.495n 0.0v 899.505n 0.0v 909.495n 0.0v 909.505n 0.0v 919.495n 0.0v 919.505n 3.3v 929.495n 3.3v 929.505n 3.3v 939.495n 3.3v 939.505n 3.3v 949.495n 3.3v 949.505n 0.0v 959.495n 0.0v 959.505n 0.0v 969.495n 0.0v 969.505n 0.0v 979.495n 0.0v 979.505n 0.0v 989.495n 0.0v 989.505n 0.0v 999.495n 0.0v 999.505n 0.0v 1009.495n 0.0v 1009.505n 0.0v 1019.495n 0.0v 1019.505n 0.0v 1029.495n 0.0v 1029.505n 3.3v 1039.495n 3.3v 1039.505n 3.3v 1049.495n 3.3v 1049.505n 3.3v 1059.495n 3.3v 1059.505n 3.3v 1069.495n 3.3v 1069.505n 3.3v 1079.495n 3.3v 1079.505n 3.3v 1089.495n 3.3v 1089.505n 3.3v 1099.495n 3.3v 1099.505n 3.3v 1109.495n 3.3v 1109.505n 0.0v 1119.495n 0.0v 1119.505n 0.0v 1129.495n 0.0v 1129.505n 0.0v 1139.495n 0.0v 1139.505n 0.0v 1149.495n 0.0v 1149.505n 0.0v 1159.495n 0.0v 1159.505n 0.0v 1169.495n 0.0v 1169.505n 0.0v 1179.495n 0.0v 1179.505n 3.3v 1189.495n 3.3v 1189.505n 3.3v 1199.495n 3.3v 1199.505n 3.3v 1209.495n 3.3v 1209.505n 3.3v 1219.495n 3.3v 1219.505n 0.0v 1229.495n 0.0v 1229.505n 0.0v 1239.495n 0.0v 1239.505n 0.0v 1249.495n 0.0v 1249.505n 0.0v 1259.495n 0.0v 1259.505n 3.3v 1269.495n 3.3v 1269.505n 3.3v 1279.495n 3.3v 1279.505n 3.3v 1289.495n 3.3v 1289.505n 3.3v 1299.495n 3.3v 1299.505n 3.3v 1309.495n 3.3v 1309.505n 3.3v 1319.495n 3.3v 1319.505n 3.3v 1329.495n 3.3v 1329.505n 3.3v 1339.495n 3.3v 1339.505n 3.3v 1349.495n 3.3v 1349.505n 3.3v 1359.495n 3.3v 1359.505n 0.0v 1369.495n 0.0v 1369.505n 0.0v 1379.495n 0.0v 1379.505n 0.0v 1389.495n 0.0v 1389.505n 0.0v 1399.495n 0.0v 1399.505n 0.0v 1409.495n 0.0v 1409.505n 0.0v 1419.495n 0.0v 1419.505n 0.0v 1429.495n 0.0v 1429.505n 0.0v 1439.495n 0.0v 1439.505n 3.3v 1449.495n 3.3v 1449.505n 3.3v 1459.495n 3.3v 1459.505n 3.3v 1469.495n 3.3v 1469.505n 3.3v 1479.495n 3.3v 1479.505n 3.3v 1489.495n 3.3v 1489.505n 3.3v 1499.495n 3.3v 1499.505n 0.0v 1509.495n 0.0v 1509.505n 0.0v 1519.495n 0.0v 1519.505n 0.0v 1529.495n 0.0v 1529.505n 3.3v 1539.495n 3.3v 1539.505n 3.3v 1549.495n 3.3v 1549.505n 3.3v 1559.495n 3.3v 1559.505n 3.3v 1569.495n 3.3v 1569.505n 3.3v 1579.495n 3.3v 1579.505n 3.3v 1589.495n 3.3v 1589.505n 3.3v 1599.495n 3.3v 1599.505n 3.3v 1609.495n 3.3v 1609.505n 3.3v 1619.495n 3.3v 1619.505n 0.0v 1629.495n 0.0v 1629.505n 0.0v 1639.495n 0.0v 1639.505n 0.0v 1649.495n 0.0v 1649.505n 0.0v 1659.495n 0.0v 1659.505n 3.3v 1669.495n 3.3v 1669.505n 3.3v 1679.495n 3.3v 1679.505n 3.3v 1689.495n 3.3v 1689.505n 3.3v 1699.495n 3.3v 1699.505n 0.0v 1709.495n 0.0v 1709.505n 0.0v 1719.495n 0.0v 1719.505n 0.0v 1729.495n 0.0v 1729.505n 0.0v 1739.495n 0.0v 1739.505n 0.0v 1749.495n 0.0v 1749.505n 0.0v 1759.495n 0.0v 1759.505n 0.0v 1769.495n 0.0v 1769.505n 3.3v 1779.495n 3.3v 1779.505n 3.3v 1789.495n 3.3v 1789.505n 3.3v 1799.495n 3.3v 1799.505n 3.3v 1809.495n 3.3v 1809.505n 3.3v 1819.495n 3.3v 1819.505n 3.3v 1829.495n 3.3v 1829.505n 3.3v 1839.495n 3.3v 1839.505n 3.3v 1849.495n 3.3v 1849.505n 3.3v 1859.495n 3.3v 1859.505n 3.3v 1869.495n 3.3v 1869.505n 3.3v 1879.495n 3.3v 1879.505n 3.3v 1889.495n 3.3v 1889.505n 3.3v 1899.495n 3.3v 1899.505n 3.3v 1909.495n 3.3v 1909.505n 3.3v 1919.495n 3.3v 1919.505n 3.3v 1929.495n 3.3v 1929.505n 0.0v 1939.495n 0.0v 1939.505n 0.0v 1949.495n 0.0v 1949.505n 0.0v 1959.495n 0.0v 1959.505n 0.0v 1969.495n 0.0v 1969.505n 0.0v 1979.495n 0.0v 1979.505n 0.0v 1989.495n 0.0v 1989.505n 0.0v 1999.495n 0.0v 1999.505n 0.0v 2009.495n 0.0v 2009.505n 0.0v 2019.495n 0.0v 2019.505n 0.0v 2029.495n 0.0v 2029.505n 0.0v 2039.495n 0.0v 2039.505n 0.0v 2049.495n 0.0v 2049.505n 0.0v )
* (time, data): [(0, 0), (10, 0), (20, 1), (30, 0), (40, 0), (50, 0), (60, 0), (70, 0), (80, 0), (90, 0), (100, 0), (110, 0), (120, 1), (130, 1), (140, 1), (150, 1), (160, 1), (170, 1), (180, 1), (190, 1), (200, 0), (210, 1), (220, 0), (230, 0), (240, 1), (250, 0), (260, 0), (270, 1), (280, 1), (290, 1), (300, 1), (310, 1), (320, 0), (330, 0), (340, 0), (350, 0), (360, 0), (370, 0), (380, 0), (390, 0), (400, 0), (410, 0), (420, 0), (430, 0), (440, 0), (450, 0), (460, 0), (470, 0), (480, 0), (490, 0), (500, 0), (510, 1), (520, 1), (530, 1), (540, 1), (550, 0), (560, 0), (570, 0), (580, 0), (590, 0), (600, 0), (610, 0), (620, 0), (630, 0), (640, 0), (650, 0), (660, 0), (670, 0), (680, 0), (690, 0), (700, 0), (710, 0), (720, 0), (730, 0), (740, 0), (750, 0), (760, 0), (770, 0), (780, 0), (790, 0), (800, 0), (810, 0), (820, 0), (830, 0), (840, 1), (850, 1), (860, 1), (870, 1), (880, 1), (890, 1), (900, 1), (910, 1), (920, 0), (930, 0), (940, 0), (950, 0), (960, 0), (970, 0), (980, 1), (990, 1), (1000, 1), (1010, 1), (1020, 1), (1030, 0), (1040, 1), (1050, 1), (1060, 1), (1070, 1), (1080, 1), (1090, 1), (1100, 1), (1110, 0), (1120, 0), (1130, 0), (1140, 0), (1150, 0), (1160, 0), (1170, 0), (1180, 0), (1190, 0), (1200, 0), (1210, 0), (1220, 1), (1230, 1), (1240, 1), (1250, 1), (1260, 1), (1270, 1), (1280, 1), (1290, 1), (1300, 1), (1310, 1), (1320, 1), (1330, 1), (1340, 1), (1350, 1), (1360, 0), (1370, 1), (1380, 1), (1390, 1), (1400, 1), (1410, 1), (1420, 1), (1430, 1), (1440, 0), (1450, 0), (1460, 1), (1470, 1), (1480, 1), (1490, 1), (1500, 0), (1510, 1), (1520, 1), (1530, 0), (1540, 0), (1550, 0), (1560, 0), (1570, 0), (1580, 0), (1590, 0), (1600, 0), (1610, 0), (1620, 0), (1630, 0), (1640, 0), (1650, 0), (1660, 1), (1670, 1), (1680, 1), (1690, 1), (1700, 1), (1710, 1), (1720, 1), (1730, 1), (1740, 1), (1750, 1), (1760, 1), (1770, 0), (1780, 0), (1790, 0), (1800, 0), (1810, 0), (1820, 0), (1830, 0), (1840, 0), (1850, 1), (1860, 1), (1870, 1), (1880, 0), (1890, 0), (1900, 0), (1910, 0), (1920, 0), (1930, 1), (1940, 1), (1950, 1), (1960, 1), (1970, 1), (1980, 1), (1990, 1), (2000, 1), (2010, 0), (2020, 0), (2030, 0), (2040, 0), (2050, 0)]
Vdin0_1  din0_1  0 PWL (0n 0.0v 9.495n 0.0v 9.505n 0.0v 19.495n 0.0v 19.505n 3.3v 29.495n 3.3v 29.505n 0.0v 39.495n 0.0v 39.505n 0.0v 49.495n 0.0v 49.505n 0.0v 59.495n 0.0v 59.505n 0.0v 69.495n 0.0v 69.505n 0.0v 79.495n 0.0v 79.505n 0.0v 89.495n 0.0v 89.505n 0.0v 99.495n 0.0v 99.505n 0.0v 109.495n 0.0v 109.505n 0.0v 119.495n 0.0v 119.505n 3.3v 129.495n 3.3v 129.505n 3.3v 139.495n 3.3v 139.505n 3.3v 149.495n 3.3v 149.505n 3.3v 159.495n 3.3v 159.505n 3.3v 169.495n 3.3v 169.505n 3.3v 179.495n 3.3v 179.505n 3.3v 189.495n 3.3v 189.505n 3.3v 199.495n 3.3v 199.505n 0.0v 209.495n 0.0v 209.505n 3.3v 219.495n 3.3v 219.505n 0.0v 229.495n 0.0v 229.505n 0.0v 239.495n 0.0v 239.505n 3.3v 249.495n 3.3v 249.505n 0.0v 259.495n 0.0v 259.505n 0.0v 269.495n 0.0v 269.505n 3.3v 279.495n 3.3v 279.505n 3.3v 289.495n 3.3v 289.505n 3.3v 299.495n 3.3v 299.505n 3.3v 309.495n 3.3v 309.505n 3.3v 319.495n 3.3v 319.505n 0.0v 329.495n 0.0v 329.505n 0.0v 339.495n 0.0v 339.505n 0.0v 349.495n 0.0v 349.505n 0.0v 359.495n 0.0v 359.505n 0.0v 369.495n 0.0v 369.505n 0.0v 379.495n 0.0v 379.505n 0.0v 389.495n 0.0v 389.505n 0.0v 399.495n 0.0v 399.505n 0.0v 409.495n 0.0v 409.505n 0.0v 419.495n 0.0v 419.505n 0.0v 429.495n 0.0v 429.505n 0.0v 439.495n 0.0v 439.505n 0.0v 449.495n 0.0v 449.505n 0.0v 459.495n 0.0v 459.505n 0.0v 469.495n 0.0v 469.505n 0.0v 479.495n 0.0v 479.505n 0.0v 489.495n 0.0v 489.505n 0.0v 499.495n 0.0v 499.505n 0.0v 509.495n 0.0v 509.505n 3.3v 519.495n 3.3v 519.505n 3.3v 529.495n 3.3v 529.505n 3.3v 539.495n 3.3v 539.505n 3.3v 549.495n 3.3v 549.505n 0.0v 559.495n 0.0v 559.505n 0.0v 569.495n 0.0v 569.505n 0.0v 579.495n 0.0v 579.505n 0.0v 589.495n 0.0v 589.505n 0.0v 599.495n 0.0v 599.505n 0.0v 609.495n 0.0v 609.505n 0.0v 619.495n 0.0v 619.505n 0.0v 629.495n 0.0v 629.505n 0.0v 639.495n 0.0v 639.505n 0.0v 649.495n 0.0v 649.505n 0.0v 659.495n 0.0v 659.505n 0.0v 669.495n 0.0v 669.505n 0.0v 679.495n 0.0v 679.505n 0.0v 689.495n 0.0v 689.505n 0.0v 699.495n 0.0v 699.505n 0.0v 709.495n 0.0v 709.505n 0.0v 719.495n 0.0v 719.505n 0.0v 729.495n 0.0v 729.505n 0.0v 739.495n 0.0v 739.505n 0.0v 749.495n 0.0v 749.505n 0.0v 759.495n 0.0v 759.505n 0.0v 769.495n 0.0v 769.505n 0.0v 779.495n 0.0v 779.505n 0.0v 789.495n 0.0v 789.505n 0.0v 799.495n 0.0v 799.505n 0.0v 809.495n 0.0v 809.505n 0.0v 819.495n 0.0v 819.505n 0.0v 829.495n 0.0v 829.505n 0.0v 839.495n 0.0v 839.505n 3.3v 849.495n 3.3v 849.505n 3.3v 859.495n 3.3v 859.505n 3.3v 869.495n 3.3v 869.505n 3.3v 879.495n 3.3v 879.505n 3.3v 889.495n 3.3v 889.505n 3.3v 899.495n 3.3v 899.505n 3.3v 909.495n 3.3v 909.505n 3.3v 919.495n 3.3v 919.505n 0.0v 929.495n 0.0v 929.505n 0.0v 939.495n 0.0v 939.505n 0.0v 949.495n 0.0v 949.505n 0.0v 959.495n 0.0v 959.505n 0.0v 969.495n 0.0v 969.505n 0.0v 979.495n 0.0v 979.505n 3.3v 989.495n 3.3v 989.505n 3.3v 999.495n 3.3v 999.505n 3.3v 1009.495n 3.3v 1009.505n 3.3v 1019.495n 3.3v 1019.505n 3.3v 1029.495n 3.3v 1029.505n 0.0v 1039.495n 0.0v 1039.505n 3.3v 1049.495n 3.3v 1049.505n 3.3v 1059.495n 3.3v 1059.505n 3.3v 1069.495n 3.3v 1069.505n 3.3v 1079.495n 3.3v 1079.505n 3.3v 1089.495n 3.3v 1089.505n 3.3v 1099.495n 3.3v 1099.505n 3.3v 1109.495n 3.3v 1109.505n 0.0v 1119.495n 0.0v 1119.505n 0.0v 1129.495n 0.0v 1129.505n 0.0v 1139.495n 0.0v 1139.505n 0.0v 1149.495n 0.0v 1149.505n 0.0v 1159.495n 0.0v 1159.505n 0.0v 1169.495n 0.0v 1169.505n 0.0v 1179.495n 0.0v 1179.505n 0.0v 1189.495n 0.0v 1189.505n 0.0v 1199.495n 0.0v 1199.505n 0.0v 1209.495n 0.0v 1209.505n 0.0v 1219.495n 0.0v 1219.505n 3.3v 1229.495n 3.3v 1229.505n 3.3v 1239.495n 3.3v 1239.505n 3.3v 1249.495n 3.3v 1249.505n 3.3v 1259.495n 3.3v 1259.505n 3.3v 1269.495n 3.3v 1269.505n 3.3v 1279.495n 3.3v 1279.505n 3.3v 1289.495n 3.3v 1289.505n 3.3v 1299.495n 3.3v 1299.505n 3.3v 1309.495n 3.3v 1309.505n 3.3v 1319.495n 3.3v 1319.505n 3.3v 1329.495n 3.3v 1329.505n 3.3v 1339.495n 3.3v 1339.505n 3.3v 1349.495n 3.3v 1349.505n 3.3v 1359.495n 3.3v 1359.505n 0.0v 1369.495n 0.0v 1369.505n 3.3v 1379.495n 3.3v 1379.505n 3.3v 1389.495n 3.3v 1389.505n 3.3v 1399.495n 3.3v 1399.505n 3.3v 1409.495n 3.3v 1409.505n 3.3v 1419.495n 3.3v 1419.505n 3.3v 1429.495n 3.3v 1429.505n 3.3v 1439.495n 3.3v 1439.505n 0.0v 1449.495n 0.0v 1449.505n 0.0v 1459.495n 0.0v 1459.505n 3.3v 1469.495n 3.3v 1469.505n 3.3v 1479.495n 3.3v 1479.505n 3.3v 1489.495n 3.3v 1489.505n 3.3v 1499.495n 3.3v 1499.505n 0.0v 1509.495n 0.0v 1509.505n 3.3v 1519.495n 3.3v 1519.505n 3.3v 1529.495n 3.3v 1529.505n 0.0v 1539.495n 0.0v 1539.505n 0.0v 1549.495n 0.0v 1549.505n 0.0v 1559.495n 0.0v 1559.505n 0.0v 1569.495n 0.0v 1569.505n 0.0v 1579.495n 0.0v 1579.505n 0.0v 1589.495n 0.0v 1589.505n 0.0v 1599.495n 0.0v 1599.505n 0.0v 1609.495n 0.0v 1609.505n 0.0v 1619.495n 0.0v 1619.505n 0.0v 1629.495n 0.0v 1629.505n 0.0v 1639.495n 0.0v 1639.505n 0.0v 1649.495n 0.0v 1649.505n 0.0v 1659.495n 0.0v 1659.505n 3.3v 1669.495n 3.3v 1669.505n 3.3v 1679.495n 3.3v 1679.505n 3.3v 1689.495n 3.3v 1689.505n 3.3v 1699.495n 3.3v 1699.505n 3.3v 1709.495n 3.3v 1709.505n 3.3v 1719.495n 3.3v 1719.505n 3.3v 1729.495n 3.3v 1729.505n 3.3v 1739.495n 3.3v 1739.505n 3.3v 1749.495n 3.3v 1749.505n 3.3v 1759.495n 3.3v 1759.505n 3.3v 1769.495n 3.3v 1769.505n 0.0v 1779.495n 0.0v 1779.505n 0.0v 1789.495n 0.0v 1789.505n 0.0v 1799.495n 0.0v 1799.505n 0.0v 1809.495n 0.0v 1809.505n 0.0v 1819.495n 0.0v 1819.505n 0.0v 1829.495n 0.0v 1829.505n 0.0v 1839.495n 0.0v 1839.505n 0.0v 1849.495n 0.0v 1849.505n 3.3v 1859.495n 3.3v 1859.505n 3.3v 1869.495n 3.3v 1869.505n 3.3v 1879.495n 3.3v 1879.505n 0.0v 1889.495n 0.0v 1889.505n 0.0v 1899.495n 0.0v 1899.505n 0.0v 1909.495n 0.0v 1909.505n 0.0v 1919.495n 0.0v 1919.505n 0.0v 1929.495n 0.0v 1929.505n 3.3v 1939.495n 3.3v 1939.505n 3.3v 1949.495n 3.3v 1949.505n 3.3v 1959.495n 3.3v 1959.505n 3.3v 1969.495n 3.3v 1969.505n 3.3v 1979.495n 3.3v 1979.505n 3.3v 1989.495n 3.3v 1989.505n 3.3v 1999.495n 3.3v 1999.505n 3.3v 2009.495n 3.3v 2009.505n 0.0v 2019.495n 0.0v 2019.505n 0.0v 2029.495n 0.0v 2029.505n 0.0v 2039.495n 0.0v 2039.505n 0.0v 2049.495n 0.0v 2049.505n 0.0v )
* (time, data): [(0, 0), (10, 0), (20, 0), (30, 1), (40, 1), (50, 1), (60, 1), (70, 1), (80, 1), (90, 1), (100, 1), (110, 1), (120, 0), (130, 0), (140, 0), (150, 0), (160, 0), (170, 0), (180, 0), (190, 1), (200, 0), (210, 1), (220, 0), (230, 0), (240, 0), (250, 1), (260, 1), (270, 0), (280, 0), (290, 0), (300, 0), (310, 1), (320, 1), (330, 1), (340, 1), (350, 0), (360, 0), (370, 0), (380, 0), (390, 0), (400, 0), (410, 0), (420, 0), (430, 0), (440, 0), (450, 0), (460, 0), (470, 0), (480, 0), (490, 0), (500, 1), (510, 1), (520, 0), (530, 0), (540, 0), (550, 1), (560, 0), (570, 1), (580, 1), (590, 1), (600, 1), (610, 1), (620, 1), (630, 1), (640, 1), (650, 1), (660, 1), (670, 1), (680, 1), (690, 1), (700, 1), (710, 1), (720, 1), (730, 1), (740, 1), (750, 1), (760, 1), (770, 1), (780, 1), (790, 1), (800, 1), (810, 1), (820, 1), (830, 1), (840, 0), (850, 0), (860, 0), (870, 0), (880, 0), (890, 1), (900, 1), (910, 1), (920, 0), (930, 1), (940, 1), (950, 0), (960, 0), (970, 0), (980, 1), (990, 1), (1000, 1), (1010, 1), (1020, 1), (1030, 1), (1040, 0), (1050, 0), (1060, 0), (1070, 0), (1080, 0), (1090, 0), (1100, 0), (1110, 0), (1120, 0), (1130, 0), (1140, 0), (1150, 0), (1160, 0), (1170, 0), (1180, 1), (1190, 1), (1200, 1), (1210, 1), (1220, 0), (1230, 0), (1240, 0), (1250, 0), (1260, 0), (1270, 0), (1280, 0), (1290, 0), (1300, 0), (1310, 0), (1320, 0), (1330, 0), (1340, 0), (1350, 0), (1360, 1), (1370, 1), (1380, 1), (1390, 1), (1400, 1), (1410, 1), (1420, 1), (1430, 1), (1440, 1), (1450, 1), (1460, 1), (1470, 1), (1480, 1), (1490, 1), (1500, 1), (1510, 0), (1520, 0), (1530, 0), (1540, 0), (1550, 0), (1560, 0), (1570, 0), (1580, 0), (1590, 1), (1600, 1), (1610, 1), (1620, 0), (1630, 0), (1640, 0), (1650, 0), (1660, 0), (1670, 0), (1680, 0), (1690, 0), (1700, 1), (1710, 1), (1720, 1), (1730, 1), (1740, 1), (1750, 1), (1760, 1), (1770, 1), (1780, 0), (1790, 0), (1800, 0), (1810, 0), (1820, 0), (1830, 0), (1840, 0), (1850, 1), (1860, 1), (1870, 1), (1880, 0), (1890, 0), (1900, 0), (1910, 0), (1920, 0), (1930, 1), (1940, 1), (1950, 1), (1960, 1), (1970, 1), (1980, 0), (1990, 0), (2000, 0), (2010, 0), (2020, 0), (2030, 0), (2040, 0), (2050, 0)]
Vdin0_2  din0_2  0 PWL (0n 0.0v 9.495n 0.0v 9.505n 0.0v 19.495n 0.0v 19.505n 0.0v 29.495n 0.0v 29.505n 3.3v 39.495n 3.3v 39.505n 3.3v 49.495n 3.3v 49.505n 3.3v 59.495n 3.3v 59.505n 3.3v 69.495n 3.3v 69.505n 3.3v 79.495n 3.3v 79.505n 3.3v 89.495n 3.3v 89.505n 3.3v 99.495n 3.3v 99.505n 3.3v 109.495n 3.3v 109.505n 3.3v 119.495n 3.3v 119.505n 0.0v 129.495n 0.0v 129.505n 0.0v 139.495n 0.0v 139.505n 0.0v 149.495n 0.0v 149.505n 0.0v 159.495n 0.0v 159.505n 0.0v 169.495n 0.0v 169.505n 0.0v 179.495n 0.0v 179.505n 0.0v 189.495n 0.0v 189.505n 3.3v 199.495n 3.3v 199.505n 0.0v 209.495n 0.0v 209.505n 3.3v 219.495n 3.3v 219.505n 0.0v 229.495n 0.0v 229.505n 0.0v 239.495n 0.0v 239.505n 0.0v 249.495n 0.0v 249.505n 3.3v 259.495n 3.3v 259.505n 3.3v 269.495n 3.3v 269.505n 0.0v 279.495n 0.0v 279.505n 0.0v 289.495n 0.0v 289.505n 0.0v 299.495n 0.0v 299.505n 0.0v 309.495n 0.0v 309.505n 3.3v 319.495n 3.3v 319.505n 3.3v 329.495n 3.3v 329.505n 3.3v 339.495n 3.3v 339.505n 3.3v 349.495n 3.3v 349.505n 0.0v 359.495n 0.0v 359.505n 0.0v 369.495n 0.0v 369.505n 0.0v 379.495n 0.0v 379.505n 0.0v 389.495n 0.0v 389.505n 0.0v 399.495n 0.0v 399.505n 0.0v 409.495n 0.0v 409.505n 0.0v 419.495n 0.0v 419.505n 0.0v 429.495n 0.0v 429.505n 0.0v 439.495n 0.0v 439.505n 0.0v 449.495n 0.0v 449.505n 0.0v 459.495n 0.0v 459.505n 0.0v 469.495n 0.0v 469.505n 0.0v 479.495n 0.0v 479.505n 0.0v 489.495n 0.0v 489.505n 0.0v 499.495n 0.0v 499.505n 3.3v 509.495n 3.3v 509.505n 3.3v 519.495n 3.3v 519.505n 0.0v 529.495n 0.0v 529.505n 0.0v 539.495n 0.0v 539.505n 0.0v 549.495n 0.0v 549.505n 3.3v 559.495n 3.3v 559.505n 0.0v 569.495n 0.0v 569.505n 3.3v 579.495n 3.3v 579.505n 3.3v 589.495n 3.3v 589.505n 3.3v 599.495n 3.3v 599.505n 3.3v 609.495n 3.3v 609.505n 3.3v 619.495n 3.3v 619.505n 3.3v 629.495n 3.3v 629.505n 3.3v 639.495n 3.3v 639.505n 3.3v 649.495n 3.3v 649.505n 3.3v 659.495n 3.3v 659.505n 3.3v 669.495n 3.3v 669.505n 3.3v 679.495n 3.3v 679.505n 3.3v 689.495n 3.3v 689.505n 3.3v 699.495n 3.3v 699.505n 3.3v 709.495n 3.3v 709.505n 3.3v 719.495n 3.3v 719.505n 3.3v 729.495n 3.3v 729.505n 3.3v 739.495n 3.3v 739.505n 3.3v 749.495n 3.3v 749.505n 3.3v 759.495n 3.3v 759.505n 3.3v 769.495n 3.3v 769.505n 3.3v 779.495n 3.3v 779.505n 3.3v 789.495n 3.3v 789.505n 3.3v 799.495n 3.3v 799.505n 3.3v 809.495n 3.3v 809.505n 3.3v 819.495n 3.3v 819.505n 3.3v 829.495n 3.3v 829.505n 3.3v 839.495n 3.3v 839.505n 0.0v 849.495n 0.0v 849.505n 0.0v 859.495n 0.0v 859.505n 0.0v 869.495n 0.0v 869.505n 0.0v 879.495n 0.0v 879.505n 0.0v 889.495n 0.0v 889.505n 3.3v 899.495n 3.3v 899.505n 3.3v 909.495n 3.3v 909.505n 3.3v 919.495n 3.3v 919.505n 0.0v 929.495n 0.0v 929.505n 3.3v 939.495n 3.3v 939.505n 3.3v 949.495n 3.3v 949.505n 0.0v 959.495n 0.0v 959.505n 0.0v 969.495n 0.0v 969.505n 0.0v 979.495n 0.0v 979.505n 3.3v 989.495n 3.3v 989.505n 3.3v 999.495n 3.3v 999.505n 3.3v 1009.495n 3.3v 1009.505n 3.3v 1019.495n 3.3v 1019.505n 3.3v 1029.495n 3.3v 1029.505n 3.3v 1039.495n 3.3v 1039.505n 0.0v 1049.495n 0.0v 1049.505n 0.0v 1059.495n 0.0v 1059.505n 0.0v 1069.495n 0.0v 1069.505n 0.0v 1079.495n 0.0v 1079.505n 0.0v 1089.495n 0.0v 1089.505n 0.0v 1099.495n 0.0v 1099.505n 0.0v 1109.495n 0.0v 1109.505n 0.0v 1119.495n 0.0v 1119.505n 0.0v 1129.495n 0.0v 1129.505n 0.0v 1139.495n 0.0v 1139.505n 0.0v 1149.495n 0.0v 1149.505n 0.0v 1159.495n 0.0v 1159.505n 0.0v 1169.495n 0.0v 1169.505n 0.0v 1179.495n 0.0v 1179.505n 3.3v 1189.495n 3.3v 1189.505n 3.3v 1199.495n 3.3v 1199.505n 3.3v 1209.495n 3.3v 1209.505n 3.3v 1219.495n 3.3v 1219.505n 0.0v 1229.495n 0.0v 1229.505n 0.0v 1239.495n 0.0v 1239.505n 0.0v 1249.495n 0.0v 1249.505n 0.0v 1259.495n 0.0v 1259.505n 0.0v 1269.495n 0.0v 1269.505n 0.0v 1279.495n 0.0v 1279.505n 0.0v 1289.495n 0.0v 1289.505n 0.0v 1299.495n 0.0v 1299.505n 0.0v 1309.495n 0.0v 1309.505n 0.0v 1319.495n 0.0v 1319.505n 0.0v 1329.495n 0.0v 1329.505n 0.0v 1339.495n 0.0v 1339.505n 0.0v 1349.495n 0.0v 1349.505n 0.0v 1359.495n 0.0v 1359.505n 3.3v 1369.495n 3.3v 1369.505n 3.3v 1379.495n 3.3v 1379.505n 3.3v 1389.495n 3.3v 1389.505n 3.3v 1399.495n 3.3v 1399.505n 3.3v 1409.495n 3.3v 1409.505n 3.3v 1419.495n 3.3v 1419.505n 3.3v 1429.495n 3.3v 1429.505n 3.3v 1439.495n 3.3v 1439.505n 3.3v 1449.495n 3.3v 1449.505n 3.3v 1459.495n 3.3v 1459.505n 3.3v 1469.495n 3.3v 1469.505n 3.3v 1479.495n 3.3v 1479.505n 3.3v 1489.495n 3.3v 1489.505n 3.3v 1499.495n 3.3v 1499.505n 3.3v 1509.495n 3.3v 1509.505n 0.0v 1519.495n 0.0v 1519.505n 0.0v 1529.495n 0.0v 1529.505n 0.0v 1539.495n 0.0v 1539.505n 0.0v 1549.495n 0.0v 1549.505n 0.0v 1559.495n 0.0v 1559.505n 0.0v 1569.495n 0.0v 1569.505n 0.0v 1579.495n 0.0v 1579.505n 0.0v 1589.495n 0.0v 1589.505n 3.3v 1599.495n 3.3v 1599.505n 3.3v 1609.495n 3.3v 1609.505n 3.3v 1619.495n 3.3v 1619.505n 0.0v 1629.495n 0.0v 1629.505n 0.0v 1639.495n 0.0v 1639.505n 0.0v 1649.495n 0.0v 1649.505n 0.0v 1659.495n 0.0v 1659.505n 0.0v 1669.495n 0.0v 1669.505n 0.0v 1679.495n 0.0v 1679.505n 0.0v 1689.495n 0.0v 1689.505n 0.0v 1699.495n 0.0v 1699.505n 3.3v 1709.495n 3.3v 1709.505n 3.3v 1719.495n 3.3v 1719.505n 3.3v 1729.495n 3.3v 1729.505n 3.3v 1739.495n 3.3v 1739.505n 3.3v 1749.495n 3.3v 1749.505n 3.3v 1759.495n 3.3v 1759.505n 3.3v 1769.495n 3.3v 1769.505n 3.3v 1779.495n 3.3v 1779.505n 0.0v 1789.495n 0.0v 1789.505n 0.0v 1799.495n 0.0v 1799.505n 0.0v 1809.495n 0.0v 1809.505n 0.0v 1819.495n 0.0v 1819.505n 0.0v 1829.495n 0.0v 1829.505n 0.0v 1839.495n 0.0v 1839.505n 0.0v 1849.495n 0.0v 1849.505n 3.3v 1859.495n 3.3v 1859.505n 3.3v 1869.495n 3.3v 1869.505n 3.3v 1879.495n 3.3v 1879.505n 0.0v 1889.495n 0.0v 1889.505n 0.0v 1899.495n 0.0v 1899.505n 0.0v 1909.495n 0.0v 1909.505n 0.0v 1919.495n 0.0v 1919.505n 0.0v 1929.495n 0.0v 1929.505n 3.3v 1939.495n 3.3v 1939.505n 3.3v 1949.495n 3.3v 1949.505n 3.3v 1959.495n 3.3v 1959.505n 3.3v 1969.495n 3.3v 1969.505n 3.3v 1979.495n 3.3v 1979.505n 0.0v 1989.495n 0.0v 1989.505n 0.0v 1999.495n 0.0v 1999.505n 0.0v 2009.495n 0.0v 2009.505n 0.0v 2019.495n 0.0v 2019.505n 0.0v 2029.495n 0.0v 2029.505n 0.0v 2039.495n 0.0v 2039.505n 0.0v 2049.495n 0.0v 2049.505n 0.0v )
* (time, data): [(0, 0), (10, 0), (20, 0), (30, 0), (40, 0), (50, 0), (60, 0), (70, 0), (80, 0), (90, 0), (100, 0), (110, 0), (120, 1), (130, 1), (140, 0), (150, 0), (160, 0), (170, 1), (180, 0), (190, 1), (200, 0), (210, 1), (220, 0), (230, 0), (240, 0), (250, 1), (260, 1), (270, 0), (280, 0), (290, 0), (300, 0), (310, 0), (320, 0), (330, 0), (340, 0), (350, 0), (360, 0), (370, 0), (380, 0), (390, 0), (400, 0), (410, 0), (420, 1), (430, 1), (440, 1), (450, 0), (460, 0), (470, 0), (480, 0), (490, 0), (500, 1), (510, 1), (520, 0), (530, 0), (540, 0), (550, 0), (560, 0), (570, 1), (580, 1), (590, 1), (600, 1), (610, 1), (620, 1), (630, 1), (640, 1), (650, 0), (660, 0), (670, 0), (680, 0), (690, 0), (700, 0), (710, 0), (720, 0), (730, 0), (740, 1), (750, 1), (760, 1), (770, 1), (780, 1), (790, 1), (800, 1), (810, 1), (820, 1), (830, 1), (840, 0), (850, 0), (860, 0), (870, 0), (880, 0), (890, 0), (900, 0), (910, 0), (920, 1), (930, 1), (940, 1), (950, 0), (960, 0), (970, 0), (980, 0), (990, 0), (1000, 0), (1010, 0), (1020, 0), (1030, 1), (1040, 1), (1050, 1), (1060, 1), (1070, 1), (1080, 1), (1090, 1), (1100, 1), (1110, 1), (1120, 1), (1130, 1), (1140, 1), (1150, 1), (1160, 1), (1170, 1), (1180, 1), (1190, 1), (1200, 1), (1210, 1), (1220, 0), (1230, 0), (1240, 0), (1250, 0), (1260, 0), (1270, 0), (1280, 0), (1290, 0), (1300, 0), (1310, 0), (1320, 0), (1330, 0), (1340, 0), (1350, 0), (1360, 1), (1370, 0), (1380, 0), (1390, 0), (1400, 0), (1410, 0), (1420, 0), (1430, 0), (1440, 1), (1450, 1), (1460, 0), (1470, 0), (1480, 0), (1490, 0), (1500, 0), (1510, 0), (1520, 0), (1530, 0), (1540, 0), (1550, 0), (1560, 0), (1570, 0), (1580, 0), (1590, 0), (1600, 0), (1610, 0), (1620, 1), (1630, 1), (1640, 1), (1650, 1), (1660, 1), (1670, 1), (1680, 1), (1690, 1), (1700, 1), (1710, 0), (1720, 1), (1730, 1), (1740, 1), (1750, 1), (1760, 1), (1770, 1), (1780, 0), (1790, 0), (1800, 0), (1810, 0), (1820, 0), (1830, 0), (1840, 1), (1850, 0), (1860, 0), (1870, 0), (1880, 0), (1890, 0), (1900, 0), (1910, 0), (1920, 0), (1930, 0), (1940, 0), (1950, 0), (1960, 0), (1970, 0), (1980, 1), (1990, 1), (2000, 1), (2010, 0), (2020, 0), (2030, 0), (2040, 0), (2050, 0)]
Vdin0_3  din0_3  0 PWL (0n 0.0v 9.495n 0.0v 9.505n 0.0v 19.495n 0.0v 19.505n 0.0v 29.495n 0.0v 29.505n 0.0v 39.495n 0.0v 39.505n 0.0v 49.495n 0.0v 49.505n 0.0v 59.495n 0.0v 59.505n 0.0v 69.495n 0.0v 69.505n 0.0v 79.495n 0.0v 79.505n 0.0v 89.495n 0.0v 89.505n 0.0v 99.495n 0.0v 99.505n 0.0v 109.495n 0.0v 109.505n 0.0v 119.495n 0.0v 119.505n 3.3v 129.495n 3.3v 129.505n 3.3v 139.495n 3.3v 139.505n 0.0v 149.495n 0.0v 149.505n 0.0v 159.495n 0.0v 159.505n 0.0v 169.495n 0.0v 169.505n 3.3v 179.495n 3.3v 179.505n 0.0v 189.495n 0.0v 189.505n 3.3v 199.495n 3.3v 199.505n 0.0v 209.495n 0.0v 209.505n 3.3v 219.495n 3.3v 219.505n 0.0v 229.495n 0.0v 229.505n 0.0v 239.495n 0.0v 239.505n 0.0v 249.495n 0.0v 249.505n 3.3v 259.495n 3.3v 259.505n 3.3v 269.495n 3.3v 269.505n 0.0v 279.495n 0.0v 279.505n 0.0v 289.495n 0.0v 289.505n 0.0v 299.495n 0.0v 299.505n 0.0v 309.495n 0.0v 309.505n 0.0v 319.495n 0.0v 319.505n 0.0v 329.495n 0.0v 329.505n 0.0v 339.495n 0.0v 339.505n 0.0v 349.495n 0.0v 349.505n 0.0v 359.495n 0.0v 359.505n 0.0v 369.495n 0.0v 369.505n 0.0v 379.495n 0.0v 379.505n 0.0v 389.495n 0.0v 389.505n 0.0v 399.495n 0.0v 399.505n 0.0v 409.495n 0.0v 409.505n 0.0v 419.495n 0.0v 419.505n 3.3v 429.495n 3.3v 429.505n 3.3v 439.495n 3.3v 439.505n 3.3v 449.495n 3.3v 449.505n 0.0v 459.495n 0.0v 459.505n 0.0v 469.495n 0.0v 469.505n 0.0v 479.495n 0.0v 479.505n 0.0v 489.495n 0.0v 489.505n 0.0v 499.495n 0.0v 499.505n 3.3v 509.495n 3.3v 509.505n 3.3v 519.495n 3.3v 519.505n 0.0v 529.495n 0.0v 529.505n 0.0v 539.495n 0.0v 539.505n 0.0v 549.495n 0.0v 549.505n 0.0v 559.495n 0.0v 559.505n 0.0v 569.495n 0.0v 569.505n 3.3v 579.495n 3.3v 579.505n 3.3v 589.495n 3.3v 589.505n 3.3v 599.495n 3.3v 599.505n 3.3v 609.495n 3.3v 609.505n 3.3v 619.495n 3.3v 619.505n 3.3v 629.495n 3.3v 629.505n 3.3v 639.495n 3.3v 639.505n 3.3v 649.495n 3.3v 649.505n 0.0v 659.495n 0.0v 659.505n 0.0v 669.495n 0.0v 669.505n 0.0v 679.495n 0.0v 679.505n 0.0v 689.495n 0.0v 689.505n 0.0v 699.495n 0.0v 699.505n 0.0v 709.495n 0.0v 709.505n 0.0v 719.495n 0.0v 719.505n 0.0v 729.495n 0.0v 729.505n 0.0v 739.495n 0.0v 739.505n 3.3v 749.495n 3.3v 749.505n 3.3v 759.495n 3.3v 759.505n 3.3v 769.495n 3.3v 769.505n 3.3v 779.495n 3.3v 779.505n 3.3v 789.495n 3.3v 789.505n 3.3v 799.495n 3.3v 799.505n 3.3v 809.495n 3.3v 809.505n 3.3v 819.495n 3.3v 819.505n 3.3v 829.495n 3.3v 829.505n 3.3v 839.495n 3.3v 839.505n 0.0v 849.495n 0.0v 849.505n 0.0v 859.495n 0.0v 859.505n 0.0v 869.495n 0.0v 869.505n 0.0v 879.495n 0.0v 879.505n 0.0v 889.495n 0.0v 889.505n 0.0v 899.495n 0.0v 899.505n 0.0v 909.495n 0.0v 909.505n 0.0v 919.495n 0.0v 919.505n 3.3v 929.495n 3.3v 929.505n 3.3v 939.495n 3.3v 939.505n 3.3v 949.495n 3.3v 949.505n 0.0v 959.495n 0.0v 959.505n 0.0v 969.495n 0.0v 969.505n 0.0v 979.495n 0.0v 979.505n 0.0v 989.495n 0.0v 989.505n 0.0v 999.495n 0.0v 999.505n 0.0v 1009.495n 0.0v 1009.505n 0.0v 1019.495n 0.0v 1019.505n 0.0v 1029.495n 0.0v 1029.505n 3.3v 1039.495n 3.3v 1039.505n 3.3v 1049.495n 3.3v 1049.505n 3.3v 1059.495n 3.3v 1059.505n 3.3v 1069.495n 3.3v 1069.505n 3.3v 1079.495n 3.3v 1079.505n 3.3v 1089.495n 3.3v 1089.505n 3.3v 1099.495n 3.3v 1099.505n 3.3v 1109.495n 3.3v 1109.505n 3.3v 1119.495n 3.3v 1119.505n 3.3v 1129.495n 3.3v 1129.505n 3.3v 1139.495n 3.3v 1139.505n 3.3v 1149.495n 3.3v 1149.505n 3.3v 1159.495n 3.3v 1159.505n 3.3v 1169.495n 3.3v 1169.505n 3.3v 1179.495n 3.3v 1179.505n 3.3v 1189.495n 3.3v 1189.505n 3.3v 1199.495n 3.3v 1199.505n 3.3v 1209.495n 3.3v 1209.505n 3.3v 1219.495n 3.3v 1219.505n 0.0v 1229.495n 0.0v 1229.505n 0.0v 1239.495n 0.0v 1239.505n 0.0v 1249.495n 0.0v 1249.505n 0.0v 1259.495n 0.0v 1259.505n 0.0v 1269.495n 0.0v 1269.505n 0.0v 1279.495n 0.0v 1279.505n 0.0v 1289.495n 0.0v 1289.505n 0.0v 1299.495n 0.0v 1299.505n 0.0v 1309.495n 0.0v 1309.505n 0.0v 1319.495n 0.0v 1319.505n 0.0v 1329.495n 0.0v 1329.505n 0.0v 1339.495n 0.0v 1339.505n 0.0v 1349.495n 0.0v 1349.505n 0.0v 1359.495n 0.0v 1359.505n 3.3v 1369.495n 3.3v 1369.505n 0.0v 1379.495n 0.0v 1379.505n 0.0v 1389.495n 0.0v 1389.505n 0.0v 1399.495n 0.0v 1399.505n 0.0v 1409.495n 0.0v 1409.505n 0.0v 1419.495n 0.0v 1419.505n 0.0v 1429.495n 0.0v 1429.505n 0.0v 1439.495n 0.0v 1439.505n 3.3v 1449.495n 3.3v 1449.505n 3.3v 1459.495n 3.3v 1459.505n 0.0v 1469.495n 0.0v 1469.505n 0.0v 1479.495n 0.0v 1479.505n 0.0v 1489.495n 0.0v 1489.505n 0.0v 1499.495n 0.0v 1499.505n 0.0v 1509.495n 0.0v 1509.505n 0.0v 1519.495n 0.0v 1519.505n 0.0v 1529.495n 0.0v 1529.505n 0.0v 1539.495n 0.0v 1539.505n 0.0v 1549.495n 0.0v 1549.505n 0.0v 1559.495n 0.0v 1559.505n 0.0v 1569.495n 0.0v 1569.505n 0.0v 1579.495n 0.0v 1579.505n 0.0v 1589.495n 0.0v 1589.505n 0.0v 1599.495n 0.0v 1599.505n 0.0v 1609.495n 0.0v 1609.505n 0.0v 1619.495n 0.0v 1619.505n 3.3v 1629.495n 3.3v 1629.505n 3.3v 1639.495n 3.3v 1639.505n 3.3v 1649.495n 3.3v 1649.505n 3.3v 1659.495n 3.3v 1659.505n 3.3v 1669.495n 3.3v 1669.505n 3.3v 1679.495n 3.3v 1679.505n 3.3v 1689.495n 3.3v 1689.505n 3.3v 1699.495n 3.3v 1699.505n 3.3v 1709.495n 3.3v 1709.505n 0.0v 1719.495n 0.0v 1719.505n 3.3v 1729.495n 3.3v 1729.505n 3.3v 1739.495n 3.3v 1739.505n 3.3v 1749.495n 3.3v 1749.505n 3.3v 1759.495n 3.3v 1759.505n 3.3v 1769.495n 3.3v 1769.505n 3.3v 1779.495n 3.3v 1779.505n 0.0v 1789.495n 0.0v 1789.505n 0.0v 1799.495n 0.0v 1799.505n 0.0v 1809.495n 0.0v 1809.505n 0.0v 1819.495n 0.0v 1819.505n 0.0v 1829.495n 0.0v 1829.505n 0.0v 1839.495n 0.0v 1839.505n 3.3v 1849.495n 3.3v 1849.505n 0.0v 1859.495n 0.0v 1859.505n 0.0v 1869.495n 0.0v 1869.505n 0.0v 1879.495n 0.0v 1879.505n 0.0v 1889.495n 0.0v 1889.505n 0.0v 1899.495n 0.0v 1899.505n 0.0v 1909.495n 0.0v 1909.505n 0.0v 1919.495n 0.0v 1919.505n 0.0v 1929.495n 0.0v 1929.505n 0.0v 1939.495n 0.0v 1939.505n 0.0v 1949.495n 0.0v 1949.505n 0.0v 1959.495n 0.0v 1959.505n 0.0v 1969.495n 0.0v 1969.505n 0.0v 1979.495n 0.0v 1979.505n 3.3v 1989.495n 3.3v 1989.505n 3.3v 1999.495n 3.3v 1999.505n 3.3v 2009.495n 3.3v 2009.505n 0.0v 2019.495n 0.0v 2019.505n 0.0v 2029.495n 0.0v 2029.505n 0.0v 2039.495n 0.0v 2039.505n 0.0v 2049.495n 0.0v 2049.505n 0.0v )
* (time, data): [(0, 0), (10, 0), (20, 1), (30, 1), (40, 1), (50, 1), (60, 1), (70, 1), (80, 1), (90, 1), (100, 1), (110, 1), (120, 1), (130, 1), (140, 0), (150, 0), (160, 0), (170, 0), (180, 1), (190, 0), (200, 1), (210, 0), (220, 0), (230, 0), (240, 0), (250, 1), (260, 1), (270, 1), (280, 1), (290, 1), (300, 1), (310, 1), (320, 1), (330, 1), (340, 1), (350, 0), (360, 0), (370, 0), (380, 0), (390, 0), (400, 0), (410, 0), (420, 1), (430, 0), (440, 0), (450, 0), (460, 0), (470, 0), (480, 0), (490, 1), (500, 0), (510, 0), (520, 1), (530, 1), (540, 1), (550, 1), (560, 0), (570, 1), (580, 1), (590, 1), (600, 1), (610, 1), (620, 1), (630, 1), (640, 1), (650, 0), (660, 0), (670, 1), (680, 1), (690, 1), (700, 1), (710, 1), (720, 1), (730, 1), (740, 0), (750, 0), (760, 0), (770, 0), (780, 0), (790, 0), (800, 0), (810, 0), (820, 0), (830, 0), (840, 1), (850, 1), (860, 1), (870, 1), (880, 0), (890, 1), (900, 1), (910, 1), (920, 1), (930, 1), (940, 1), (950, 1), (960, 1), (970, 1), (980, 0), (990, 0), (1000, 0), (1010, 0), (1020, 0), (1030, 1), (1040, 1), (1050, 1), (1060, 1), (1070, 1), (1080, 1), (1090, 1), (1100, 1), (1110, 1), (1120, 1), (1130, 1), (1140, 1), (1150, 1), (1160, 1), (1170, 1), (1180, 0), (1190, 0), (1200, 0), (1210, 0), (1220, 0), (1230, 0), (1240, 0), (1250, 0), (1260, 1), (1270, 1), (1280, 1), (1290, 1), (1300, 1), (1310, 1), (1320, 1), (1330, 1), (1340, 1), (1350, 1), (1360, 0), (1370, 0), (1380, 0), (1390, 0), (1400, 0), (1410, 0), (1420, 0), (1430, 0), (1440, 1), (1450, 1), (1460, 1), (1470, 1), (1480, 1), (1490, 1), (1500, 1), (1510, 0), (1520, 0), (1530, 0), (1540, 0), (1550, 0), (1560, 0), (1570, 0), (1580, 0), (1590, 0), (1600, 0), (1610, 0), (1620, 0), (1630, 0), (1640, 0), (1650, 0), (1660, 1), (1670, 1), (1680, 1), (1690, 1), (1700, 1), (1710, 1), (1720, 1), (1730, 1), (1740, 1), (1750, 1), (1760, 1), (1770, 1), (1780, 1), (1790, 1), (1800, 1), (1810, 1), (1820, 1), (1830, 1), (1840, 1), (1850, 1), (1860, 1), (1870, 1), (1880, 1), (1890, 0), (1900, 0), (1910, 0), (1920, 0), (1930, 0), (1940, 0), (1950, 0), (1960, 0), (1970, 0), (1980, 0), (1990, 0), (2000, 0), (2010, 1), (2020, 1), (2030, 1), (2040, 1), (2050, 1)]
Vdin0_4  din0_4  0 PWL (0n 0.0v 9.495n 0.0v 9.505n 0.0v 19.495n 0.0v 19.505n 3.3v 29.495n 3.3v 29.505n 3.3v 39.495n 3.3v 39.505n 3.3v 49.495n 3.3v 49.505n 3.3v 59.495n 3.3v 59.505n 3.3v 69.495n 3.3v 69.505n 3.3v 79.495n 3.3v 79.505n 3.3v 89.495n 3.3v 89.505n 3.3v 99.495n 3.3v 99.505n 3.3v 109.495n 3.3v 109.505n 3.3v 119.495n 3.3v 119.505n 3.3v 129.495n 3.3v 129.505n 3.3v 139.495n 3.3v 139.505n 0.0v 149.495n 0.0v 149.505n 0.0v 159.495n 0.0v 159.505n 0.0v 169.495n 0.0v 169.505n 0.0v 179.495n 0.0v 179.505n 3.3v 189.495n 3.3v 189.505n 0.0v 199.495n 0.0v 199.505n 3.3v 209.495n 3.3v 209.505n 0.0v 219.495n 0.0v 219.505n 0.0v 229.495n 0.0v 229.505n 0.0v 239.495n 0.0v 239.505n 0.0v 249.495n 0.0v 249.505n 3.3v 259.495n 3.3v 259.505n 3.3v 269.495n 3.3v 269.505n 3.3v 279.495n 3.3v 279.505n 3.3v 289.495n 3.3v 289.505n 3.3v 299.495n 3.3v 299.505n 3.3v 309.495n 3.3v 309.505n 3.3v 319.495n 3.3v 319.505n 3.3v 329.495n 3.3v 329.505n 3.3v 339.495n 3.3v 339.505n 3.3v 349.495n 3.3v 349.505n 0.0v 359.495n 0.0v 359.505n 0.0v 369.495n 0.0v 369.505n 0.0v 379.495n 0.0v 379.505n 0.0v 389.495n 0.0v 389.505n 0.0v 399.495n 0.0v 399.505n 0.0v 409.495n 0.0v 409.505n 0.0v 419.495n 0.0v 419.505n 3.3v 429.495n 3.3v 429.505n 0.0v 439.495n 0.0v 439.505n 0.0v 449.495n 0.0v 449.505n 0.0v 459.495n 0.0v 459.505n 0.0v 469.495n 0.0v 469.505n 0.0v 479.495n 0.0v 479.505n 0.0v 489.495n 0.0v 489.505n 3.3v 499.495n 3.3v 499.505n 0.0v 509.495n 0.0v 509.505n 0.0v 519.495n 0.0v 519.505n 3.3v 529.495n 3.3v 529.505n 3.3v 539.495n 3.3v 539.505n 3.3v 549.495n 3.3v 549.505n 3.3v 559.495n 3.3v 559.505n 0.0v 569.495n 0.0v 569.505n 3.3v 579.495n 3.3v 579.505n 3.3v 589.495n 3.3v 589.505n 3.3v 599.495n 3.3v 599.505n 3.3v 609.495n 3.3v 609.505n 3.3v 619.495n 3.3v 619.505n 3.3v 629.495n 3.3v 629.505n 3.3v 639.495n 3.3v 639.505n 3.3v 649.495n 3.3v 649.505n 0.0v 659.495n 0.0v 659.505n 0.0v 669.495n 0.0v 669.505n 3.3v 679.495n 3.3v 679.505n 3.3v 689.495n 3.3v 689.505n 3.3v 699.495n 3.3v 699.505n 3.3v 709.495n 3.3v 709.505n 3.3v 719.495n 3.3v 719.505n 3.3v 729.495n 3.3v 729.505n 3.3v 739.495n 3.3v 739.505n 0.0v 749.495n 0.0v 749.505n 0.0v 759.495n 0.0v 759.505n 0.0v 769.495n 0.0v 769.505n 0.0v 779.495n 0.0v 779.505n 0.0v 789.495n 0.0v 789.505n 0.0v 799.495n 0.0v 799.505n 0.0v 809.495n 0.0v 809.505n 0.0v 819.495n 0.0v 819.505n 0.0v 829.495n 0.0v 829.505n 0.0v 839.495n 0.0v 839.505n 3.3v 849.495n 3.3v 849.505n 3.3v 859.495n 3.3v 859.505n 3.3v 869.495n 3.3v 869.505n 3.3v 879.495n 3.3v 879.505n 0.0v 889.495n 0.0v 889.505n 3.3v 899.495n 3.3v 899.505n 3.3v 909.495n 3.3v 909.505n 3.3v 919.495n 3.3v 919.505n 3.3v 929.495n 3.3v 929.505n 3.3v 939.495n 3.3v 939.505n 3.3v 949.495n 3.3v 949.505n 3.3v 959.495n 3.3v 959.505n 3.3v 969.495n 3.3v 969.505n 3.3v 979.495n 3.3v 979.505n 0.0v 989.495n 0.0v 989.505n 0.0v 999.495n 0.0v 999.505n 0.0v 1009.495n 0.0v 1009.505n 0.0v 1019.495n 0.0v 1019.505n 0.0v 1029.495n 0.0v 1029.505n 3.3v 1039.495n 3.3v 1039.505n 3.3v 1049.495n 3.3v 1049.505n 3.3v 1059.495n 3.3v 1059.505n 3.3v 1069.495n 3.3v 1069.505n 3.3v 1079.495n 3.3v 1079.505n 3.3v 1089.495n 3.3v 1089.505n 3.3v 1099.495n 3.3v 1099.505n 3.3v 1109.495n 3.3v 1109.505n 3.3v 1119.495n 3.3v 1119.505n 3.3v 1129.495n 3.3v 1129.505n 3.3v 1139.495n 3.3v 1139.505n 3.3v 1149.495n 3.3v 1149.505n 3.3v 1159.495n 3.3v 1159.505n 3.3v 1169.495n 3.3v 1169.505n 3.3v 1179.495n 3.3v 1179.505n 0.0v 1189.495n 0.0v 1189.505n 0.0v 1199.495n 0.0v 1199.505n 0.0v 1209.495n 0.0v 1209.505n 0.0v 1219.495n 0.0v 1219.505n 0.0v 1229.495n 0.0v 1229.505n 0.0v 1239.495n 0.0v 1239.505n 0.0v 1249.495n 0.0v 1249.505n 0.0v 1259.495n 0.0v 1259.505n 3.3v 1269.495n 3.3v 1269.505n 3.3v 1279.495n 3.3v 1279.505n 3.3v 1289.495n 3.3v 1289.505n 3.3v 1299.495n 3.3v 1299.505n 3.3v 1309.495n 3.3v 1309.505n 3.3v 1319.495n 3.3v 1319.505n 3.3v 1329.495n 3.3v 1329.505n 3.3v 1339.495n 3.3v 1339.505n 3.3v 1349.495n 3.3v 1349.505n 3.3v 1359.495n 3.3v 1359.505n 0.0v 1369.495n 0.0v 1369.505n 0.0v 1379.495n 0.0v 1379.505n 0.0v 1389.495n 0.0v 1389.505n 0.0v 1399.495n 0.0v 1399.505n 0.0v 1409.495n 0.0v 1409.505n 0.0v 1419.495n 0.0v 1419.505n 0.0v 1429.495n 0.0v 1429.505n 0.0v 1439.495n 0.0v 1439.505n 3.3v 1449.495n 3.3v 1449.505n 3.3v 1459.495n 3.3v 1459.505n 3.3v 1469.495n 3.3v 1469.505n 3.3v 1479.495n 3.3v 1479.505n 3.3v 1489.495n 3.3v 1489.505n 3.3v 1499.495n 3.3v 1499.505n 3.3v 1509.495n 3.3v 1509.505n 0.0v 1519.495n 0.0v 1519.505n 0.0v 1529.495n 0.0v 1529.505n 0.0v 1539.495n 0.0v 1539.505n 0.0v 1549.495n 0.0v 1549.505n 0.0v 1559.495n 0.0v 1559.505n 0.0v 1569.495n 0.0v 1569.505n 0.0v 1579.495n 0.0v 1579.505n 0.0v 1589.495n 0.0v 1589.505n 0.0v 1599.495n 0.0v 1599.505n 0.0v 1609.495n 0.0v 1609.505n 0.0v 1619.495n 0.0v 1619.505n 0.0v 1629.495n 0.0v 1629.505n 0.0v 1639.495n 0.0v 1639.505n 0.0v 1649.495n 0.0v 1649.505n 0.0v 1659.495n 0.0v 1659.505n 3.3v 1669.495n 3.3v 1669.505n 3.3v 1679.495n 3.3v 1679.505n 3.3v 1689.495n 3.3v 1689.505n 3.3v 1699.495n 3.3v 1699.505n 3.3v 1709.495n 3.3v 1709.505n 3.3v 1719.495n 3.3v 1719.505n 3.3v 1729.495n 3.3v 1729.505n 3.3v 1739.495n 3.3v 1739.505n 3.3v 1749.495n 3.3v 1749.505n 3.3v 1759.495n 3.3v 1759.505n 3.3v 1769.495n 3.3v 1769.505n 3.3v 1779.495n 3.3v 1779.505n 3.3v 1789.495n 3.3v 1789.505n 3.3v 1799.495n 3.3v 1799.505n 3.3v 1809.495n 3.3v 1809.505n 3.3v 1819.495n 3.3v 1819.505n 3.3v 1829.495n 3.3v 1829.505n 3.3v 1839.495n 3.3v 1839.505n 3.3v 1849.495n 3.3v 1849.505n 3.3v 1859.495n 3.3v 1859.505n 3.3v 1869.495n 3.3v 1869.505n 3.3v 1879.495n 3.3v 1879.505n 3.3v 1889.495n 3.3v 1889.505n 0.0v 1899.495n 0.0v 1899.505n 0.0v 1909.495n 0.0v 1909.505n 0.0v 1919.495n 0.0v 1919.505n 0.0v 1929.495n 0.0v 1929.505n 0.0v 1939.495n 0.0v 1939.505n 0.0v 1949.495n 0.0v 1949.505n 0.0v 1959.495n 0.0v 1959.505n 0.0v 1969.495n 0.0v 1969.505n 0.0v 1979.495n 0.0v 1979.505n 0.0v 1989.495n 0.0v 1989.505n 0.0v 1999.495n 0.0v 1999.505n 0.0v 2009.495n 0.0v 2009.505n 3.3v 2019.495n 3.3v 2019.505n 3.3v 2029.495n 3.3v 2029.505n 3.3v 2039.495n 3.3v 2039.505n 3.3v 2049.495n 3.3v 2049.505n 3.3v )
* (time, data): [(0, 0), (10, 0), (20, 1), (30, 0), (40, 0), (50, 0), (60, 0), (70, 0), (80, 0), (90, 0), (100, 0), (110, 0), (120, 0), (130, 0), (140, 0), (150, 0), (160, 0), (170, 0), (180, 1), (190, 0), (200, 0), (210, 0), (220, 1), (230, 1), (240, 1), (250, 0), (260, 0), (270, 0), (280, 0), (290, 0), (300, 0), (310, 1), (320, 1), (330, 1), (340, 1), (350, 0), (360, 0), (370, 0), (380, 0), (390, 0), (400, 0), (410, 0), (420, 1), (430, 0), (440, 0), (450, 0), (460, 0), (470, 0), (480, 0), (490, 1), (500, 1), (510, 1), (520, 0), (530, 0), (540, 0), (550, 0), (560, 0), (570, 1), (580, 1), (590, 1), (600, 1), (610, 1), (620, 1), (630, 1), (640, 1), (650, 0), (660, 0), (670, 1), (680, 1), (690, 1), (700, 1), (710, 1), (720, 1), (730, 1), (740, 0), (750, 0), (760, 0), (770, 0), (780, 0), (790, 0), (800, 0), (810, 0), (820, 0), (830, 0), (840, 1), (850, 1), (860, 1), (870, 1), (880, 1), (890, 0), (900, 0), (910, 0), (920, 1), (930, 1), (940, 1), (950, 0), (960, 0), (970, 0), (980, 1), (990, 1), (1000, 1), (1010, 1), (1020, 1), (1030, 1), (1040, 0), (1050, 0), (1060, 0), (1070, 0), (1080, 0), (1090, 0), (1100, 0), (1110, 1), (1120, 1), (1130, 1), (1140, 1), (1150, 1), (1160, 1), (1170, 1), (1180, 1), (1190, 1), (1200, 1), (1210, 1), (1220, 1), (1230, 1), (1240, 1), (1250, 1), (1260, 0), (1270, 0), (1280, 0), (1290, 0), (1300, 0), (1310, 0), (1320, 0), (1330, 0), (1340, 0), (1350, 0), (1360, 0), (1370, 1), (1380, 1), (1390, 1), (1400, 1), (1410, 1), (1420, 1), (1430, 1), (1440, 0), (1450, 0), (1460, 1), (1470, 1), (1480, 1), (1490, 1), (1500, 0), (1510, 0), (1520, 0), (1530, 0), (1540, 0), (1550, 0), (1560, 0), (1570, 0), (1580, 0), (1590, 1), (1600, 1), (1610, 1), (1620, 1), (1630, 1), (1640, 1), (1650, 1), (1660, 1), (1670, 1), (1680, 1), (1690, 1), (1700, 1), (1710, 1), (1720, 0), (1730, 0), (1740, 0), (1750, 0), (1760, 0), (1770, 0), (1780, 1), (1790, 1), (1800, 1), (1810, 1), (1820, 1), (1830, 1), (1840, 1), (1850, 1), (1860, 1), (1870, 1), (1880, 1), (1890, 1), (1900, 1), (1910, 1), (1920, 1), (1930, 1), (1940, 1), (1950, 1), (1960, 1), (1970, 1), (1980, 1), (1990, 1), (2000, 1), (2010, 1), (2020, 1), (2030, 1), (2040, 1), (2050, 1)]
Vdin0_5  din0_5  0 PWL (0n 0.0v 9.495n 0.0v 9.505n 0.0v 19.495n 0.0v 19.505n 3.3v 29.495n 3.3v 29.505n 0.0v 39.495n 0.0v 39.505n 0.0v 49.495n 0.0v 49.505n 0.0v 59.495n 0.0v 59.505n 0.0v 69.495n 0.0v 69.505n 0.0v 79.495n 0.0v 79.505n 0.0v 89.495n 0.0v 89.505n 0.0v 99.495n 0.0v 99.505n 0.0v 109.495n 0.0v 109.505n 0.0v 119.495n 0.0v 119.505n 0.0v 129.495n 0.0v 129.505n 0.0v 139.495n 0.0v 139.505n 0.0v 149.495n 0.0v 149.505n 0.0v 159.495n 0.0v 159.505n 0.0v 169.495n 0.0v 169.505n 0.0v 179.495n 0.0v 179.505n 3.3v 189.495n 3.3v 189.505n 0.0v 199.495n 0.0v 199.505n 0.0v 209.495n 0.0v 209.505n 0.0v 219.495n 0.0v 219.505n 3.3v 229.495n 3.3v 229.505n 3.3v 239.495n 3.3v 239.505n 3.3v 249.495n 3.3v 249.505n 0.0v 259.495n 0.0v 259.505n 0.0v 269.495n 0.0v 269.505n 0.0v 279.495n 0.0v 279.505n 0.0v 289.495n 0.0v 289.505n 0.0v 299.495n 0.0v 299.505n 0.0v 309.495n 0.0v 309.505n 3.3v 319.495n 3.3v 319.505n 3.3v 329.495n 3.3v 329.505n 3.3v 339.495n 3.3v 339.505n 3.3v 349.495n 3.3v 349.505n 0.0v 359.495n 0.0v 359.505n 0.0v 369.495n 0.0v 369.505n 0.0v 379.495n 0.0v 379.505n 0.0v 389.495n 0.0v 389.505n 0.0v 399.495n 0.0v 399.505n 0.0v 409.495n 0.0v 409.505n 0.0v 419.495n 0.0v 419.505n 3.3v 429.495n 3.3v 429.505n 0.0v 439.495n 0.0v 439.505n 0.0v 449.495n 0.0v 449.505n 0.0v 459.495n 0.0v 459.505n 0.0v 469.495n 0.0v 469.505n 0.0v 479.495n 0.0v 479.505n 0.0v 489.495n 0.0v 489.505n 3.3v 499.495n 3.3v 499.505n 3.3v 509.495n 3.3v 509.505n 3.3v 519.495n 3.3v 519.505n 0.0v 529.495n 0.0v 529.505n 0.0v 539.495n 0.0v 539.505n 0.0v 549.495n 0.0v 549.505n 0.0v 559.495n 0.0v 559.505n 0.0v 569.495n 0.0v 569.505n 3.3v 579.495n 3.3v 579.505n 3.3v 589.495n 3.3v 589.505n 3.3v 599.495n 3.3v 599.505n 3.3v 609.495n 3.3v 609.505n 3.3v 619.495n 3.3v 619.505n 3.3v 629.495n 3.3v 629.505n 3.3v 639.495n 3.3v 639.505n 3.3v 649.495n 3.3v 649.505n 0.0v 659.495n 0.0v 659.505n 0.0v 669.495n 0.0v 669.505n 3.3v 679.495n 3.3v 679.505n 3.3v 689.495n 3.3v 689.505n 3.3v 699.495n 3.3v 699.505n 3.3v 709.495n 3.3v 709.505n 3.3v 719.495n 3.3v 719.505n 3.3v 729.495n 3.3v 729.505n 3.3v 739.495n 3.3v 739.505n 0.0v 749.495n 0.0v 749.505n 0.0v 759.495n 0.0v 759.505n 0.0v 769.495n 0.0v 769.505n 0.0v 779.495n 0.0v 779.505n 0.0v 789.495n 0.0v 789.505n 0.0v 799.495n 0.0v 799.505n 0.0v 809.495n 0.0v 809.505n 0.0v 819.495n 0.0v 819.505n 0.0v 829.495n 0.0v 829.505n 0.0v 839.495n 0.0v 839.505n 3.3v 849.495n 3.3v 849.505n 3.3v 859.495n 3.3v 859.505n 3.3v 869.495n 3.3v 869.505n 3.3v 879.495n 3.3v 879.505n 3.3v 889.495n 3.3v 889.505n 0.0v 899.495n 0.0v 899.505n 0.0v 909.495n 0.0v 909.505n 0.0v 919.495n 0.0v 919.505n 3.3v 929.495n 3.3v 929.505n 3.3v 939.495n 3.3v 939.505n 3.3v 949.495n 3.3v 949.505n 0.0v 959.495n 0.0v 959.505n 0.0v 969.495n 0.0v 969.505n 0.0v 979.495n 0.0v 979.505n 3.3v 989.495n 3.3v 989.505n 3.3v 999.495n 3.3v 999.505n 3.3v 1009.495n 3.3v 1009.505n 3.3v 1019.495n 3.3v 1019.505n 3.3v 1029.495n 3.3v 1029.505n 3.3v 1039.495n 3.3v 1039.505n 0.0v 1049.495n 0.0v 1049.505n 0.0v 1059.495n 0.0v 1059.505n 0.0v 1069.495n 0.0v 1069.505n 0.0v 1079.495n 0.0v 1079.505n 0.0v 1089.495n 0.0v 1089.505n 0.0v 1099.495n 0.0v 1099.505n 0.0v 1109.495n 0.0v 1109.505n 3.3v 1119.495n 3.3v 1119.505n 3.3v 1129.495n 3.3v 1129.505n 3.3v 1139.495n 3.3v 1139.505n 3.3v 1149.495n 3.3v 1149.505n 3.3v 1159.495n 3.3v 1159.505n 3.3v 1169.495n 3.3v 1169.505n 3.3v 1179.495n 3.3v 1179.505n 3.3v 1189.495n 3.3v 1189.505n 3.3v 1199.495n 3.3v 1199.505n 3.3v 1209.495n 3.3v 1209.505n 3.3v 1219.495n 3.3v 1219.505n 3.3v 1229.495n 3.3v 1229.505n 3.3v 1239.495n 3.3v 1239.505n 3.3v 1249.495n 3.3v 1249.505n 3.3v 1259.495n 3.3v 1259.505n 0.0v 1269.495n 0.0v 1269.505n 0.0v 1279.495n 0.0v 1279.505n 0.0v 1289.495n 0.0v 1289.505n 0.0v 1299.495n 0.0v 1299.505n 0.0v 1309.495n 0.0v 1309.505n 0.0v 1319.495n 0.0v 1319.505n 0.0v 1329.495n 0.0v 1329.505n 0.0v 1339.495n 0.0v 1339.505n 0.0v 1349.495n 0.0v 1349.505n 0.0v 1359.495n 0.0v 1359.505n 0.0v 1369.495n 0.0v 1369.505n 3.3v 1379.495n 3.3v 1379.505n 3.3v 1389.495n 3.3v 1389.505n 3.3v 1399.495n 3.3v 1399.505n 3.3v 1409.495n 3.3v 1409.505n 3.3v 1419.495n 3.3v 1419.505n 3.3v 1429.495n 3.3v 1429.505n 3.3v 1439.495n 3.3v 1439.505n 0.0v 1449.495n 0.0v 1449.505n 0.0v 1459.495n 0.0v 1459.505n 3.3v 1469.495n 3.3v 1469.505n 3.3v 1479.495n 3.3v 1479.505n 3.3v 1489.495n 3.3v 1489.505n 3.3v 1499.495n 3.3v 1499.505n 0.0v 1509.495n 0.0v 1509.505n 0.0v 1519.495n 0.0v 1519.505n 0.0v 1529.495n 0.0v 1529.505n 0.0v 1539.495n 0.0v 1539.505n 0.0v 1549.495n 0.0v 1549.505n 0.0v 1559.495n 0.0v 1559.505n 0.0v 1569.495n 0.0v 1569.505n 0.0v 1579.495n 0.0v 1579.505n 0.0v 1589.495n 0.0v 1589.505n 3.3v 1599.495n 3.3v 1599.505n 3.3v 1609.495n 3.3v 1609.505n 3.3v 1619.495n 3.3v 1619.505n 3.3v 1629.495n 3.3v 1629.505n 3.3v 1639.495n 3.3v 1639.505n 3.3v 1649.495n 3.3v 1649.505n 3.3v 1659.495n 3.3v 1659.505n 3.3v 1669.495n 3.3v 1669.505n 3.3v 1679.495n 3.3v 1679.505n 3.3v 1689.495n 3.3v 1689.505n 3.3v 1699.495n 3.3v 1699.505n 3.3v 1709.495n 3.3v 1709.505n 3.3v 1719.495n 3.3v 1719.505n 0.0v 1729.495n 0.0v 1729.505n 0.0v 1739.495n 0.0v 1739.505n 0.0v 1749.495n 0.0v 1749.505n 0.0v 1759.495n 0.0v 1759.505n 0.0v 1769.495n 0.0v 1769.505n 0.0v 1779.495n 0.0v 1779.505n 3.3v 1789.495n 3.3v 1789.505n 3.3v 1799.495n 3.3v 1799.505n 3.3v 1809.495n 3.3v 1809.505n 3.3v 1819.495n 3.3v 1819.505n 3.3v 1829.495n 3.3v 1829.505n 3.3v 1839.495n 3.3v 1839.505n 3.3v 1849.495n 3.3v 1849.505n 3.3v 1859.495n 3.3v 1859.505n 3.3v 1869.495n 3.3v 1869.505n 3.3v 1879.495n 3.3v 1879.505n 3.3v 1889.495n 3.3v 1889.505n 3.3v 1899.495n 3.3v 1899.505n 3.3v 1909.495n 3.3v 1909.505n 3.3v 1919.495n 3.3v 1919.505n 3.3v 1929.495n 3.3v 1929.505n 3.3v 1939.495n 3.3v 1939.505n 3.3v 1949.495n 3.3v 1949.505n 3.3v 1959.495n 3.3v 1959.505n 3.3v 1969.495n 3.3v 1969.505n 3.3v 1979.495n 3.3v 1979.505n 3.3v 1989.495n 3.3v 1989.505n 3.3v 1999.495n 3.3v 1999.505n 3.3v 2009.495n 3.3v 2009.505n 3.3v 2019.495n 3.3v 2019.505n 3.3v 2029.495n 3.3v 2029.505n 3.3v 2039.495n 3.3v 2039.505n 3.3v 2049.495n 3.3v 2049.505n 3.3v )
* (time, data): [(0, 0), (10, 1), (20, 1), (30, 1), (40, 1), (50, 1), (60, 1), (70, 1), (80, 1), (90, 1), (100, 1), (110, 1), (120, 0), (130, 0), (140, 0), (150, 1), (160, 1), (170, 1), (180, 1), (190, 0), (200, 1), (210, 0), (220, 0), (230, 0), (240, 0), (250, 1), (260, 1), (270, 1), (280, 1), (290, 1), (300, 1), (310, 0), (320, 1), (330, 1), (340, 1), (350, 1), (360, 1), (370, 1), (380, 1), (390, 1), (400, 1), (410, 1), (420, 0), (430, 0), (440, 0), (450, 0), (460, 0), (470, 0), (480, 0), (490, 0), (500, 1), (510, 0), (520, 1), (530, 1), (540, 1), (550, 1), (560, 1), (570, 1), (580, 1), (590, 1), (600, 1), (610, 1), (620, 1), (630, 1), (640, 1), (650, 0), (660, 0), (670, 1), (680, 1), (690, 1), (700, 1), (710, 1), (720, 1), (730, 1), (740, 0), (750, 0), (760, 0), (770, 0), (780, 0), (790, 0), (800, 0), (810, 0), (820, 0), (830, 0), (840, 1), (850, 1), (860, 1), (870, 1), (880, 0), (890, 0), (900, 0), (910, 0), (920, 1), (930, 1), (940, 1), (950, 0), (960, 0), (970, 0), (980, 0), (990, 0), (1000, 0), (1010, 0), (1020, 0), (1030, 0), (1040, 0), (1050, 0), (1060, 0), (1070, 0), (1080, 0), (1090, 0), (1100, 0), (1110, 0), (1120, 0), (1130, 0), (1140, 0), (1150, 0), (1160, 0), (1170, 0), (1180, 0), (1190, 0), (1200, 0), (1210, 0), (1220, 0), (1230, 0), (1240, 0), (1250, 0), (1260, 1), (1270, 1), (1280, 1), (1290, 1), (1300, 1), (1310, 1), (1320, 1), (1330, 1), (1340, 1), (1350, 1), (1360, 0), (1370, 1), (1380, 1), (1390, 1), (1400, 1), (1410, 1), (1420, 1), (1430, 1), (1440, 1), (1450, 1), (1460, 0), (1470, 0), (1480, 0), (1490, 0), (1500, 1), (1510, 0), (1520, 0), (1530, 1), (1540, 1), (1550, 1), (1560, 1), (1570, 1), (1580, 1), (1590, 0), (1600, 0), (1610, 0), (1620, 0), (1630, 0), (1640, 0), (1650, 0), (1660, 0), (1670, 0), (1680, 0), (1690, 0), (1700, 0), (1710, 0), (1720, 0), (1730, 0), (1740, 0), (1750, 0), (1760, 0), (1770, 0), (1780, 1), (1790, 1), (1800, 1), (1810, 1), (1820, 1), (1830, 1), (1840, 0), (1850, 1), (1860, 1), (1870, 1), (1880, 1), (1890, 1), (1900, 1), (1910, 1), (1920, 1), (1930, 1), (1940, 1), (1950, 1), (1960, 1), (1970, 1), (1980, 1), (1990, 1), (2000, 1), (2010, 0), (2020, 0), (2030, 0), (2040, 0), (2050, 0)]
Vdin0_6  din0_6  0 PWL (0n 0.0v 9.495n 0.0v 9.505n 3.3v 19.495n 3.3v 19.505n 3.3v 29.495n 3.3v 29.505n 3.3v 39.495n 3.3v 39.505n 3.3v 49.495n 3.3v 49.505n 3.3v 59.495n 3.3v 59.505n 3.3v 69.495n 3.3v 69.505n 3.3v 79.495n 3.3v 79.505n 3.3v 89.495n 3.3v 89.505n 3.3v 99.495n 3.3v 99.505n 3.3v 109.495n 3.3v 109.505n 3.3v 119.495n 3.3v 119.505n 0.0v 129.495n 0.0v 129.505n 0.0v 139.495n 0.0v 139.505n 0.0v 149.495n 0.0v 149.505n 3.3v 159.495n 3.3v 159.505n 3.3v 169.495n 3.3v 169.505n 3.3v 179.495n 3.3v 179.505n 3.3v 189.495n 3.3v 189.505n 0.0v 199.495n 0.0v 199.505n 3.3v 209.495n 3.3v 209.505n 0.0v 219.495n 0.0v 219.505n 0.0v 229.495n 0.0v 229.505n 0.0v 239.495n 0.0v 239.505n 0.0v 249.495n 0.0v 249.505n 3.3v 259.495n 3.3v 259.505n 3.3v 269.495n 3.3v 269.505n 3.3v 279.495n 3.3v 279.505n 3.3v 289.495n 3.3v 289.505n 3.3v 299.495n 3.3v 299.505n 3.3v 309.495n 3.3v 309.505n 0.0v 319.495n 0.0v 319.505n 3.3v 329.495n 3.3v 329.505n 3.3v 339.495n 3.3v 339.505n 3.3v 349.495n 3.3v 349.505n 3.3v 359.495n 3.3v 359.505n 3.3v 369.495n 3.3v 369.505n 3.3v 379.495n 3.3v 379.505n 3.3v 389.495n 3.3v 389.505n 3.3v 399.495n 3.3v 399.505n 3.3v 409.495n 3.3v 409.505n 3.3v 419.495n 3.3v 419.505n 0.0v 429.495n 0.0v 429.505n 0.0v 439.495n 0.0v 439.505n 0.0v 449.495n 0.0v 449.505n 0.0v 459.495n 0.0v 459.505n 0.0v 469.495n 0.0v 469.505n 0.0v 479.495n 0.0v 479.505n 0.0v 489.495n 0.0v 489.505n 0.0v 499.495n 0.0v 499.505n 3.3v 509.495n 3.3v 509.505n 0.0v 519.495n 0.0v 519.505n 3.3v 529.495n 3.3v 529.505n 3.3v 539.495n 3.3v 539.505n 3.3v 549.495n 3.3v 549.505n 3.3v 559.495n 3.3v 559.505n 3.3v 569.495n 3.3v 569.505n 3.3v 579.495n 3.3v 579.505n 3.3v 589.495n 3.3v 589.505n 3.3v 599.495n 3.3v 599.505n 3.3v 609.495n 3.3v 609.505n 3.3v 619.495n 3.3v 619.505n 3.3v 629.495n 3.3v 629.505n 3.3v 639.495n 3.3v 639.505n 3.3v 649.495n 3.3v 649.505n 0.0v 659.495n 0.0v 659.505n 0.0v 669.495n 0.0v 669.505n 3.3v 679.495n 3.3v 679.505n 3.3v 689.495n 3.3v 689.505n 3.3v 699.495n 3.3v 699.505n 3.3v 709.495n 3.3v 709.505n 3.3v 719.495n 3.3v 719.505n 3.3v 729.495n 3.3v 729.505n 3.3v 739.495n 3.3v 739.505n 0.0v 749.495n 0.0v 749.505n 0.0v 759.495n 0.0v 759.505n 0.0v 769.495n 0.0v 769.505n 0.0v 779.495n 0.0v 779.505n 0.0v 789.495n 0.0v 789.505n 0.0v 799.495n 0.0v 799.505n 0.0v 809.495n 0.0v 809.505n 0.0v 819.495n 0.0v 819.505n 0.0v 829.495n 0.0v 829.505n 0.0v 839.495n 0.0v 839.505n 3.3v 849.495n 3.3v 849.505n 3.3v 859.495n 3.3v 859.505n 3.3v 869.495n 3.3v 869.505n 3.3v 879.495n 3.3v 879.505n 0.0v 889.495n 0.0v 889.505n 0.0v 899.495n 0.0v 899.505n 0.0v 909.495n 0.0v 909.505n 0.0v 919.495n 0.0v 919.505n 3.3v 929.495n 3.3v 929.505n 3.3v 939.495n 3.3v 939.505n 3.3v 949.495n 3.3v 949.505n 0.0v 959.495n 0.0v 959.505n 0.0v 969.495n 0.0v 969.505n 0.0v 979.495n 0.0v 979.505n 0.0v 989.495n 0.0v 989.505n 0.0v 999.495n 0.0v 999.505n 0.0v 1009.495n 0.0v 1009.505n 0.0v 1019.495n 0.0v 1019.505n 0.0v 1029.495n 0.0v 1029.505n 0.0v 1039.495n 0.0v 1039.505n 0.0v 1049.495n 0.0v 1049.505n 0.0v 1059.495n 0.0v 1059.505n 0.0v 1069.495n 0.0v 1069.505n 0.0v 1079.495n 0.0v 1079.505n 0.0v 1089.495n 0.0v 1089.505n 0.0v 1099.495n 0.0v 1099.505n 0.0v 1109.495n 0.0v 1109.505n 0.0v 1119.495n 0.0v 1119.505n 0.0v 1129.495n 0.0v 1129.505n 0.0v 1139.495n 0.0v 1139.505n 0.0v 1149.495n 0.0v 1149.505n 0.0v 1159.495n 0.0v 1159.505n 0.0v 1169.495n 0.0v 1169.505n 0.0v 1179.495n 0.0v 1179.505n 0.0v 1189.495n 0.0v 1189.505n 0.0v 1199.495n 0.0v 1199.505n 0.0v 1209.495n 0.0v 1209.505n 0.0v 1219.495n 0.0v 1219.505n 0.0v 1229.495n 0.0v 1229.505n 0.0v 1239.495n 0.0v 1239.505n 0.0v 1249.495n 0.0v 1249.505n 0.0v 1259.495n 0.0v 1259.505n 3.3v 1269.495n 3.3v 1269.505n 3.3v 1279.495n 3.3v 1279.505n 3.3v 1289.495n 3.3v 1289.505n 3.3v 1299.495n 3.3v 1299.505n 3.3v 1309.495n 3.3v 1309.505n 3.3v 1319.495n 3.3v 1319.505n 3.3v 1329.495n 3.3v 1329.505n 3.3v 1339.495n 3.3v 1339.505n 3.3v 1349.495n 3.3v 1349.505n 3.3v 1359.495n 3.3v 1359.505n 0.0v 1369.495n 0.0v 1369.505n 3.3v 1379.495n 3.3v 1379.505n 3.3v 1389.495n 3.3v 1389.505n 3.3v 1399.495n 3.3v 1399.505n 3.3v 1409.495n 3.3v 1409.505n 3.3v 1419.495n 3.3v 1419.505n 3.3v 1429.495n 3.3v 1429.505n 3.3v 1439.495n 3.3v 1439.505n 3.3v 1449.495n 3.3v 1449.505n 3.3v 1459.495n 3.3v 1459.505n 0.0v 1469.495n 0.0v 1469.505n 0.0v 1479.495n 0.0v 1479.505n 0.0v 1489.495n 0.0v 1489.505n 0.0v 1499.495n 0.0v 1499.505n 3.3v 1509.495n 3.3v 1509.505n 0.0v 1519.495n 0.0v 1519.505n 0.0v 1529.495n 0.0v 1529.505n 3.3v 1539.495n 3.3v 1539.505n 3.3v 1549.495n 3.3v 1549.505n 3.3v 1559.495n 3.3v 1559.505n 3.3v 1569.495n 3.3v 1569.505n 3.3v 1579.495n 3.3v 1579.505n 3.3v 1589.495n 3.3v 1589.505n 0.0v 1599.495n 0.0v 1599.505n 0.0v 1609.495n 0.0v 1609.505n 0.0v 1619.495n 0.0v 1619.505n 0.0v 1629.495n 0.0v 1629.505n 0.0v 1639.495n 0.0v 1639.505n 0.0v 1649.495n 0.0v 1649.505n 0.0v 1659.495n 0.0v 1659.505n 0.0v 1669.495n 0.0v 1669.505n 0.0v 1679.495n 0.0v 1679.505n 0.0v 1689.495n 0.0v 1689.505n 0.0v 1699.495n 0.0v 1699.505n 0.0v 1709.495n 0.0v 1709.505n 0.0v 1719.495n 0.0v 1719.505n 0.0v 1729.495n 0.0v 1729.505n 0.0v 1739.495n 0.0v 1739.505n 0.0v 1749.495n 0.0v 1749.505n 0.0v 1759.495n 0.0v 1759.505n 0.0v 1769.495n 0.0v 1769.505n 0.0v 1779.495n 0.0v 1779.505n 3.3v 1789.495n 3.3v 1789.505n 3.3v 1799.495n 3.3v 1799.505n 3.3v 1809.495n 3.3v 1809.505n 3.3v 1819.495n 3.3v 1819.505n 3.3v 1829.495n 3.3v 1829.505n 3.3v 1839.495n 3.3v 1839.505n 0.0v 1849.495n 0.0v 1849.505n 3.3v 1859.495n 3.3v 1859.505n 3.3v 1869.495n 3.3v 1869.505n 3.3v 1879.495n 3.3v 1879.505n 3.3v 1889.495n 3.3v 1889.505n 3.3v 1899.495n 3.3v 1899.505n 3.3v 1909.495n 3.3v 1909.505n 3.3v 1919.495n 3.3v 1919.505n 3.3v 1929.495n 3.3v 1929.505n 3.3v 1939.495n 3.3v 1939.505n 3.3v 1949.495n 3.3v 1949.505n 3.3v 1959.495n 3.3v 1959.505n 3.3v 1969.495n 3.3v 1969.505n 3.3v 1979.495n 3.3v 1979.505n 3.3v 1989.495n 3.3v 1989.505n 3.3v 1999.495n 3.3v 1999.505n 3.3v 2009.495n 3.3v 2009.505n 0.0v 2019.495n 0.0v 2019.505n 0.0v 2029.495n 0.0v 2029.505n 0.0v 2039.495n 0.0v 2039.505n 0.0v 2049.495n 0.0v 2049.505n 0.0v )
* (time, data): [(0, 0), (10, 1), (20, 0), (30, 1), (40, 1), (50, 1), (60, 1), (70, 1), (80, 1), (90, 1), (100, 1), (110, 1), (120, 0), (130, 0), (140, 0), (150, 0), (160, 0), (170, 0), (180, 1), (190, 1), (200, 0), (210, 1), (220, 0), (230, 0), (240, 1), (250, 1), (260, 1), (270, 0), (280, 0), (290, 0), (300, 0), (310, 0), (320, 1), (330, 1), (340, 1), (350, 0), (360, 0), (370, 0), (380, 0), (390, 0), (400, 0), (410, 0), (420, 0), (430, 0), (440, 0), (450, 1), (460, 1), (470, 1), (480, 1), (490, 1), (500, 1), (510, 1), (520, 1), (530, 1), (540, 1), (550, 0), (560, 1), (570, 0), (580, 0), (590, 0), (600, 0), (610, 0), (620, 0), (630, 0), (640, 0), (650, 1), (660, 1), (670, 0), (680, 0), (690, 0), (700, 0), (710, 0), (720, 0), (730, 0), (740, 1), (750, 1), (760, 1), (770, 1), (780, 1), (790, 1), (800, 1), (810, 1), (820, 1), (830, 1), (840, 1), (850, 1), (860, 1), (870, 1), (880, 0), (890, 0), (900, 0), (910, 0), (920, 0), (930, 1), (940, 1), (950, 0), (960, 0), (970, 0), (980, 1), (990, 1), (1000, 1), (1010, 1), (1020, 1), (1030, 1), (1040, 0), (1050, 0), (1060, 0), (1070, 0), (1080, 0), (1090, 0), (1100, 0), (1110, 1), (1120, 1), (1130, 1), (1140, 1), (1150, 1), (1160, 1), (1170, 1), (1180, 0), (1190, 0), (1200, 0), (1210, 0), (1220, 1), (1230, 1), (1240, 1), (1250, 1), (1260, 1), (1270, 1), (1280, 1), (1290, 1), (1300, 1), (1310, 1), (1320, 1), (1330, 1), (1340, 1), (1350, 1), (1360, 1), (1370, 0), (1380, 0), (1390, 0), (1400, 0), (1410, 0), (1420, 0), (1430, 0), (1440, 0), (1450, 0), (1460, 0), (1470, 0), (1480, 0), (1490, 0), (1500, 1), (1510, 1), (1520, 1), (1530, 0), (1540, 0), (1550, 0), (1560, 0), (1570, 0), (1580, 0), (1590, 1), (1600, 1), (1610, 1), (1620, 0), (1630, 0), (1640, 0), (1650, 0), (1660, 0), (1670, 0), (1680, 0), (1690, 0), (1700, 0), (1710, 1), (1720, 0), (1730, 0), (1740, 0), (1750, 0), (1760, 0), (1770, 1), (1780, 1), (1790, 1), (1800, 1), (1810, 1), (1820, 1), (1830, 1), (1840, 1), (1850, 1), (1860, 1), (1870, 1), (1880, 1), (1890, 1), (1900, 1), (1910, 1), (1920, 1), (1930, 0), (1940, 0), (1950, 0), (1960, 0), (1970, 0), (1980, 0), (1990, 0), (2000, 0), (2010, 0), (2020, 0), (2030, 0), (2040, 0), (2050, 0)]
Vdin0_7  din0_7  0 PWL (0n 0.0v 9.495n 0.0v 9.505n 3.3v 19.495n 3.3v 19.505n 0.0v 29.495n 0.0v 29.505n 3.3v 39.495n 3.3v 39.505n 3.3v 49.495n 3.3v 49.505n 3.3v 59.495n 3.3v 59.505n 3.3v 69.495n 3.3v 69.505n 3.3v 79.495n 3.3v 79.505n 3.3v 89.495n 3.3v 89.505n 3.3v 99.495n 3.3v 99.505n 3.3v 109.495n 3.3v 109.505n 3.3v 119.495n 3.3v 119.505n 0.0v 129.495n 0.0v 129.505n 0.0v 139.495n 0.0v 139.505n 0.0v 149.495n 0.0v 149.505n 0.0v 159.495n 0.0v 159.505n 0.0v 169.495n 0.0v 169.505n 0.0v 179.495n 0.0v 179.505n 3.3v 189.495n 3.3v 189.505n 3.3v 199.495n 3.3v 199.505n 0.0v 209.495n 0.0v 209.505n 3.3v 219.495n 3.3v 219.505n 0.0v 229.495n 0.0v 229.505n 0.0v 239.495n 0.0v 239.505n 3.3v 249.495n 3.3v 249.505n 3.3v 259.495n 3.3v 259.505n 3.3v 269.495n 3.3v 269.505n 0.0v 279.495n 0.0v 279.505n 0.0v 289.495n 0.0v 289.505n 0.0v 299.495n 0.0v 299.505n 0.0v 309.495n 0.0v 309.505n 0.0v 319.495n 0.0v 319.505n 3.3v 329.495n 3.3v 329.505n 3.3v 339.495n 3.3v 339.505n 3.3v 349.495n 3.3v 349.505n 0.0v 359.495n 0.0v 359.505n 0.0v 369.495n 0.0v 369.505n 0.0v 379.495n 0.0v 379.505n 0.0v 389.495n 0.0v 389.505n 0.0v 399.495n 0.0v 399.505n 0.0v 409.495n 0.0v 409.505n 0.0v 419.495n 0.0v 419.505n 0.0v 429.495n 0.0v 429.505n 0.0v 439.495n 0.0v 439.505n 0.0v 449.495n 0.0v 449.505n 3.3v 459.495n 3.3v 459.505n 3.3v 469.495n 3.3v 469.505n 3.3v 479.495n 3.3v 479.505n 3.3v 489.495n 3.3v 489.505n 3.3v 499.495n 3.3v 499.505n 3.3v 509.495n 3.3v 509.505n 3.3v 519.495n 3.3v 519.505n 3.3v 529.495n 3.3v 529.505n 3.3v 539.495n 3.3v 539.505n 3.3v 549.495n 3.3v 549.505n 0.0v 559.495n 0.0v 559.505n 3.3v 569.495n 3.3v 569.505n 0.0v 579.495n 0.0v 579.505n 0.0v 589.495n 0.0v 589.505n 0.0v 599.495n 0.0v 599.505n 0.0v 609.495n 0.0v 609.505n 0.0v 619.495n 0.0v 619.505n 0.0v 629.495n 0.0v 629.505n 0.0v 639.495n 0.0v 639.505n 0.0v 649.495n 0.0v 649.505n 3.3v 659.495n 3.3v 659.505n 3.3v 669.495n 3.3v 669.505n 0.0v 679.495n 0.0v 679.505n 0.0v 689.495n 0.0v 689.505n 0.0v 699.495n 0.0v 699.505n 0.0v 709.495n 0.0v 709.505n 0.0v 719.495n 0.0v 719.505n 0.0v 729.495n 0.0v 729.505n 0.0v 739.495n 0.0v 739.505n 3.3v 749.495n 3.3v 749.505n 3.3v 759.495n 3.3v 759.505n 3.3v 769.495n 3.3v 769.505n 3.3v 779.495n 3.3v 779.505n 3.3v 789.495n 3.3v 789.505n 3.3v 799.495n 3.3v 799.505n 3.3v 809.495n 3.3v 809.505n 3.3v 819.495n 3.3v 819.505n 3.3v 829.495n 3.3v 829.505n 3.3v 839.495n 3.3v 839.505n 3.3v 849.495n 3.3v 849.505n 3.3v 859.495n 3.3v 859.505n 3.3v 869.495n 3.3v 869.505n 3.3v 879.495n 3.3v 879.505n 0.0v 889.495n 0.0v 889.505n 0.0v 899.495n 0.0v 899.505n 0.0v 909.495n 0.0v 909.505n 0.0v 919.495n 0.0v 919.505n 0.0v 929.495n 0.0v 929.505n 3.3v 939.495n 3.3v 939.505n 3.3v 949.495n 3.3v 949.505n 0.0v 959.495n 0.0v 959.505n 0.0v 969.495n 0.0v 969.505n 0.0v 979.495n 0.0v 979.505n 3.3v 989.495n 3.3v 989.505n 3.3v 999.495n 3.3v 999.505n 3.3v 1009.495n 3.3v 1009.505n 3.3v 1019.495n 3.3v 1019.505n 3.3v 1029.495n 3.3v 1029.505n 3.3v 1039.495n 3.3v 1039.505n 0.0v 1049.495n 0.0v 1049.505n 0.0v 1059.495n 0.0v 1059.505n 0.0v 1069.495n 0.0v 1069.505n 0.0v 1079.495n 0.0v 1079.505n 0.0v 1089.495n 0.0v 1089.505n 0.0v 1099.495n 0.0v 1099.505n 0.0v 1109.495n 0.0v 1109.505n 3.3v 1119.495n 3.3v 1119.505n 3.3v 1129.495n 3.3v 1129.505n 3.3v 1139.495n 3.3v 1139.505n 3.3v 1149.495n 3.3v 1149.505n 3.3v 1159.495n 3.3v 1159.505n 3.3v 1169.495n 3.3v 1169.505n 3.3v 1179.495n 3.3v 1179.505n 0.0v 1189.495n 0.0v 1189.505n 0.0v 1199.495n 0.0v 1199.505n 0.0v 1209.495n 0.0v 1209.505n 0.0v 1219.495n 0.0v 1219.505n 3.3v 1229.495n 3.3v 1229.505n 3.3v 1239.495n 3.3v 1239.505n 3.3v 1249.495n 3.3v 1249.505n 3.3v 1259.495n 3.3v 1259.505n 3.3v 1269.495n 3.3v 1269.505n 3.3v 1279.495n 3.3v 1279.505n 3.3v 1289.495n 3.3v 1289.505n 3.3v 1299.495n 3.3v 1299.505n 3.3v 1309.495n 3.3v 1309.505n 3.3v 1319.495n 3.3v 1319.505n 3.3v 1329.495n 3.3v 1329.505n 3.3v 1339.495n 3.3v 1339.505n 3.3v 1349.495n 3.3v 1349.505n 3.3v 1359.495n 3.3v 1359.505n 3.3v 1369.495n 3.3v 1369.505n 0.0v 1379.495n 0.0v 1379.505n 0.0v 1389.495n 0.0v 1389.505n 0.0v 1399.495n 0.0v 1399.505n 0.0v 1409.495n 0.0v 1409.505n 0.0v 1419.495n 0.0v 1419.505n 0.0v 1429.495n 0.0v 1429.505n 0.0v 1439.495n 0.0v 1439.505n 0.0v 1449.495n 0.0v 1449.505n 0.0v 1459.495n 0.0v 1459.505n 0.0v 1469.495n 0.0v 1469.505n 0.0v 1479.495n 0.0v 1479.505n 0.0v 1489.495n 0.0v 1489.505n 0.0v 1499.495n 0.0v 1499.505n 3.3v 1509.495n 3.3v 1509.505n 3.3v 1519.495n 3.3v 1519.505n 3.3v 1529.495n 3.3v 1529.505n 0.0v 1539.495n 0.0v 1539.505n 0.0v 1549.495n 0.0v 1549.505n 0.0v 1559.495n 0.0v 1559.505n 0.0v 1569.495n 0.0v 1569.505n 0.0v 1579.495n 0.0v 1579.505n 0.0v 1589.495n 0.0v 1589.505n 3.3v 1599.495n 3.3v 1599.505n 3.3v 1609.495n 3.3v 1609.505n 3.3v 1619.495n 3.3v 1619.505n 0.0v 1629.495n 0.0v 1629.505n 0.0v 1639.495n 0.0v 1639.505n 0.0v 1649.495n 0.0v 1649.505n 0.0v 1659.495n 0.0v 1659.505n 0.0v 1669.495n 0.0v 1669.505n 0.0v 1679.495n 0.0v 1679.505n 0.0v 1689.495n 0.0v 1689.505n 0.0v 1699.495n 0.0v 1699.505n 0.0v 1709.495n 0.0v 1709.505n 3.3v 1719.495n 3.3v 1719.505n 0.0v 1729.495n 0.0v 1729.505n 0.0v 1739.495n 0.0v 1739.505n 0.0v 1749.495n 0.0v 1749.505n 0.0v 1759.495n 0.0v 1759.505n 0.0v 1769.495n 0.0v 1769.505n 3.3v 1779.495n 3.3v 1779.505n 3.3v 1789.495n 3.3v 1789.505n 3.3v 1799.495n 3.3v 1799.505n 3.3v 1809.495n 3.3v 1809.505n 3.3v 1819.495n 3.3v 1819.505n 3.3v 1829.495n 3.3v 1829.505n 3.3v 1839.495n 3.3v 1839.505n 3.3v 1849.495n 3.3v 1849.505n 3.3v 1859.495n 3.3v 1859.505n 3.3v 1869.495n 3.3v 1869.505n 3.3v 1879.495n 3.3v 1879.505n 3.3v 1889.495n 3.3v 1889.505n 3.3v 1899.495n 3.3v 1899.505n 3.3v 1909.495n 3.3v 1909.505n 3.3v 1919.495n 3.3v 1919.505n 3.3v 1929.495n 3.3v 1929.505n 0.0v 1939.495n 0.0v 1939.505n 0.0v 1949.495n 0.0v 1949.505n 0.0v 1959.495n 0.0v 1959.505n 0.0v 1969.495n 0.0v 1969.505n 0.0v 1979.495n 0.0v 1979.505n 0.0v 1989.495n 0.0v 1989.505n 0.0v 1999.495n 0.0v 1999.505n 0.0v 2009.495n 0.0v 2009.505n 0.0v 2019.495n 0.0v 2019.505n 0.0v 2029.495n 0.0v 2029.505n 0.0v 2039.495n 0.0v 2039.505n 0.0v 2049.495n 0.0v 2049.505n 0.0v )
* (time, data): [(0, 0), (10, 0), (20, 1), (30, 1), (40, 1), (50, 1), (60, 1), (70, 1), (80, 1), (90, 1), (100, 1), (110, 1), (120, 1), (130, 1), (140, 0), (150, 1), (160, 1), (170, 0), (180, 0), (190, 1), (200, 0), (210, 0), (220, 1), (230, 1), (240, 1), (250, 1), (260, 1), (270, 0), (280, 0), (290, 0), (300, 0), (310, 1), (320, 1), (330, 1), (340, 1), (350, 1), (360, 1), (370, 1), (380, 1), (390, 1), (400, 1), (410, 1), (420, 1), (430, 0), (440, 0), (450, 0), (460, 0), (470, 0), (480, 0), (490, 1), (500, 0), (510, 1), (520, 0), (530, 0), (540, 0), (550, 1), (560, 1), (570, 1), (580, 1), (590, 1), (600, 1), (610, 1), (620, 1), (630, 1), (640, 1), (650, 1), (660, 1), (670, 0), (680, 0), (690, 0), (700, 0), (710, 0), (720, 0), (730, 0), (740, 0), (750, 0), (760, 0), (770, 0), (780, 0), (790, 0), (800, 0), (810, 0), (820, 0), (830, 0), (840, 1), (850, 1), (860, 1), (870, 1), (880, 0), (890, 1), (900, 1), (910, 1), (920, 0), (930, 1), (940, 1), (950, 0), (960, 0), (970, 0), (980, 1), (990, 1), (1000, 1), (1010, 1), (1020, 1), (1030, 1), (1040, 1), (1050, 1), (1060, 1), (1070, 1), (1080, 1), (1090, 1), (1100, 1), (1110, 1), (1120, 1), (1130, 1), (1140, 1), (1150, 1), (1160, 1), (1170, 1), (1180, 0), (1190, 0), (1200, 0), (1210, 0), (1220, 0), (1230, 0), (1240, 0), (1250, 0), (1260, 1), (1270, 1), (1280, 1), (1290, 1), (1300, 1), (1310, 1), (1320, 1), (1330, 1), (1340, 1), (1350, 1), (1360, 0), (1370, 0), (1380, 0), (1390, 0), (1400, 0), (1410, 0), (1420, 0), (1430, 0), (1440, 0), (1450, 0), (1460, 1), (1470, 1), (1480, 1), (1490, 1), (1500, 0), (1510, 0), (1520, 0), (1530, 0), (1540, 0), (1550, 0), (1560, 0), (1570, 0), (1580, 0), (1590, 0), (1600, 0), (1610, 0), (1620, 1), (1630, 1), (1640, 1), (1650, 1), (1660, 0), (1670, 0), (1680, 0), (1690, 0), (1700, 1), (1710, 0), (1720, 1), (1730, 1), (1740, 1), (1750, 1), (1760, 1), (1770, 0), (1780, 1), (1790, 1), (1800, 1), (1810, 1), (1820, 1), (1830, 1), (1840, 0), (1850, 0), (1860, 0), (1870, 0), (1880, 1), (1890, 1), (1900, 1), (1910, 1), (1920, 1), (1930, 1), (1940, 1), (1950, 1), (1960, 1), (1970, 1), (1980, 0), (1990, 0), (2000, 0), (2010, 1), (2020, 1), (2030, 1), (2040, 1), (2050, 1)]
Vdin0_8  din0_8  0 PWL (0n 0.0v 9.495n 0.0v 9.505n 0.0v 19.495n 0.0v 19.505n 3.3v 29.495n 3.3v 29.505n 3.3v 39.495n 3.3v 39.505n 3.3v 49.495n 3.3v 49.505n 3.3v 59.495n 3.3v 59.505n 3.3v 69.495n 3.3v 69.505n 3.3v 79.495n 3.3v 79.505n 3.3v 89.495n 3.3v 89.505n 3.3v 99.495n 3.3v 99.505n 3.3v 109.495n 3.3v 109.505n 3.3v 119.495n 3.3v 119.505n 3.3v 129.495n 3.3v 129.505n 3.3v 139.495n 3.3v 139.505n 0.0v 149.495n 0.0v 149.505n 3.3v 159.495n 3.3v 159.505n 3.3v 169.495n 3.3v 169.505n 0.0v 179.495n 0.0v 179.505n 0.0v 189.495n 0.0v 189.505n 3.3v 199.495n 3.3v 199.505n 0.0v 209.495n 0.0v 209.505n 0.0v 219.495n 0.0v 219.505n 3.3v 229.495n 3.3v 229.505n 3.3v 239.495n 3.3v 239.505n 3.3v 249.495n 3.3v 249.505n 3.3v 259.495n 3.3v 259.505n 3.3v 269.495n 3.3v 269.505n 0.0v 279.495n 0.0v 279.505n 0.0v 289.495n 0.0v 289.505n 0.0v 299.495n 0.0v 299.505n 0.0v 309.495n 0.0v 309.505n 3.3v 319.495n 3.3v 319.505n 3.3v 329.495n 3.3v 329.505n 3.3v 339.495n 3.3v 339.505n 3.3v 349.495n 3.3v 349.505n 3.3v 359.495n 3.3v 359.505n 3.3v 369.495n 3.3v 369.505n 3.3v 379.495n 3.3v 379.505n 3.3v 389.495n 3.3v 389.505n 3.3v 399.495n 3.3v 399.505n 3.3v 409.495n 3.3v 409.505n 3.3v 419.495n 3.3v 419.505n 3.3v 429.495n 3.3v 429.505n 0.0v 439.495n 0.0v 439.505n 0.0v 449.495n 0.0v 449.505n 0.0v 459.495n 0.0v 459.505n 0.0v 469.495n 0.0v 469.505n 0.0v 479.495n 0.0v 479.505n 0.0v 489.495n 0.0v 489.505n 3.3v 499.495n 3.3v 499.505n 0.0v 509.495n 0.0v 509.505n 3.3v 519.495n 3.3v 519.505n 0.0v 529.495n 0.0v 529.505n 0.0v 539.495n 0.0v 539.505n 0.0v 549.495n 0.0v 549.505n 3.3v 559.495n 3.3v 559.505n 3.3v 569.495n 3.3v 569.505n 3.3v 579.495n 3.3v 579.505n 3.3v 589.495n 3.3v 589.505n 3.3v 599.495n 3.3v 599.505n 3.3v 609.495n 3.3v 609.505n 3.3v 619.495n 3.3v 619.505n 3.3v 629.495n 3.3v 629.505n 3.3v 639.495n 3.3v 639.505n 3.3v 649.495n 3.3v 649.505n 3.3v 659.495n 3.3v 659.505n 3.3v 669.495n 3.3v 669.505n 0.0v 679.495n 0.0v 679.505n 0.0v 689.495n 0.0v 689.505n 0.0v 699.495n 0.0v 699.505n 0.0v 709.495n 0.0v 709.505n 0.0v 719.495n 0.0v 719.505n 0.0v 729.495n 0.0v 729.505n 0.0v 739.495n 0.0v 739.505n 0.0v 749.495n 0.0v 749.505n 0.0v 759.495n 0.0v 759.505n 0.0v 769.495n 0.0v 769.505n 0.0v 779.495n 0.0v 779.505n 0.0v 789.495n 0.0v 789.505n 0.0v 799.495n 0.0v 799.505n 0.0v 809.495n 0.0v 809.505n 0.0v 819.495n 0.0v 819.505n 0.0v 829.495n 0.0v 829.505n 0.0v 839.495n 0.0v 839.505n 3.3v 849.495n 3.3v 849.505n 3.3v 859.495n 3.3v 859.505n 3.3v 869.495n 3.3v 869.505n 3.3v 879.495n 3.3v 879.505n 0.0v 889.495n 0.0v 889.505n 3.3v 899.495n 3.3v 899.505n 3.3v 909.495n 3.3v 909.505n 3.3v 919.495n 3.3v 919.505n 0.0v 929.495n 0.0v 929.505n 3.3v 939.495n 3.3v 939.505n 3.3v 949.495n 3.3v 949.505n 0.0v 959.495n 0.0v 959.505n 0.0v 969.495n 0.0v 969.505n 0.0v 979.495n 0.0v 979.505n 3.3v 989.495n 3.3v 989.505n 3.3v 999.495n 3.3v 999.505n 3.3v 1009.495n 3.3v 1009.505n 3.3v 1019.495n 3.3v 1019.505n 3.3v 1029.495n 3.3v 1029.505n 3.3v 1039.495n 3.3v 1039.505n 3.3v 1049.495n 3.3v 1049.505n 3.3v 1059.495n 3.3v 1059.505n 3.3v 1069.495n 3.3v 1069.505n 3.3v 1079.495n 3.3v 1079.505n 3.3v 1089.495n 3.3v 1089.505n 3.3v 1099.495n 3.3v 1099.505n 3.3v 1109.495n 3.3v 1109.505n 3.3v 1119.495n 3.3v 1119.505n 3.3v 1129.495n 3.3v 1129.505n 3.3v 1139.495n 3.3v 1139.505n 3.3v 1149.495n 3.3v 1149.505n 3.3v 1159.495n 3.3v 1159.505n 3.3v 1169.495n 3.3v 1169.505n 3.3v 1179.495n 3.3v 1179.505n 0.0v 1189.495n 0.0v 1189.505n 0.0v 1199.495n 0.0v 1199.505n 0.0v 1209.495n 0.0v 1209.505n 0.0v 1219.495n 0.0v 1219.505n 0.0v 1229.495n 0.0v 1229.505n 0.0v 1239.495n 0.0v 1239.505n 0.0v 1249.495n 0.0v 1249.505n 0.0v 1259.495n 0.0v 1259.505n 3.3v 1269.495n 3.3v 1269.505n 3.3v 1279.495n 3.3v 1279.505n 3.3v 1289.495n 3.3v 1289.505n 3.3v 1299.495n 3.3v 1299.505n 3.3v 1309.495n 3.3v 1309.505n 3.3v 1319.495n 3.3v 1319.505n 3.3v 1329.495n 3.3v 1329.505n 3.3v 1339.495n 3.3v 1339.505n 3.3v 1349.495n 3.3v 1349.505n 3.3v 1359.495n 3.3v 1359.505n 0.0v 1369.495n 0.0v 1369.505n 0.0v 1379.495n 0.0v 1379.505n 0.0v 1389.495n 0.0v 1389.505n 0.0v 1399.495n 0.0v 1399.505n 0.0v 1409.495n 0.0v 1409.505n 0.0v 1419.495n 0.0v 1419.505n 0.0v 1429.495n 0.0v 1429.505n 0.0v 1439.495n 0.0v 1439.505n 0.0v 1449.495n 0.0v 1449.505n 0.0v 1459.495n 0.0v 1459.505n 3.3v 1469.495n 3.3v 1469.505n 3.3v 1479.495n 3.3v 1479.505n 3.3v 1489.495n 3.3v 1489.505n 3.3v 1499.495n 3.3v 1499.505n 0.0v 1509.495n 0.0v 1509.505n 0.0v 1519.495n 0.0v 1519.505n 0.0v 1529.495n 0.0v 1529.505n 0.0v 1539.495n 0.0v 1539.505n 0.0v 1549.495n 0.0v 1549.505n 0.0v 1559.495n 0.0v 1559.505n 0.0v 1569.495n 0.0v 1569.505n 0.0v 1579.495n 0.0v 1579.505n 0.0v 1589.495n 0.0v 1589.505n 0.0v 1599.495n 0.0v 1599.505n 0.0v 1609.495n 0.0v 1609.505n 0.0v 1619.495n 0.0v 1619.505n 3.3v 1629.495n 3.3v 1629.505n 3.3v 1639.495n 3.3v 1639.505n 3.3v 1649.495n 3.3v 1649.505n 3.3v 1659.495n 3.3v 1659.505n 0.0v 1669.495n 0.0v 1669.505n 0.0v 1679.495n 0.0v 1679.505n 0.0v 1689.495n 0.0v 1689.505n 0.0v 1699.495n 0.0v 1699.505n 3.3v 1709.495n 3.3v 1709.505n 0.0v 1719.495n 0.0v 1719.505n 3.3v 1729.495n 3.3v 1729.505n 3.3v 1739.495n 3.3v 1739.505n 3.3v 1749.495n 3.3v 1749.505n 3.3v 1759.495n 3.3v 1759.505n 3.3v 1769.495n 3.3v 1769.505n 0.0v 1779.495n 0.0v 1779.505n 3.3v 1789.495n 3.3v 1789.505n 3.3v 1799.495n 3.3v 1799.505n 3.3v 1809.495n 3.3v 1809.505n 3.3v 1819.495n 3.3v 1819.505n 3.3v 1829.495n 3.3v 1829.505n 3.3v 1839.495n 3.3v 1839.505n 0.0v 1849.495n 0.0v 1849.505n 0.0v 1859.495n 0.0v 1859.505n 0.0v 1869.495n 0.0v 1869.505n 0.0v 1879.495n 0.0v 1879.505n 3.3v 1889.495n 3.3v 1889.505n 3.3v 1899.495n 3.3v 1899.505n 3.3v 1909.495n 3.3v 1909.505n 3.3v 1919.495n 3.3v 1919.505n 3.3v 1929.495n 3.3v 1929.505n 3.3v 1939.495n 3.3v 1939.505n 3.3v 1949.495n 3.3v 1949.505n 3.3v 1959.495n 3.3v 1959.505n 3.3v 1969.495n 3.3v 1969.505n 3.3v 1979.495n 3.3v 1979.505n 0.0v 1989.495n 0.0v 1989.505n 0.0v 1999.495n 0.0v 1999.505n 0.0v 2009.495n 0.0v 2009.505n 3.3v 2019.495n 3.3v 2019.505n 3.3v 2029.495n 3.3v 2029.505n 3.3v 2039.495n 3.3v 2039.505n 3.3v 2049.495n 3.3v 2049.505n 3.3v )
* (time, data): [(0, 0), (10, 0), (20, 1), (30, 0), (40, 0), (50, 0), (60, 0), (70, 0), (80, 0), (90, 0), (100, 0), (110, 0), (120, 0), (130, 0), (140, 1), (150, 0), (160, 0), (170, 1), (180, 1), (190, 1), (200, 1), (210, 1), (220, 1), (230, 1), (240, 1), (250, 0), (260, 0), (270, 0), (280, 0), (290, 0), (300, 0), (310, 1), (320, 1), (330, 1), (340, 1), (350, 0), (360, 0), (370, 0), (380, 0), (390, 0), (400, 0), (410, 0), (420, 1), (430, 0), (440, 0), (450, 0), (460, 0), (470, 0), (480, 0), (490, 0), (500, 1), (510, 0), (520, 1), (530, 1), (540, 1), (550, 0), (560, 0), (570, 1), (580, 1), (590, 1), (600, 1), (610, 1), (620, 1), (630, 1), (640, 1), (650, 0), (660, 0), (670, 1), (680, 1), (690, 1), (700, 1), (710, 1), (720, 1), (730, 1), (740, 0), (750, 0), (760, 0), (770, 0), (780, 0), (790, 0), (800, 0), (810, 0), (820, 0), (830, 0), (840, 1), (850, 1), (860, 1), (870, 1), (880, 1), (890, 1), (900, 1), (910, 1), (920, 1), (930, 1), (940, 1), (950, 1), (960, 1), (970, 1), (980, 1), (990, 1), (1000, 1), (1010, 1), (1020, 1), (1030, 1), (1040, 1), (1050, 1), (1060, 1), (1070, 1), (1080, 1), (1090, 1), (1100, 1), (1110, 0), (1120, 0), (1130, 0), (1140, 0), (1150, 0), (1160, 0), (1170, 0), (1180, 1), (1190, 1), (1200, 1), (1210, 1), (1220, 1), (1230, 1), (1240, 1), (1250, 1), (1260, 0), (1270, 0), (1280, 0), (1290, 0), (1300, 0), (1310, 0), (1320, 0), (1330, 0), (1340, 0), (1350, 0), (1360, 0), (1370, 1), (1380, 1), (1390, 1), (1400, 1), (1410, 1), (1420, 1), (1430, 1), (1440, 1), (1450, 1), (1460, 0), (1470, 0), (1480, 0), (1490, 0), (1500, 1), (1510, 1), (1520, 1), (1530, 1), (1540, 1), (1550, 1), (1560, 1), (1570, 1), (1580, 1), (1590, 1), (1600, 1), (1610, 1), (1620, 1), (1630, 1), (1640, 1), (1650, 1), (1660, 1), (1670, 1), (1680, 1), (1690, 1), (1700, 0), (1710, 1), (1720, 1), (1730, 1), (1740, 1), (1750, 1), (1760, 1), (1770, 1), (1780, 0), (1790, 0), (1800, 0), (1810, 0), (1820, 0), (1830, 0), (1840, 1), (1850, 0), (1860, 0), (1870, 0), (1880, 1), (1890, 0), (1900, 0), (1910, 0), (1920, 0), (1930, 0), (1940, 0), (1950, 0), (1960, 0), (1970, 0), (1980, 1), (1990, 1), (2000, 1), (2010, 1), (2020, 1), (2030, 1), (2040, 1), (2050, 1)]
Vdin0_9  din0_9  0 PWL (0n 0.0v 9.495n 0.0v 9.505n 0.0v 19.495n 0.0v 19.505n 3.3v 29.495n 3.3v 29.505n 0.0v 39.495n 0.0v 39.505n 0.0v 49.495n 0.0v 49.505n 0.0v 59.495n 0.0v 59.505n 0.0v 69.495n 0.0v 69.505n 0.0v 79.495n 0.0v 79.505n 0.0v 89.495n 0.0v 89.505n 0.0v 99.495n 0.0v 99.505n 0.0v 109.495n 0.0v 109.505n 0.0v 119.495n 0.0v 119.505n 0.0v 129.495n 0.0v 129.505n 0.0v 139.495n 0.0v 139.505n 3.3v 149.495n 3.3v 149.505n 0.0v 159.495n 0.0v 159.505n 0.0v 169.495n 0.0v 169.505n 3.3v 179.495n 3.3v 179.505n 3.3v 189.495n 3.3v 189.505n 3.3v 199.495n 3.3v 199.505n 3.3v 209.495n 3.3v 209.505n 3.3v 219.495n 3.3v 219.505n 3.3v 229.495n 3.3v 229.505n 3.3v 239.495n 3.3v 239.505n 3.3v 249.495n 3.3v 249.505n 0.0v 259.495n 0.0v 259.505n 0.0v 269.495n 0.0v 269.505n 0.0v 279.495n 0.0v 279.505n 0.0v 289.495n 0.0v 289.505n 0.0v 299.495n 0.0v 299.505n 0.0v 309.495n 0.0v 309.505n 3.3v 319.495n 3.3v 319.505n 3.3v 329.495n 3.3v 329.505n 3.3v 339.495n 3.3v 339.505n 3.3v 349.495n 3.3v 349.505n 0.0v 359.495n 0.0v 359.505n 0.0v 369.495n 0.0v 369.505n 0.0v 379.495n 0.0v 379.505n 0.0v 389.495n 0.0v 389.505n 0.0v 399.495n 0.0v 399.505n 0.0v 409.495n 0.0v 409.505n 0.0v 419.495n 0.0v 419.505n 3.3v 429.495n 3.3v 429.505n 0.0v 439.495n 0.0v 439.505n 0.0v 449.495n 0.0v 449.505n 0.0v 459.495n 0.0v 459.505n 0.0v 469.495n 0.0v 469.505n 0.0v 479.495n 0.0v 479.505n 0.0v 489.495n 0.0v 489.505n 0.0v 499.495n 0.0v 499.505n 3.3v 509.495n 3.3v 509.505n 0.0v 519.495n 0.0v 519.505n 3.3v 529.495n 3.3v 529.505n 3.3v 539.495n 3.3v 539.505n 3.3v 549.495n 3.3v 549.505n 0.0v 559.495n 0.0v 559.505n 0.0v 569.495n 0.0v 569.505n 3.3v 579.495n 3.3v 579.505n 3.3v 589.495n 3.3v 589.505n 3.3v 599.495n 3.3v 599.505n 3.3v 609.495n 3.3v 609.505n 3.3v 619.495n 3.3v 619.505n 3.3v 629.495n 3.3v 629.505n 3.3v 639.495n 3.3v 639.505n 3.3v 649.495n 3.3v 649.505n 0.0v 659.495n 0.0v 659.505n 0.0v 669.495n 0.0v 669.505n 3.3v 679.495n 3.3v 679.505n 3.3v 689.495n 3.3v 689.505n 3.3v 699.495n 3.3v 699.505n 3.3v 709.495n 3.3v 709.505n 3.3v 719.495n 3.3v 719.505n 3.3v 729.495n 3.3v 729.505n 3.3v 739.495n 3.3v 739.505n 0.0v 749.495n 0.0v 749.505n 0.0v 759.495n 0.0v 759.505n 0.0v 769.495n 0.0v 769.505n 0.0v 779.495n 0.0v 779.505n 0.0v 789.495n 0.0v 789.505n 0.0v 799.495n 0.0v 799.505n 0.0v 809.495n 0.0v 809.505n 0.0v 819.495n 0.0v 819.505n 0.0v 829.495n 0.0v 829.505n 0.0v 839.495n 0.0v 839.505n 3.3v 849.495n 3.3v 849.505n 3.3v 859.495n 3.3v 859.505n 3.3v 869.495n 3.3v 869.505n 3.3v 879.495n 3.3v 879.505n 3.3v 889.495n 3.3v 889.505n 3.3v 899.495n 3.3v 899.505n 3.3v 909.495n 3.3v 909.505n 3.3v 919.495n 3.3v 919.505n 3.3v 929.495n 3.3v 929.505n 3.3v 939.495n 3.3v 939.505n 3.3v 949.495n 3.3v 949.505n 3.3v 959.495n 3.3v 959.505n 3.3v 969.495n 3.3v 969.505n 3.3v 979.495n 3.3v 979.505n 3.3v 989.495n 3.3v 989.505n 3.3v 999.495n 3.3v 999.505n 3.3v 1009.495n 3.3v 1009.505n 3.3v 1019.495n 3.3v 1019.505n 3.3v 1029.495n 3.3v 1029.505n 3.3v 1039.495n 3.3v 1039.505n 3.3v 1049.495n 3.3v 1049.505n 3.3v 1059.495n 3.3v 1059.505n 3.3v 1069.495n 3.3v 1069.505n 3.3v 1079.495n 3.3v 1079.505n 3.3v 1089.495n 3.3v 1089.505n 3.3v 1099.495n 3.3v 1099.505n 3.3v 1109.495n 3.3v 1109.505n 0.0v 1119.495n 0.0v 1119.505n 0.0v 1129.495n 0.0v 1129.505n 0.0v 1139.495n 0.0v 1139.505n 0.0v 1149.495n 0.0v 1149.505n 0.0v 1159.495n 0.0v 1159.505n 0.0v 1169.495n 0.0v 1169.505n 0.0v 1179.495n 0.0v 1179.505n 3.3v 1189.495n 3.3v 1189.505n 3.3v 1199.495n 3.3v 1199.505n 3.3v 1209.495n 3.3v 1209.505n 3.3v 1219.495n 3.3v 1219.505n 3.3v 1229.495n 3.3v 1229.505n 3.3v 1239.495n 3.3v 1239.505n 3.3v 1249.495n 3.3v 1249.505n 3.3v 1259.495n 3.3v 1259.505n 0.0v 1269.495n 0.0v 1269.505n 0.0v 1279.495n 0.0v 1279.505n 0.0v 1289.495n 0.0v 1289.505n 0.0v 1299.495n 0.0v 1299.505n 0.0v 1309.495n 0.0v 1309.505n 0.0v 1319.495n 0.0v 1319.505n 0.0v 1329.495n 0.0v 1329.505n 0.0v 1339.495n 0.0v 1339.505n 0.0v 1349.495n 0.0v 1349.505n 0.0v 1359.495n 0.0v 1359.505n 0.0v 1369.495n 0.0v 1369.505n 3.3v 1379.495n 3.3v 1379.505n 3.3v 1389.495n 3.3v 1389.505n 3.3v 1399.495n 3.3v 1399.505n 3.3v 1409.495n 3.3v 1409.505n 3.3v 1419.495n 3.3v 1419.505n 3.3v 1429.495n 3.3v 1429.505n 3.3v 1439.495n 3.3v 1439.505n 3.3v 1449.495n 3.3v 1449.505n 3.3v 1459.495n 3.3v 1459.505n 0.0v 1469.495n 0.0v 1469.505n 0.0v 1479.495n 0.0v 1479.505n 0.0v 1489.495n 0.0v 1489.505n 0.0v 1499.495n 0.0v 1499.505n 3.3v 1509.495n 3.3v 1509.505n 3.3v 1519.495n 3.3v 1519.505n 3.3v 1529.495n 3.3v 1529.505n 3.3v 1539.495n 3.3v 1539.505n 3.3v 1549.495n 3.3v 1549.505n 3.3v 1559.495n 3.3v 1559.505n 3.3v 1569.495n 3.3v 1569.505n 3.3v 1579.495n 3.3v 1579.505n 3.3v 1589.495n 3.3v 1589.505n 3.3v 1599.495n 3.3v 1599.505n 3.3v 1609.495n 3.3v 1609.505n 3.3v 1619.495n 3.3v 1619.505n 3.3v 1629.495n 3.3v 1629.505n 3.3v 1639.495n 3.3v 1639.505n 3.3v 1649.495n 3.3v 1649.505n 3.3v 1659.495n 3.3v 1659.505n 3.3v 1669.495n 3.3v 1669.505n 3.3v 1679.495n 3.3v 1679.505n 3.3v 1689.495n 3.3v 1689.505n 3.3v 1699.495n 3.3v 1699.505n 0.0v 1709.495n 0.0v 1709.505n 3.3v 1719.495n 3.3v 1719.505n 3.3v 1729.495n 3.3v 1729.505n 3.3v 1739.495n 3.3v 1739.505n 3.3v 1749.495n 3.3v 1749.505n 3.3v 1759.495n 3.3v 1759.505n 3.3v 1769.495n 3.3v 1769.505n 3.3v 1779.495n 3.3v 1779.505n 0.0v 1789.495n 0.0v 1789.505n 0.0v 1799.495n 0.0v 1799.505n 0.0v 1809.495n 0.0v 1809.505n 0.0v 1819.495n 0.0v 1819.505n 0.0v 1829.495n 0.0v 1829.505n 0.0v 1839.495n 0.0v 1839.505n 3.3v 1849.495n 3.3v 1849.505n 0.0v 1859.495n 0.0v 1859.505n 0.0v 1869.495n 0.0v 1869.505n 0.0v 1879.495n 0.0v 1879.505n 3.3v 1889.495n 3.3v 1889.505n 0.0v 1899.495n 0.0v 1899.505n 0.0v 1909.495n 0.0v 1909.505n 0.0v 1919.495n 0.0v 1919.505n 0.0v 1929.495n 0.0v 1929.505n 0.0v 1939.495n 0.0v 1939.505n 0.0v 1949.495n 0.0v 1949.505n 0.0v 1959.495n 0.0v 1959.505n 0.0v 1969.495n 0.0v 1969.505n 0.0v 1979.495n 0.0v 1979.505n 3.3v 1989.495n 3.3v 1989.505n 3.3v 1999.495n 3.3v 1999.505n 3.3v 2009.495n 3.3v 2009.505n 3.3v 2019.495n 3.3v 2019.505n 3.3v 2029.495n 3.3v 2029.505n 3.3v 2039.495n 3.3v 2039.505n 3.3v 2049.495n 3.3v 2049.505n 3.3v )
* (time, data): [(0, 0), (10, 0), (20, 0), (30, 1), (40, 1), (50, 1), (60, 1), (70, 1), (80, 1), (90, 1), (100, 1), (110, 1), (120, 0), (130, 0), (140, 0), (150, 0), (160, 0), (170, 0), (180, 1), (190, 0), (200, 0), (210, 1), (220, 1), (230, 1), (240, 1), (250, 0), (260, 0), (270, 0), (280, 0), (290, 0), (300, 0), (310, 0), (320, 1), (330, 1), (340, 1), (350, 0), (360, 0), (370, 0), (380, 0), (390, 0), (400, 0), (410, 0), (420, 0), (430, 0), (440, 0), (450, 0), (460, 0), (470, 0), (480, 0), (490, 1), (500, 0), (510, 0), (520, 0), (530, 0), (540, 0), (550, 0), (560, 1), (570, 0), (580, 0), (590, 0), (600, 0), (610, 0), (620, 0), (630, 0), (640, 0), (650, 1), (660, 1), (670, 0), (680, 0), (690, 0), (700, 0), (710, 0), (720, 0), (730, 0), (740, 0), (750, 0), (760, 0), (770, 0), (780, 0), (790, 0), (800, 0), (810, 0), (820, 0), (830, 0), (840, 1), (850, 1), (860, 1), (870, 1), (880, 0), (890, 1), (900, 1), (910, 1), (920, 0), (930, 1), (940, 1), (950, 1), (960, 1), (970, 1), (980, 1), (990, 1), (1000, 1), (1010, 1), (1020, 1), (1030, 0), (1040, 1), (1050, 1), (1060, 1), (1070, 1), (1080, 1), (1090, 1), (1100, 1), (1110, 1), (1120, 1), (1130, 1), (1140, 1), (1150, 1), (1160, 1), (1170, 1), (1180, 0), (1190, 0), (1200, 0), (1210, 0), (1220, 1), (1230, 1), (1240, 1), (1250, 1), (1260, 0), (1270, 0), (1280, 0), (1290, 0), (1300, 0), (1310, 0), (1320, 0), (1330, 0), (1340, 0), (1350, 0), (1360, 1), (1370, 0), (1380, 0), (1390, 0), (1400, 0), (1410, 0), (1420, 0), (1430, 0), (1440, 0), (1450, 0), (1460, 1), (1470, 1), (1480, 1), (1490, 1), (1500, 0), (1510, 0), (1520, 0), (1530, 0), (1540, 0), (1550, 0), (1560, 0), (1570, 0), (1580, 0), (1590, 1), (1600, 1), (1610, 1), (1620, 0), (1630, 0), (1640, 0), (1650, 0), (1660, 1), (1670, 1), (1680, 1), (1690, 1), (1700, 0), (1710, 1), (1720, 1), (1730, 1), (1740, 1), (1750, 1), (1760, 1), (1770, 0), (1780, 0), (1790, 0), (1800, 0), (1810, 0), (1820, 0), (1830, 0), (1840, 1), (1850, 1), (1860, 1), (1870, 1), (1880, 0), (1890, 0), (1900, 0), (1910, 0), (1920, 0), (1930, 0), (1940, 0), (1950, 0), (1960, 0), (1970, 0), (1980, 0), (1990, 0), (2000, 0), (2010, 0), (2020, 0), (2030, 0), (2040, 0), (2050, 0)]
Vdin0_10  din0_10  0 PWL (0n 0.0v 9.495n 0.0v 9.505n 0.0v 19.495n 0.0v 19.505n 0.0v 29.495n 0.0v 29.505n 3.3v 39.495n 3.3v 39.505n 3.3v 49.495n 3.3v 49.505n 3.3v 59.495n 3.3v 59.505n 3.3v 69.495n 3.3v 69.505n 3.3v 79.495n 3.3v 79.505n 3.3v 89.495n 3.3v 89.505n 3.3v 99.495n 3.3v 99.505n 3.3v 109.495n 3.3v 109.505n 3.3v 119.495n 3.3v 119.505n 0.0v 129.495n 0.0v 129.505n 0.0v 139.495n 0.0v 139.505n 0.0v 149.495n 0.0v 149.505n 0.0v 159.495n 0.0v 159.505n 0.0v 169.495n 0.0v 169.505n 0.0v 179.495n 0.0v 179.505n 3.3v 189.495n 3.3v 189.505n 0.0v 199.495n 0.0v 199.505n 0.0v 209.495n 0.0v 209.505n 3.3v 219.495n 3.3v 219.505n 3.3v 229.495n 3.3v 229.505n 3.3v 239.495n 3.3v 239.505n 3.3v 249.495n 3.3v 249.505n 0.0v 259.495n 0.0v 259.505n 0.0v 269.495n 0.0v 269.505n 0.0v 279.495n 0.0v 279.505n 0.0v 289.495n 0.0v 289.505n 0.0v 299.495n 0.0v 299.505n 0.0v 309.495n 0.0v 309.505n 0.0v 319.495n 0.0v 319.505n 3.3v 329.495n 3.3v 329.505n 3.3v 339.495n 3.3v 339.505n 3.3v 349.495n 3.3v 349.505n 0.0v 359.495n 0.0v 359.505n 0.0v 369.495n 0.0v 369.505n 0.0v 379.495n 0.0v 379.505n 0.0v 389.495n 0.0v 389.505n 0.0v 399.495n 0.0v 399.505n 0.0v 409.495n 0.0v 409.505n 0.0v 419.495n 0.0v 419.505n 0.0v 429.495n 0.0v 429.505n 0.0v 439.495n 0.0v 439.505n 0.0v 449.495n 0.0v 449.505n 0.0v 459.495n 0.0v 459.505n 0.0v 469.495n 0.0v 469.505n 0.0v 479.495n 0.0v 479.505n 0.0v 489.495n 0.0v 489.505n 3.3v 499.495n 3.3v 499.505n 0.0v 509.495n 0.0v 509.505n 0.0v 519.495n 0.0v 519.505n 0.0v 529.495n 0.0v 529.505n 0.0v 539.495n 0.0v 539.505n 0.0v 549.495n 0.0v 549.505n 0.0v 559.495n 0.0v 559.505n 3.3v 569.495n 3.3v 569.505n 0.0v 579.495n 0.0v 579.505n 0.0v 589.495n 0.0v 589.505n 0.0v 599.495n 0.0v 599.505n 0.0v 609.495n 0.0v 609.505n 0.0v 619.495n 0.0v 619.505n 0.0v 629.495n 0.0v 629.505n 0.0v 639.495n 0.0v 639.505n 0.0v 649.495n 0.0v 649.505n 3.3v 659.495n 3.3v 659.505n 3.3v 669.495n 3.3v 669.505n 0.0v 679.495n 0.0v 679.505n 0.0v 689.495n 0.0v 689.505n 0.0v 699.495n 0.0v 699.505n 0.0v 709.495n 0.0v 709.505n 0.0v 719.495n 0.0v 719.505n 0.0v 729.495n 0.0v 729.505n 0.0v 739.495n 0.0v 739.505n 0.0v 749.495n 0.0v 749.505n 0.0v 759.495n 0.0v 759.505n 0.0v 769.495n 0.0v 769.505n 0.0v 779.495n 0.0v 779.505n 0.0v 789.495n 0.0v 789.505n 0.0v 799.495n 0.0v 799.505n 0.0v 809.495n 0.0v 809.505n 0.0v 819.495n 0.0v 819.505n 0.0v 829.495n 0.0v 829.505n 0.0v 839.495n 0.0v 839.505n 3.3v 849.495n 3.3v 849.505n 3.3v 859.495n 3.3v 859.505n 3.3v 869.495n 3.3v 869.505n 3.3v 879.495n 3.3v 879.505n 0.0v 889.495n 0.0v 889.505n 3.3v 899.495n 3.3v 899.505n 3.3v 909.495n 3.3v 909.505n 3.3v 919.495n 3.3v 919.505n 0.0v 929.495n 0.0v 929.505n 3.3v 939.495n 3.3v 939.505n 3.3v 949.495n 3.3v 949.505n 3.3v 959.495n 3.3v 959.505n 3.3v 969.495n 3.3v 969.505n 3.3v 979.495n 3.3v 979.505n 3.3v 989.495n 3.3v 989.505n 3.3v 999.495n 3.3v 999.505n 3.3v 1009.495n 3.3v 1009.505n 3.3v 1019.495n 3.3v 1019.505n 3.3v 1029.495n 3.3v 1029.505n 0.0v 1039.495n 0.0v 1039.505n 3.3v 1049.495n 3.3v 1049.505n 3.3v 1059.495n 3.3v 1059.505n 3.3v 1069.495n 3.3v 1069.505n 3.3v 1079.495n 3.3v 1079.505n 3.3v 1089.495n 3.3v 1089.505n 3.3v 1099.495n 3.3v 1099.505n 3.3v 1109.495n 3.3v 1109.505n 3.3v 1119.495n 3.3v 1119.505n 3.3v 1129.495n 3.3v 1129.505n 3.3v 1139.495n 3.3v 1139.505n 3.3v 1149.495n 3.3v 1149.505n 3.3v 1159.495n 3.3v 1159.505n 3.3v 1169.495n 3.3v 1169.505n 3.3v 1179.495n 3.3v 1179.505n 0.0v 1189.495n 0.0v 1189.505n 0.0v 1199.495n 0.0v 1199.505n 0.0v 1209.495n 0.0v 1209.505n 0.0v 1219.495n 0.0v 1219.505n 3.3v 1229.495n 3.3v 1229.505n 3.3v 1239.495n 3.3v 1239.505n 3.3v 1249.495n 3.3v 1249.505n 3.3v 1259.495n 3.3v 1259.505n 0.0v 1269.495n 0.0v 1269.505n 0.0v 1279.495n 0.0v 1279.505n 0.0v 1289.495n 0.0v 1289.505n 0.0v 1299.495n 0.0v 1299.505n 0.0v 1309.495n 0.0v 1309.505n 0.0v 1319.495n 0.0v 1319.505n 0.0v 1329.495n 0.0v 1329.505n 0.0v 1339.495n 0.0v 1339.505n 0.0v 1349.495n 0.0v 1349.505n 0.0v 1359.495n 0.0v 1359.505n 3.3v 1369.495n 3.3v 1369.505n 0.0v 1379.495n 0.0v 1379.505n 0.0v 1389.495n 0.0v 1389.505n 0.0v 1399.495n 0.0v 1399.505n 0.0v 1409.495n 0.0v 1409.505n 0.0v 1419.495n 0.0v 1419.505n 0.0v 1429.495n 0.0v 1429.505n 0.0v 1439.495n 0.0v 1439.505n 0.0v 1449.495n 0.0v 1449.505n 0.0v 1459.495n 0.0v 1459.505n 3.3v 1469.495n 3.3v 1469.505n 3.3v 1479.495n 3.3v 1479.505n 3.3v 1489.495n 3.3v 1489.505n 3.3v 1499.495n 3.3v 1499.505n 0.0v 1509.495n 0.0v 1509.505n 0.0v 1519.495n 0.0v 1519.505n 0.0v 1529.495n 0.0v 1529.505n 0.0v 1539.495n 0.0v 1539.505n 0.0v 1549.495n 0.0v 1549.505n 0.0v 1559.495n 0.0v 1559.505n 0.0v 1569.495n 0.0v 1569.505n 0.0v 1579.495n 0.0v 1579.505n 0.0v 1589.495n 0.0v 1589.505n 3.3v 1599.495n 3.3v 1599.505n 3.3v 1609.495n 3.3v 1609.505n 3.3v 1619.495n 3.3v 1619.505n 0.0v 1629.495n 0.0v 1629.505n 0.0v 1639.495n 0.0v 1639.505n 0.0v 1649.495n 0.0v 1649.505n 0.0v 1659.495n 0.0v 1659.505n 3.3v 1669.495n 3.3v 1669.505n 3.3v 1679.495n 3.3v 1679.505n 3.3v 1689.495n 3.3v 1689.505n 3.3v 1699.495n 3.3v 1699.505n 0.0v 1709.495n 0.0v 1709.505n 3.3v 1719.495n 3.3v 1719.505n 3.3v 1729.495n 3.3v 1729.505n 3.3v 1739.495n 3.3v 1739.505n 3.3v 1749.495n 3.3v 1749.505n 3.3v 1759.495n 3.3v 1759.505n 3.3v 1769.495n 3.3v 1769.505n 0.0v 1779.495n 0.0v 1779.505n 0.0v 1789.495n 0.0v 1789.505n 0.0v 1799.495n 0.0v 1799.505n 0.0v 1809.495n 0.0v 1809.505n 0.0v 1819.495n 0.0v 1819.505n 0.0v 1829.495n 0.0v 1829.505n 0.0v 1839.495n 0.0v 1839.505n 3.3v 1849.495n 3.3v 1849.505n 3.3v 1859.495n 3.3v 1859.505n 3.3v 1869.495n 3.3v 1869.505n 3.3v 1879.495n 3.3v 1879.505n 0.0v 1889.495n 0.0v 1889.505n 0.0v 1899.495n 0.0v 1899.505n 0.0v 1909.495n 0.0v 1909.505n 0.0v 1919.495n 0.0v 1919.505n 0.0v 1929.495n 0.0v 1929.505n 0.0v 1939.495n 0.0v 1939.505n 0.0v 1949.495n 0.0v 1949.505n 0.0v 1959.495n 0.0v 1959.505n 0.0v 1969.495n 0.0v 1969.505n 0.0v 1979.495n 0.0v 1979.505n 0.0v 1989.495n 0.0v 1989.505n 0.0v 1999.495n 0.0v 1999.505n 0.0v 2009.495n 0.0v 2009.505n 0.0v 2019.495n 0.0v 2019.505n 0.0v 2029.495n 0.0v 2029.505n 0.0v 2039.495n 0.0v 2039.505n 0.0v 2049.495n 0.0v 2049.505n 0.0v )
* (time, data): [(0, 0), (10, 0), (20, 0), (30, 0), (40, 0), (50, 0), (60, 0), (70, 0), (80, 0), (90, 0), (100, 0), (110, 0), (120, 1), (130, 1), (140, 0), (150, 0), (160, 0), (170, 0), (180, 1), (190, 1), (200, 1), (210, 0), (220, 0), (230, 0), (240, 0), (250, 0), (260, 0), (270, 0), (280, 0), (290, 0), (300, 0), (310, 1), (320, 1), (330, 1), (340, 1), (350, 0), (360, 0), (370, 0), (380, 0), (390, 0), (400, 0), (410, 0), (420, 0), (430, 1), (440, 1), (450, 1), (460, 1), (470, 1), (480, 1), (490, 0), (500, 1), (510, 1), (520, 0), (530, 0), (540, 0), (550, 0), (560, 1), (570, 1), (580, 1), (590, 1), (600, 1), (610, 1), (620, 1), (630, 1), (640, 1), (650, 1), (660, 1), (670, 0), (680, 0), (690, 0), (700, 0), (710, 0), (720, 0), (730, 0), (740, 0), (750, 0), (760, 0), (770, 0), (780, 0), (790, 0), (800, 0), (810, 0), (820, 0), (830, 0), (840, 0), (850, 0), (860, 0), (870, 0), (880, 1), (890, 1), (900, 1), (910, 1), (920, 1), (930, 1), (940, 1), (950, 0), (960, 0), (970, 0), (980, 0), (990, 0), (1000, 0), (1010, 0), (1020, 0), (1030, 1), (1040, 1), (1050, 1), (1060, 1), (1070, 1), (1080, 1), (1090, 1), (1100, 1), (1110, 1), (1120, 1), (1130, 1), (1140, 1), (1150, 1), (1160, 1), (1170, 1), (1180, 1), (1190, 1), (1200, 1), (1210, 1), (1220, 0), (1230, 0), (1240, 0), (1250, 0), (1260, 1), (1270, 1), (1280, 1), (1290, 1), (1300, 1), (1310, 1), (1320, 1), (1330, 1), (1340, 1), (1350, 1), (1360, 0), (1370, 1), (1380, 1), (1390, 1), (1400, 1), (1410, 1), (1420, 1), (1430, 1), (1440, 0), (1450, 0), (1460, 1), (1470, 1), (1480, 1), (1490, 1), (1500, 0), (1510, 1), (1520, 1), (1530, 0), (1540, 0), (1550, 0), (1560, 0), (1570, 0), (1580, 0), (1590, 1), (1600, 1), (1610, 1), (1620, 1), (1630, 1), (1640, 1), (1650, 1), (1660, 0), (1670, 0), (1680, 0), (1690, 0), (1700, 1), (1710, 1), (1720, 1), (1730, 1), (1740, 1), (1750, 1), (1760, 1), (1770, 0), (1780, 0), (1790, 0), (1800, 0), (1810, 0), (1820, 0), (1830, 0), (1840, 0), (1850, 1), (1860, 1), (1870, 1), (1880, 0), (1890, 1), (1900, 1), (1910, 1), (1920, 1), (1930, 1), (1940, 1), (1950, 1), (1960, 1), (1970, 1), (1980, 0), (1990, 0), (2000, 0), (2010, 1), (2020, 1), (2030, 1), (2040, 1), (2050, 1)]
Vdin0_11  din0_11  0 PWL (0n 0.0v 9.495n 0.0v 9.505n 0.0v 19.495n 0.0v 19.505n 0.0v 29.495n 0.0v 29.505n 0.0v 39.495n 0.0v 39.505n 0.0v 49.495n 0.0v 49.505n 0.0v 59.495n 0.0v 59.505n 0.0v 69.495n 0.0v 69.505n 0.0v 79.495n 0.0v 79.505n 0.0v 89.495n 0.0v 89.505n 0.0v 99.495n 0.0v 99.505n 0.0v 109.495n 0.0v 109.505n 0.0v 119.495n 0.0v 119.505n 3.3v 129.495n 3.3v 129.505n 3.3v 139.495n 3.3v 139.505n 0.0v 149.495n 0.0v 149.505n 0.0v 159.495n 0.0v 159.505n 0.0v 169.495n 0.0v 169.505n 0.0v 179.495n 0.0v 179.505n 3.3v 189.495n 3.3v 189.505n 3.3v 199.495n 3.3v 199.505n 3.3v 209.495n 3.3v 209.505n 0.0v 219.495n 0.0v 219.505n 0.0v 229.495n 0.0v 229.505n 0.0v 239.495n 0.0v 239.505n 0.0v 249.495n 0.0v 249.505n 0.0v 259.495n 0.0v 259.505n 0.0v 269.495n 0.0v 269.505n 0.0v 279.495n 0.0v 279.505n 0.0v 289.495n 0.0v 289.505n 0.0v 299.495n 0.0v 299.505n 0.0v 309.495n 0.0v 309.505n 3.3v 319.495n 3.3v 319.505n 3.3v 329.495n 3.3v 329.505n 3.3v 339.495n 3.3v 339.505n 3.3v 349.495n 3.3v 349.505n 0.0v 359.495n 0.0v 359.505n 0.0v 369.495n 0.0v 369.505n 0.0v 379.495n 0.0v 379.505n 0.0v 389.495n 0.0v 389.505n 0.0v 399.495n 0.0v 399.505n 0.0v 409.495n 0.0v 409.505n 0.0v 419.495n 0.0v 419.505n 0.0v 429.495n 0.0v 429.505n 3.3v 439.495n 3.3v 439.505n 3.3v 449.495n 3.3v 449.505n 3.3v 459.495n 3.3v 459.505n 3.3v 469.495n 3.3v 469.505n 3.3v 479.495n 3.3v 479.505n 3.3v 489.495n 3.3v 489.505n 0.0v 499.495n 0.0v 499.505n 3.3v 509.495n 3.3v 509.505n 3.3v 519.495n 3.3v 519.505n 0.0v 529.495n 0.0v 529.505n 0.0v 539.495n 0.0v 539.505n 0.0v 549.495n 0.0v 549.505n 0.0v 559.495n 0.0v 559.505n 3.3v 569.495n 3.3v 569.505n 3.3v 579.495n 3.3v 579.505n 3.3v 589.495n 3.3v 589.505n 3.3v 599.495n 3.3v 599.505n 3.3v 609.495n 3.3v 609.505n 3.3v 619.495n 3.3v 619.505n 3.3v 629.495n 3.3v 629.505n 3.3v 639.495n 3.3v 639.505n 3.3v 649.495n 3.3v 649.505n 3.3v 659.495n 3.3v 659.505n 3.3v 669.495n 3.3v 669.505n 0.0v 679.495n 0.0v 679.505n 0.0v 689.495n 0.0v 689.505n 0.0v 699.495n 0.0v 699.505n 0.0v 709.495n 0.0v 709.505n 0.0v 719.495n 0.0v 719.505n 0.0v 729.495n 0.0v 729.505n 0.0v 739.495n 0.0v 739.505n 0.0v 749.495n 0.0v 749.505n 0.0v 759.495n 0.0v 759.505n 0.0v 769.495n 0.0v 769.505n 0.0v 779.495n 0.0v 779.505n 0.0v 789.495n 0.0v 789.505n 0.0v 799.495n 0.0v 799.505n 0.0v 809.495n 0.0v 809.505n 0.0v 819.495n 0.0v 819.505n 0.0v 829.495n 0.0v 829.505n 0.0v 839.495n 0.0v 839.505n 0.0v 849.495n 0.0v 849.505n 0.0v 859.495n 0.0v 859.505n 0.0v 869.495n 0.0v 869.505n 0.0v 879.495n 0.0v 879.505n 3.3v 889.495n 3.3v 889.505n 3.3v 899.495n 3.3v 899.505n 3.3v 909.495n 3.3v 909.505n 3.3v 919.495n 3.3v 919.505n 3.3v 929.495n 3.3v 929.505n 3.3v 939.495n 3.3v 939.505n 3.3v 949.495n 3.3v 949.505n 0.0v 959.495n 0.0v 959.505n 0.0v 969.495n 0.0v 969.505n 0.0v 979.495n 0.0v 979.505n 0.0v 989.495n 0.0v 989.505n 0.0v 999.495n 0.0v 999.505n 0.0v 1009.495n 0.0v 1009.505n 0.0v 1019.495n 0.0v 1019.505n 0.0v 1029.495n 0.0v 1029.505n 3.3v 1039.495n 3.3v 1039.505n 3.3v 1049.495n 3.3v 1049.505n 3.3v 1059.495n 3.3v 1059.505n 3.3v 1069.495n 3.3v 1069.505n 3.3v 1079.495n 3.3v 1079.505n 3.3v 1089.495n 3.3v 1089.505n 3.3v 1099.495n 3.3v 1099.505n 3.3v 1109.495n 3.3v 1109.505n 3.3v 1119.495n 3.3v 1119.505n 3.3v 1129.495n 3.3v 1129.505n 3.3v 1139.495n 3.3v 1139.505n 3.3v 1149.495n 3.3v 1149.505n 3.3v 1159.495n 3.3v 1159.505n 3.3v 1169.495n 3.3v 1169.505n 3.3v 1179.495n 3.3v 1179.505n 3.3v 1189.495n 3.3v 1189.505n 3.3v 1199.495n 3.3v 1199.505n 3.3v 1209.495n 3.3v 1209.505n 3.3v 1219.495n 3.3v 1219.505n 0.0v 1229.495n 0.0v 1229.505n 0.0v 1239.495n 0.0v 1239.505n 0.0v 1249.495n 0.0v 1249.505n 0.0v 1259.495n 0.0v 1259.505n 3.3v 1269.495n 3.3v 1269.505n 3.3v 1279.495n 3.3v 1279.505n 3.3v 1289.495n 3.3v 1289.505n 3.3v 1299.495n 3.3v 1299.505n 3.3v 1309.495n 3.3v 1309.505n 3.3v 1319.495n 3.3v 1319.505n 3.3v 1329.495n 3.3v 1329.505n 3.3v 1339.495n 3.3v 1339.505n 3.3v 1349.495n 3.3v 1349.505n 3.3v 1359.495n 3.3v 1359.505n 0.0v 1369.495n 0.0v 1369.505n 3.3v 1379.495n 3.3v 1379.505n 3.3v 1389.495n 3.3v 1389.505n 3.3v 1399.495n 3.3v 1399.505n 3.3v 1409.495n 3.3v 1409.505n 3.3v 1419.495n 3.3v 1419.505n 3.3v 1429.495n 3.3v 1429.505n 3.3v 1439.495n 3.3v 1439.505n 0.0v 1449.495n 0.0v 1449.505n 0.0v 1459.495n 0.0v 1459.505n 3.3v 1469.495n 3.3v 1469.505n 3.3v 1479.495n 3.3v 1479.505n 3.3v 1489.495n 3.3v 1489.505n 3.3v 1499.495n 3.3v 1499.505n 0.0v 1509.495n 0.0v 1509.505n 3.3v 1519.495n 3.3v 1519.505n 3.3v 1529.495n 3.3v 1529.505n 0.0v 1539.495n 0.0v 1539.505n 0.0v 1549.495n 0.0v 1549.505n 0.0v 1559.495n 0.0v 1559.505n 0.0v 1569.495n 0.0v 1569.505n 0.0v 1579.495n 0.0v 1579.505n 0.0v 1589.495n 0.0v 1589.505n 3.3v 1599.495n 3.3v 1599.505n 3.3v 1609.495n 3.3v 1609.505n 3.3v 1619.495n 3.3v 1619.505n 3.3v 1629.495n 3.3v 1629.505n 3.3v 1639.495n 3.3v 1639.505n 3.3v 1649.495n 3.3v 1649.505n 3.3v 1659.495n 3.3v 1659.505n 0.0v 1669.495n 0.0v 1669.505n 0.0v 1679.495n 0.0v 1679.505n 0.0v 1689.495n 0.0v 1689.505n 0.0v 1699.495n 0.0v 1699.505n 3.3v 1709.495n 3.3v 1709.505n 3.3v 1719.495n 3.3v 1719.505n 3.3v 1729.495n 3.3v 1729.505n 3.3v 1739.495n 3.3v 1739.505n 3.3v 1749.495n 3.3v 1749.505n 3.3v 1759.495n 3.3v 1759.505n 3.3v 1769.495n 3.3v 1769.505n 0.0v 1779.495n 0.0v 1779.505n 0.0v 1789.495n 0.0v 1789.505n 0.0v 1799.495n 0.0v 1799.505n 0.0v 1809.495n 0.0v 1809.505n 0.0v 1819.495n 0.0v 1819.505n 0.0v 1829.495n 0.0v 1829.505n 0.0v 1839.495n 0.0v 1839.505n 0.0v 1849.495n 0.0v 1849.505n 3.3v 1859.495n 3.3v 1859.505n 3.3v 1869.495n 3.3v 1869.505n 3.3v 1879.495n 3.3v 1879.505n 0.0v 1889.495n 0.0v 1889.505n 3.3v 1899.495n 3.3v 1899.505n 3.3v 1909.495n 3.3v 1909.505n 3.3v 1919.495n 3.3v 1919.505n 3.3v 1929.495n 3.3v 1929.505n 3.3v 1939.495n 3.3v 1939.505n 3.3v 1949.495n 3.3v 1949.505n 3.3v 1959.495n 3.3v 1959.505n 3.3v 1969.495n 3.3v 1969.505n 3.3v 1979.495n 3.3v 1979.505n 0.0v 1989.495n 0.0v 1989.505n 0.0v 1999.495n 0.0v 1999.505n 0.0v 2009.495n 0.0v 2009.505n 3.3v 2019.495n 3.3v 2019.505n 3.3v 2029.495n 3.3v 2029.505n 3.3v 2039.495n 3.3v 2039.505n 3.3v 2049.495n 3.3v 2049.505n 3.3v )
* (time, data): [(0, 0), (10, 1), (20, 1), (30, 1), (40, 1), (50, 1), (60, 1), (70, 1), (80, 1), (90, 1), (100, 1), (110, 1), (120, 0), (130, 0), (140, 1), (150, 1), (160, 1), (170, 0), (180, 0), (190, 1), (200, 1), (210, 1), (220, 0), (230, 0), (240, 0), (250, 0), (260, 0), (270, 0), (280, 0), (290, 0), (300, 0), (310, 1), (320, 0), (330, 0), (340, 0), (350, 0), (360, 0), (370, 0), (380, 0), (390, 0), (400, 0), (410, 0), (420, 0), (430, 0), (440, 0), (450, 1), (460, 1), (470, 1), (480, 1), (490, 1), (500, 0), (510, 1), (520, 0), (530, 0), (540, 0), (550, 0), (560, 1), (570, 0), (580, 0), (590, 0), (600, 0), (610, 0), (620, 0), (630, 0), (640, 0), (650, 0), (660, 0), (670, 1), (680, 1), (690, 1), (700, 1), (710, 1), (720, 1), (730, 1), (740, 0), (750, 0), (760, 0), (770, 0), (780, 0), (790, 0), (800, 0), (810, 0), (820, 0), (830, 0), (840, 1), (850, 1), (860, 1), (870, 1), (880, 1), (890, 0), (900, 0), (910, 0), (920, 0), (930, 0), (940, 0), (950, 1), (960, 1), (970, 1), (980, 0), (990, 0), (1000, 0), (1010, 0), (1020, 0), (1030, 1), (1040, 0), (1050, 0), (1060, 0), (1070, 0), (1080, 0), (1090, 0), (1100, 0), (1110, 0), (1120, 0), (1130, 0), (1140, 0), (1150, 0), (1160, 0), (1170, 0), (1180, 0), (1190, 0), (1200, 0), (1210, 0), (1220, 0), (1230, 0), (1240, 0), (1250, 0), (1260, 1), (1270, 1), (1280, 1), (1290, 1), (1300, 1), (1310, 1), (1320, 1), (1330, 1), (1340, 1), (1350, 1), (1360, 0), (1370, 0), (1380, 0), (1390, 0), (1400, 0), (1410, 0), (1420, 0), (1430, 0), (1440, 1), (1450, 1), (1460, 0), (1470, 0), (1480, 0), (1490, 0), (1500, 1), (1510, 0), (1520, 0), (1530, 1), (1540, 1), (1550, 1), (1560, 1), (1570, 1), (1580, 1), (1590, 0), (1600, 0), (1610, 0), (1620, 0), (1630, 0), (1640, 0), (1650, 0), (1660, 0), (1670, 0), (1680, 0), (1690, 0), (1700, 0), (1710, 1), (1720, 0), (1730, 0), (1740, 0), (1750, 0), (1760, 0), (1770, 1), (1780, 1), (1790, 1), (1800, 1), (1810, 1), (1820, 1), (1830, 1), (1840, 1), (1850, 0), (1860, 0), (1870, 0), (1880, 1), (1890, 1), (1900, 1), (1910, 1), (1920, 1), (1930, 1), (1940, 1), (1950, 1), (1960, 1), (1970, 1), (1980, 1), (1990, 1), (2000, 1), (2010, 0), (2020, 0), (2030, 0), (2040, 0), (2050, 0)]
Vdin0_12  din0_12  0 PWL (0n 0.0v 9.495n 0.0v 9.505n 3.3v 19.495n 3.3v 19.505n 3.3v 29.495n 3.3v 29.505n 3.3v 39.495n 3.3v 39.505n 3.3v 49.495n 3.3v 49.505n 3.3v 59.495n 3.3v 59.505n 3.3v 69.495n 3.3v 69.505n 3.3v 79.495n 3.3v 79.505n 3.3v 89.495n 3.3v 89.505n 3.3v 99.495n 3.3v 99.505n 3.3v 109.495n 3.3v 109.505n 3.3v 119.495n 3.3v 119.505n 0.0v 129.495n 0.0v 129.505n 0.0v 139.495n 0.0v 139.505n 3.3v 149.495n 3.3v 149.505n 3.3v 159.495n 3.3v 159.505n 3.3v 169.495n 3.3v 169.505n 0.0v 179.495n 0.0v 179.505n 0.0v 189.495n 0.0v 189.505n 3.3v 199.495n 3.3v 199.505n 3.3v 209.495n 3.3v 209.505n 3.3v 219.495n 3.3v 219.505n 0.0v 229.495n 0.0v 229.505n 0.0v 239.495n 0.0v 239.505n 0.0v 249.495n 0.0v 249.505n 0.0v 259.495n 0.0v 259.505n 0.0v 269.495n 0.0v 269.505n 0.0v 279.495n 0.0v 279.505n 0.0v 289.495n 0.0v 289.505n 0.0v 299.495n 0.0v 299.505n 0.0v 309.495n 0.0v 309.505n 3.3v 319.495n 3.3v 319.505n 0.0v 329.495n 0.0v 329.505n 0.0v 339.495n 0.0v 339.505n 0.0v 349.495n 0.0v 349.505n 0.0v 359.495n 0.0v 359.505n 0.0v 369.495n 0.0v 369.505n 0.0v 379.495n 0.0v 379.505n 0.0v 389.495n 0.0v 389.505n 0.0v 399.495n 0.0v 399.505n 0.0v 409.495n 0.0v 409.505n 0.0v 419.495n 0.0v 419.505n 0.0v 429.495n 0.0v 429.505n 0.0v 439.495n 0.0v 439.505n 0.0v 449.495n 0.0v 449.505n 3.3v 459.495n 3.3v 459.505n 3.3v 469.495n 3.3v 469.505n 3.3v 479.495n 3.3v 479.505n 3.3v 489.495n 3.3v 489.505n 3.3v 499.495n 3.3v 499.505n 0.0v 509.495n 0.0v 509.505n 3.3v 519.495n 3.3v 519.505n 0.0v 529.495n 0.0v 529.505n 0.0v 539.495n 0.0v 539.505n 0.0v 549.495n 0.0v 549.505n 0.0v 559.495n 0.0v 559.505n 3.3v 569.495n 3.3v 569.505n 0.0v 579.495n 0.0v 579.505n 0.0v 589.495n 0.0v 589.505n 0.0v 599.495n 0.0v 599.505n 0.0v 609.495n 0.0v 609.505n 0.0v 619.495n 0.0v 619.505n 0.0v 629.495n 0.0v 629.505n 0.0v 639.495n 0.0v 639.505n 0.0v 649.495n 0.0v 649.505n 0.0v 659.495n 0.0v 659.505n 0.0v 669.495n 0.0v 669.505n 3.3v 679.495n 3.3v 679.505n 3.3v 689.495n 3.3v 689.505n 3.3v 699.495n 3.3v 699.505n 3.3v 709.495n 3.3v 709.505n 3.3v 719.495n 3.3v 719.505n 3.3v 729.495n 3.3v 729.505n 3.3v 739.495n 3.3v 739.505n 0.0v 749.495n 0.0v 749.505n 0.0v 759.495n 0.0v 759.505n 0.0v 769.495n 0.0v 769.505n 0.0v 779.495n 0.0v 779.505n 0.0v 789.495n 0.0v 789.505n 0.0v 799.495n 0.0v 799.505n 0.0v 809.495n 0.0v 809.505n 0.0v 819.495n 0.0v 819.505n 0.0v 829.495n 0.0v 829.505n 0.0v 839.495n 0.0v 839.505n 3.3v 849.495n 3.3v 849.505n 3.3v 859.495n 3.3v 859.505n 3.3v 869.495n 3.3v 869.505n 3.3v 879.495n 3.3v 879.505n 3.3v 889.495n 3.3v 889.505n 0.0v 899.495n 0.0v 899.505n 0.0v 909.495n 0.0v 909.505n 0.0v 919.495n 0.0v 919.505n 0.0v 929.495n 0.0v 929.505n 0.0v 939.495n 0.0v 939.505n 0.0v 949.495n 0.0v 949.505n 3.3v 959.495n 3.3v 959.505n 3.3v 969.495n 3.3v 969.505n 3.3v 979.495n 3.3v 979.505n 0.0v 989.495n 0.0v 989.505n 0.0v 999.495n 0.0v 999.505n 0.0v 1009.495n 0.0v 1009.505n 0.0v 1019.495n 0.0v 1019.505n 0.0v 1029.495n 0.0v 1029.505n 3.3v 1039.495n 3.3v 1039.505n 0.0v 1049.495n 0.0v 1049.505n 0.0v 1059.495n 0.0v 1059.505n 0.0v 1069.495n 0.0v 1069.505n 0.0v 1079.495n 0.0v 1079.505n 0.0v 1089.495n 0.0v 1089.505n 0.0v 1099.495n 0.0v 1099.505n 0.0v 1109.495n 0.0v 1109.505n 0.0v 1119.495n 0.0v 1119.505n 0.0v 1129.495n 0.0v 1129.505n 0.0v 1139.495n 0.0v 1139.505n 0.0v 1149.495n 0.0v 1149.505n 0.0v 1159.495n 0.0v 1159.505n 0.0v 1169.495n 0.0v 1169.505n 0.0v 1179.495n 0.0v 1179.505n 0.0v 1189.495n 0.0v 1189.505n 0.0v 1199.495n 0.0v 1199.505n 0.0v 1209.495n 0.0v 1209.505n 0.0v 1219.495n 0.0v 1219.505n 0.0v 1229.495n 0.0v 1229.505n 0.0v 1239.495n 0.0v 1239.505n 0.0v 1249.495n 0.0v 1249.505n 0.0v 1259.495n 0.0v 1259.505n 3.3v 1269.495n 3.3v 1269.505n 3.3v 1279.495n 3.3v 1279.505n 3.3v 1289.495n 3.3v 1289.505n 3.3v 1299.495n 3.3v 1299.505n 3.3v 1309.495n 3.3v 1309.505n 3.3v 1319.495n 3.3v 1319.505n 3.3v 1329.495n 3.3v 1329.505n 3.3v 1339.495n 3.3v 1339.505n 3.3v 1349.495n 3.3v 1349.505n 3.3v 1359.495n 3.3v 1359.505n 0.0v 1369.495n 0.0v 1369.505n 0.0v 1379.495n 0.0v 1379.505n 0.0v 1389.495n 0.0v 1389.505n 0.0v 1399.495n 0.0v 1399.505n 0.0v 1409.495n 0.0v 1409.505n 0.0v 1419.495n 0.0v 1419.505n 0.0v 1429.495n 0.0v 1429.505n 0.0v 1439.495n 0.0v 1439.505n 3.3v 1449.495n 3.3v 1449.505n 3.3v 1459.495n 3.3v 1459.505n 0.0v 1469.495n 0.0v 1469.505n 0.0v 1479.495n 0.0v 1479.505n 0.0v 1489.495n 0.0v 1489.505n 0.0v 1499.495n 0.0v 1499.505n 3.3v 1509.495n 3.3v 1509.505n 0.0v 1519.495n 0.0v 1519.505n 0.0v 1529.495n 0.0v 1529.505n 3.3v 1539.495n 3.3v 1539.505n 3.3v 1549.495n 3.3v 1549.505n 3.3v 1559.495n 3.3v 1559.505n 3.3v 1569.495n 3.3v 1569.505n 3.3v 1579.495n 3.3v 1579.505n 3.3v 1589.495n 3.3v 1589.505n 0.0v 1599.495n 0.0v 1599.505n 0.0v 1609.495n 0.0v 1609.505n 0.0v 1619.495n 0.0v 1619.505n 0.0v 1629.495n 0.0v 1629.505n 0.0v 1639.495n 0.0v 1639.505n 0.0v 1649.495n 0.0v 1649.505n 0.0v 1659.495n 0.0v 1659.505n 0.0v 1669.495n 0.0v 1669.505n 0.0v 1679.495n 0.0v 1679.505n 0.0v 1689.495n 0.0v 1689.505n 0.0v 1699.495n 0.0v 1699.505n 0.0v 1709.495n 0.0v 1709.505n 3.3v 1719.495n 3.3v 1719.505n 0.0v 1729.495n 0.0v 1729.505n 0.0v 1739.495n 0.0v 1739.505n 0.0v 1749.495n 0.0v 1749.505n 0.0v 1759.495n 0.0v 1759.505n 0.0v 1769.495n 0.0v 1769.505n 3.3v 1779.495n 3.3v 1779.505n 3.3v 1789.495n 3.3v 1789.505n 3.3v 1799.495n 3.3v 1799.505n 3.3v 1809.495n 3.3v 1809.505n 3.3v 1819.495n 3.3v 1819.505n 3.3v 1829.495n 3.3v 1829.505n 3.3v 1839.495n 3.3v 1839.505n 3.3v 1849.495n 3.3v 1849.505n 0.0v 1859.495n 0.0v 1859.505n 0.0v 1869.495n 0.0v 1869.505n 0.0v 1879.495n 0.0v 1879.505n 3.3v 1889.495n 3.3v 1889.505n 3.3v 1899.495n 3.3v 1899.505n 3.3v 1909.495n 3.3v 1909.505n 3.3v 1919.495n 3.3v 1919.505n 3.3v 1929.495n 3.3v 1929.505n 3.3v 1939.495n 3.3v 1939.505n 3.3v 1949.495n 3.3v 1949.505n 3.3v 1959.495n 3.3v 1959.505n 3.3v 1969.495n 3.3v 1969.505n 3.3v 1979.495n 3.3v 1979.505n 3.3v 1989.495n 3.3v 1989.505n 3.3v 1999.495n 3.3v 1999.505n 3.3v 2009.495n 3.3v 2009.505n 0.0v 2019.495n 0.0v 2019.505n 0.0v 2029.495n 0.0v 2029.505n 0.0v 2039.495n 0.0v 2039.505n 0.0v 2049.495n 0.0v 2049.505n 0.0v )
* (time, data): [(0, 0), (10, 1), (20, 0), (30, 1), (40, 1), (50, 1), (60, 1), (70, 1), (80, 1), (90, 1), (100, 1), (110, 1), (120, 1), (130, 1), (140, 0), (150, 1), (160, 1), (170, 1), (180, 0), (190, 0), (200, 1), (210, 1), (220, 1), (230, 1), (240, 1), (250, 1), (260, 1), (270, 0), (280, 0), (290, 0), (300, 0), (310, 1), (320, 0), (330, 0), (340, 0), (350, 0), (360, 0), (370, 0), (380, 0), (390, 0), (400, 0), (410, 0), (420, 0), (430, 0), (440, 0), (450, 1), (460, 1), (470, 1), (480, 1), (490, 0), (500, 0), (510, 0), (520, 1), (530, 1), (540, 1), (550, 0), (560, 1), (570, 0), (580, 0), (590, 0), (600, 0), (610, 0), (620, 0), (630, 0), (640, 0), (650, 0), (660, 0), (670, 0), (680, 0), (690, 0), (700, 0), (710, 0), (720, 0), (730, 0), (740, 0), (750, 0), (760, 0), (770, 0), (780, 0), (790, 0), (800, 0), (810, 0), (820, 0), (830, 0), (840, 0), (850, 0), (860, 0), (870, 0), (880, 0), (890, 0), (900, 0), (910, 0), (920, 1), (930, 1), (940, 1), (950, 1), (960, 1), (970, 1), (980, 1), (990, 1), (1000, 1), (1010, 1), (1020, 1), (1030, 0), (1040, 0), (1050, 0), (1060, 0), (1070, 0), (1080, 0), (1090, 0), (1100, 0), (1110, 0), (1120, 0), (1130, 0), (1140, 0), (1150, 0), (1160, 0), (1170, 0), (1180, 1), (1190, 1), (1200, 1), (1210, 1), (1220, 0), (1230, 0), (1240, 0), (1250, 0), (1260, 1), (1270, 1), (1280, 1), (1290, 1), (1300, 1), (1310, 1), (1320, 1), (1330, 1), (1340, 1), (1350, 1), (1360, 1), (1370, 1), (1380, 1), (1390, 1), (1400, 1), (1410, 1), (1420, 1), (1430, 1), (1440, 1), (1450, 1), (1460, 0), (1470, 0), (1480, 0), (1490, 0), (1500, 0), (1510, 1), (1520, 1), (1530, 0), (1540, 0), (1550, 0), (1560, 0), (1570, 0), (1580, 0), (1590, 1), (1600, 1), (1610, 1), (1620, 0), (1630, 0), (1640, 0), (1650, 0), (1660, 1), (1670, 1), (1680, 1), (1690, 1), (1700, 0), (1710, 1), (1720, 1), (1730, 1), (1740, 1), (1750, 1), (1760, 1), (1770, 1), (1780, 1), (1790, 1), (1800, 1), (1810, 1), (1820, 1), (1830, 1), (1840, 1), (1850, 1), (1860, 1), (1870, 1), (1880, 0), (1890, 1), (1900, 1), (1910, 1), (1920, 1), (1930, 1), (1940, 1), (1950, 1), (1960, 1), (1970, 1), (1980, 0), (1990, 0), (2000, 0), (2010, 1), (2020, 1), (2030, 1), (2040, 1), (2050, 1)]
Vdin0_13  din0_13  0 PWL (0n 0.0v 9.495n 0.0v 9.505n 3.3v 19.495n 3.3v 19.505n 0.0v 29.495n 0.0v 29.505n 3.3v 39.495n 3.3v 39.505n 3.3v 49.495n 3.3v 49.505n 3.3v 59.495n 3.3v 59.505n 3.3v 69.495n 3.3v 69.505n 3.3v 79.495n 3.3v 79.505n 3.3v 89.495n 3.3v 89.505n 3.3v 99.495n 3.3v 99.505n 3.3v 109.495n 3.3v 109.505n 3.3v 119.495n 3.3v 119.505n 3.3v 129.495n 3.3v 129.505n 3.3v 139.495n 3.3v 139.505n 0.0v 149.495n 0.0v 149.505n 3.3v 159.495n 3.3v 159.505n 3.3v 169.495n 3.3v 169.505n 3.3v 179.495n 3.3v 179.505n 0.0v 189.495n 0.0v 189.505n 0.0v 199.495n 0.0v 199.505n 3.3v 209.495n 3.3v 209.505n 3.3v 219.495n 3.3v 219.505n 3.3v 229.495n 3.3v 229.505n 3.3v 239.495n 3.3v 239.505n 3.3v 249.495n 3.3v 249.505n 3.3v 259.495n 3.3v 259.505n 3.3v 269.495n 3.3v 269.505n 0.0v 279.495n 0.0v 279.505n 0.0v 289.495n 0.0v 289.505n 0.0v 299.495n 0.0v 299.505n 0.0v 309.495n 0.0v 309.505n 3.3v 319.495n 3.3v 319.505n 0.0v 329.495n 0.0v 329.505n 0.0v 339.495n 0.0v 339.505n 0.0v 349.495n 0.0v 349.505n 0.0v 359.495n 0.0v 359.505n 0.0v 369.495n 0.0v 369.505n 0.0v 379.495n 0.0v 379.505n 0.0v 389.495n 0.0v 389.505n 0.0v 399.495n 0.0v 399.505n 0.0v 409.495n 0.0v 409.505n 0.0v 419.495n 0.0v 419.505n 0.0v 429.495n 0.0v 429.505n 0.0v 439.495n 0.0v 439.505n 0.0v 449.495n 0.0v 449.505n 3.3v 459.495n 3.3v 459.505n 3.3v 469.495n 3.3v 469.505n 3.3v 479.495n 3.3v 479.505n 3.3v 489.495n 3.3v 489.505n 0.0v 499.495n 0.0v 499.505n 0.0v 509.495n 0.0v 509.505n 0.0v 519.495n 0.0v 519.505n 3.3v 529.495n 3.3v 529.505n 3.3v 539.495n 3.3v 539.505n 3.3v 549.495n 3.3v 549.505n 0.0v 559.495n 0.0v 559.505n 3.3v 569.495n 3.3v 569.505n 0.0v 579.495n 0.0v 579.505n 0.0v 589.495n 0.0v 589.505n 0.0v 599.495n 0.0v 599.505n 0.0v 609.495n 0.0v 609.505n 0.0v 619.495n 0.0v 619.505n 0.0v 629.495n 0.0v 629.505n 0.0v 639.495n 0.0v 639.505n 0.0v 649.495n 0.0v 649.505n 0.0v 659.495n 0.0v 659.505n 0.0v 669.495n 0.0v 669.505n 0.0v 679.495n 0.0v 679.505n 0.0v 689.495n 0.0v 689.505n 0.0v 699.495n 0.0v 699.505n 0.0v 709.495n 0.0v 709.505n 0.0v 719.495n 0.0v 719.505n 0.0v 729.495n 0.0v 729.505n 0.0v 739.495n 0.0v 739.505n 0.0v 749.495n 0.0v 749.505n 0.0v 759.495n 0.0v 759.505n 0.0v 769.495n 0.0v 769.505n 0.0v 779.495n 0.0v 779.505n 0.0v 789.495n 0.0v 789.505n 0.0v 799.495n 0.0v 799.505n 0.0v 809.495n 0.0v 809.505n 0.0v 819.495n 0.0v 819.505n 0.0v 829.495n 0.0v 829.505n 0.0v 839.495n 0.0v 839.505n 0.0v 849.495n 0.0v 849.505n 0.0v 859.495n 0.0v 859.505n 0.0v 869.495n 0.0v 869.505n 0.0v 879.495n 0.0v 879.505n 0.0v 889.495n 0.0v 889.505n 0.0v 899.495n 0.0v 899.505n 0.0v 909.495n 0.0v 909.505n 0.0v 919.495n 0.0v 919.505n 3.3v 929.495n 3.3v 929.505n 3.3v 939.495n 3.3v 939.505n 3.3v 949.495n 3.3v 949.505n 3.3v 959.495n 3.3v 959.505n 3.3v 969.495n 3.3v 969.505n 3.3v 979.495n 3.3v 979.505n 3.3v 989.495n 3.3v 989.505n 3.3v 999.495n 3.3v 999.505n 3.3v 1009.495n 3.3v 1009.505n 3.3v 1019.495n 3.3v 1019.505n 3.3v 1029.495n 3.3v 1029.505n 0.0v 1039.495n 0.0v 1039.505n 0.0v 1049.495n 0.0v 1049.505n 0.0v 1059.495n 0.0v 1059.505n 0.0v 1069.495n 0.0v 1069.505n 0.0v 1079.495n 0.0v 1079.505n 0.0v 1089.495n 0.0v 1089.505n 0.0v 1099.495n 0.0v 1099.505n 0.0v 1109.495n 0.0v 1109.505n 0.0v 1119.495n 0.0v 1119.505n 0.0v 1129.495n 0.0v 1129.505n 0.0v 1139.495n 0.0v 1139.505n 0.0v 1149.495n 0.0v 1149.505n 0.0v 1159.495n 0.0v 1159.505n 0.0v 1169.495n 0.0v 1169.505n 0.0v 1179.495n 0.0v 1179.505n 3.3v 1189.495n 3.3v 1189.505n 3.3v 1199.495n 3.3v 1199.505n 3.3v 1209.495n 3.3v 1209.505n 3.3v 1219.495n 3.3v 1219.505n 0.0v 1229.495n 0.0v 1229.505n 0.0v 1239.495n 0.0v 1239.505n 0.0v 1249.495n 0.0v 1249.505n 0.0v 1259.495n 0.0v 1259.505n 3.3v 1269.495n 3.3v 1269.505n 3.3v 1279.495n 3.3v 1279.505n 3.3v 1289.495n 3.3v 1289.505n 3.3v 1299.495n 3.3v 1299.505n 3.3v 1309.495n 3.3v 1309.505n 3.3v 1319.495n 3.3v 1319.505n 3.3v 1329.495n 3.3v 1329.505n 3.3v 1339.495n 3.3v 1339.505n 3.3v 1349.495n 3.3v 1349.505n 3.3v 1359.495n 3.3v 1359.505n 3.3v 1369.495n 3.3v 1369.505n 3.3v 1379.495n 3.3v 1379.505n 3.3v 1389.495n 3.3v 1389.505n 3.3v 1399.495n 3.3v 1399.505n 3.3v 1409.495n 3.3v 1409.505n 3.3v 1419.495n 3.3v 1419.505n 3.3v 1429.495n 3.3v 1429.505n 3.3v 1439.495n 3.3v 1439.505n 3.3v 1449.495n 3.3v 1449.505n 3.3v 1459.495n 3.3v 1459.505n 0.0v 1469.495n 0.0v 1469.505n 0.0v 1479.495n 0.0v 1479.505n 0.0v 1489.495n 0.0v 1489.505n 0.0v 1499.495n 0.0v 1499.505n 0.0v 1509.495n 0.0v 1509.505n 3.3v 1519.495n 3.3v 1519.505n 3.3v 1529.495n 3.3v 1529.505n 0.0v 1539.495n 0.0v 1539.505n 0.0v 1549.495n 0.0v 1549.505n 0.0v 1559.495n 0.0v 1559.505n 0.0v 1569.495n 0.0v 1569.505n 0.0v 1579.495n 0.0v 1579.505n 0.0v 1589.495n 0.0v 1589.505n 3.3v 1599.495n 3.3v 1599.505n 3.3v 1609.495n 3.3v 1609.505n 3.3v 1619.495n 3.3v 1619.505n 0.0v 1629.495n 0.0v 1629.505n 0.0v 1639.495n 0.0v 1639.505n 0.0v 1649.495n 0.0v 1649.505n 0.0v 1659.495n 0.0v 1659.505n 3.3v 1669.495n 3.3v 1669.505n 3.3v 1679.495n 3.3v 1679.505n 3.3v 1689.495n 3.3v 1689.505n 3.3v 1699.495n 3.3v 1699.505n 0.0v 1709.495n 0.0v 1709.505n 3.3v 1719.495n 3.3v 1719.505n 3.3v 1729.495n 3.3v 1729.505n 3.3v 1739.495n 3.3v 1739.505n 3.3v 1749.495n 3.3v 1749.505n 3.3v 1759.495n 3.3v 1759.505n 3.3v 1769.495n 3.3v 1769.505n 3.3v 1779.495n 3.3v 1779.505n 3.3v 1789.495n 3.3v 1789.505n 3.3v 1799.495n 3.3v 1799.505n 3.3v 1809.495n 3.3v 1809.505n 3.3v 1819.495n 3.3v 1819.505n 3.3v 1829.495n 3.3v 1829.505n 3.3v 1839.495n 3.3v 1839.505n 3.3v 1849.495n 3.3v 1849.505n 3.3v 1859.495n 3.3v 1859.505n 3.3v 1869.495n 3.3v 1869.505n 3.3v 1879.495n 3.3v 1879.505n 0.0v 1889.495n 0.0v 1889.505n 3.3v 1899.495n 3.3v 1899.505n 3.3v 1909.495n 3.3v 1909.505n 3.3v 1919.495n 3.3v 1919.505n 3.3v 1929.495n 3.3v 1929.505n 3.3v 1939.495n 3.3v 1939.505n 3.3v 1949.495n 3.3v 1949.505n 3.3v 1959.495n 3.3v 1959.505n 3.3v 1969.495n 3.3v 1969.505n 3.3v 1979.495n 3.3v 1979.505n 0.0v 1989.495n 0.0v 1989.505n 0.0v 1999.495n 0.0v 1999.505n 0.0v 2009.495n 0.0v 2009.505n 3.3v 2019.495n 3.3v 2019.505n 3.3v 2029.495n 3.3v 2029.505n 3.3v 2039.495n 3.3v 2039.505n 3.3v 2049.495n 3.3v 2049.505n 3.3v )
* (time, data): [(0, 0), (10, 0), (20, 0), (30, 1), (40, 1), (50, 1), (60, 1), (70, 1), (80, 1), (90, 1), (100, 1), (110, 1), (120, 1), (130, 1), (140, 1), (150, 0), (160, 0), (170, 1), (180, 1), (190, 1), (200, 0), (210, 1), (220, 1), (230, 1), (240, 0), (250, 1), (260, 1), (270, 1), (280, 1), (290, 1), (300, 1), (310, 0), (320, 1), (330, 1), (340, 1), (350, 0), (360, 0), (370, 0), (380, 0), (390, 0), (400, 0), (410, 0), (420, 0), (430, 1), (440, 1), (450, 1), (460, 1), (470, 1), (480, 1), (490, 1), (500, 1), (510, 0), (520, 1), (530, 1), (540, 1), (550, 1), (560, 1), (570, 1), (580, 1), (590, 1), (600, 1), (610, 1), (620, 1), (630, 1), (640, 1), (650, 1), (660, 1), (670, 0), (680, 0), (690, 0), (700, 0), (710, 0), (720, 0), (730, 0), (740, 0), (750, 0), (760, 0), (770, 0), (780, 0), (790, 0), (800, 0), (810, 0), (820, 0), (830, 0), (840, 1), (850, 1), (860, 1), (870, 1), (880, 1), (890, 1), (900, 1), (910, 1), (920, 0), (930, 0), (940, 0), (950, 1), (960, 1), (970, 1), (980, 1), (990, 1), (1000, 1), (1010, 1), (1020, 1), (1030, 1), (1040, 1), (1050, 1), (1060, 1), (1070, 1), (1080, 1), (1090, 1), (1100, 1), (1110, 1), (1120, 1), (1130, 1), (1140, 1), (1150, 1), (1160, 1), (1170, 1), (1180, 0), (1190, 0), (1200, 0), (1210, 0), (1220, 0), (1230, 0), (1240, 0), (1250, 0), (1260, 0), (1270, 0), (1280, 0), (1290, 0), (1300, 0), (1310, 0), (1320, 0), (1330, 0), (1340, 0), (1350, 0), (1360, 0), (1370, 1), (1380, 1), (1390, 1), (1400, 1), (1410, 1), (1420, 1), (1430, 1), (1440, 1), (1450, 1), (1460, 1), (1470, 1), (1480, 1), (1490, 1), (1500, 1), (1510, 1), (1520, 1), (1530, 0), (1540, 0), (1550, 0), (1560, 0), (1570, 0), (1580, 0), (1590, 1), (1600, 1), (1610, 1), (1620, 1), (1630, 1), (1640, 1), (1650, 1), (1660, 1), (1670, 1), (1680, 1), (1690, 1), (1700, 1), (1710, 0), (1720, 0), (1730, 0), (1740, 0), (1750, 0), (1760, 0), (1770, 1), (1780, 0), (1790, 0), (1800, 0), (1810, 0), (1820, 0), (1830, 0), (1840, 1), (1850, 1), (1860, 1), (1870, 1), (1880, 0), (1890, 1), (1900, 1), (1910, 1), (1920, 1), (1930, 0), (1940, 0), (1950, 0), (1960, 0), (1970, 0), (1980, 0), (1990, 0), (2000, 0), (2010, 1), (2020, 1), (2030, 1), (2040, 1), (2050, 1)]
Vdin0_14  din0_14  0 PWL (0n 0.0v 9.495n 0.0v 9.505n 0.0v 19.495n 0.0v 19.505n 0.0v 29.495n 0.0v 29.505n 3.3v 39.495n 3.3v 39.505n 3.3v 49.495n 3.3v 49.505n 3.3v 59.495n 3.3v 59.505n 3.3v 69.495n 3.3v 69.505n 3.3v 79.495n 3.3v 79.505n 3.3v 89.495n 3.3v 89.505n 3.3v 99.495n 3.3v 99.505n 3.3v 109.495n 3.3v 109.505n 3.3v 119.495n 3.3v 119.505n 3.3v 129.495n 3.3v 129.505n 3.3v 139.495n 3.3v 139.505n 3.3v 149.495n 3.3v 149.505n 0.0v 159.495n 0.0v 159.505n 0.0v 169.495n 0.0v 169.505n 3.3v 179.495n 3.3v 179.505n 3.3v 189.495n 3.3v 189.505n 3.3v 199.495n 3.3v 199.505n 0.0v 209.495n 0.0v 209.505n 3.3v 219.495n 3.3v 219.505n 3.3v 229.495n 3.3v 229.505n 3.3v 239.495n 3.3v 239.505n 0.0v 249.495n 0.0v 249.505n 3.3v 259.495n 3.3v 259.505n 3.3v 269.495n 3.3v 269.505n 3.3v 279.495n 3.3v 279.505n 3.3v 289.495n 3.3v 289.505n 3.3v 299.495n 3.3v 299.505n 3.3v 309.495n 3.3v 309.505n 0.0v 319.495n 0.0v 319.505n 3.3v 329.495n 3.3v 329.505n 3.3v 339.495n 3.3v 339.505n 3.3v 349.495n 3.3v 349.505n 0.0v 359.495n 0.0v 359.505n 0.0v 369.495n 0.0v 369.505n 0.0v 379.495n 0.0v 379.505n 0.0v 389.495n 0.0v 389.505n 0.0v 399.495n 0.0v 399.505n 0.0v 409.495n 0.0v 409.505n 0.0v 419.495n 0.0v 419.505n 0.0v 429.495n 0.0v 429.505n 3.3v 439.495n 3.3v 439.505n 3.3v 449.495n 3.3v 449.505n 3.3v 459.495n 3.3v 459.505n 3.3v 469.495n 3.3v 469.505n 3.3v 479.495n 3.3v 479.505n 3.3v 489.495n 3.3v 489.505n 3.3v 499.495n 3.3v 499.505n 3.3v 509.495n 3.3v 509.505n 0.0v 519.495n 0.0v 519.505n 3.3v 529.495n 3.3v 529.505n 3.3v 539.495n 3.3v 539.505n 3.3v 549.495n 3.3v 549.505n 3.3v 559.495n 3.3v 559.505n 3.3v 569.495n 3.3v 569.505n 3.3v 579.495n 3.3v 579.505n 3.3v 589.495n 3.3v 589.505n 3.3v 599.495n 3.3v 599.505n 3.3v 609.495n 3.3v 609.505n 3.3v 619.495n 3.3v 619.505n 3.3v 629.495n 3.3v 629.505n 3.3v 639.495n 3.3v 639.505n 3.3v 649.495n 3.3v 649.505n 3.3v 659.495n 3.3v 659.505n 3.3v 669.495n 3.3v 669.505n 0.0v 679.495n 0.0v 679.505n 0.0v 689.495n 0.0v 689.505n 0.0v 699.495n 0.0v 699.505n 0.0v 709.495n 0.0v 709.505n 0.0v 719.495n 0.0v 719.505n 0.0v 729.495n 0.0v 729.505n 0.0v 739.495n 0.0v 739.505n 0.0v 749.495n 0.0v 749.505n 0.0v 759.495n 0.0v 759.505n 0.0v 769.495n 0.0v 769.505n 0.0v 779.495n 0.0v 779.505n 0.0v 789.495n 0.0v 789.505n 0.0v 799.495n 0.0v 799.505n 0.0v 809.495n 0.0v 809.505n 0.0v 819.495n 0.0v 819.505n 0.0v 829.495n 0.0v 829.505n 0.0v 839.495n 0.0v 839.505n 3.3v 849.495n 3.3v 849.505n 3.3v 859.495n 3.3v 859.505n 3.3v 869.495n 3.3v 869.505n 3.3v 879.495n 3.3v 879.505n 3.3v 889.495n 3.3v 889.505n 3.3v 899.495n 3.3v 899.505n 3.3v 909.495n 3.3v 909.505n 3.3v 919.495n 3.3v 919.505n 0.0v 929.495n 0.0v 929.505n 0.0v 939.495n 0.0v 939.505n 0.0v 949.495n 0.0v 949.505n 3.3v 959.495n 3.3v 959.505n 3.3v 969.495n 3.3v 969.505n 3.3v 979.495n 3.3v 979.505n 3.3v 989.495n 3.3v 989.505n 3.3v 999.495n 3.3v 999.505n 3.3v 1009.495n 3.3v 1009.505n 3.3v 1019.495n 3.3v 1019.505n 3.3v 1029.495n 3.3v 1029.505n 3.3v 1039.495n 3.3v 1039.505n 3.3v 1049.495n 3.3v 1049.505n 3.3v 1059.495n 3.3v 1059.505n 3.3v 1069.495n 3.3v 1069.505n 3.3v 1079.495n 3.3v 1079.505n 3.3v 1089.495n 3.3v 1089.505n 3.3v 1099.495n 3.3v 1099.505n 3.3v 1109.495n 3.3v 1109.505n 3.3v 1119.495n 3.3v 1119.505n 3.3v 1129.495n 3.3v 1129.505n 3.3v 1139.495n 3.3v 1139.505n 3.3v 1149.495n 3.3v 1149.505n 3.3v 1159.495n 3.3v 1159.505n 3.3v 1169.495n 3.3v 1169.505n 3.3v 1179.495n 3.3v 1179.505n 0.0v 1189.495n 0.0v 1189.505n 0.0v 1199.495n 0.0v 1199.505n 0.0v 1209.495n 0.0v 1209.505n 0.0v 1219.495n 0.0v 1219.505n 0.0v 1229.495n 0.0v 1229.505n 0.0v 1239.495n 0.0v 1239.505n 0.0v 1249.495n 0.0v 1249.505n 0.0v 1259.495n 0.0v 1259.505n 0.0v 1269.495n 0.0v 1269.505n 0.0v 1279.495n 0.0v 1279.505n 0.0v 1289.495n 0.0v 1289.505n 0.0v 1299.495n 0.0v 1299.505n 0.0v 1309.495n 0.0v 1309.505n 0.0v 1319.495n 0.0v 1319.505n 0.0v 1329.495n 0.0v 1329.505n 0.0v 1339.495n 0.0v 1339.505n 0.0v 1349.495n 0.0v 1349.505n 0.0v 1359.495n 0.0v 1359.505n 0.0v 1369.495n 0.0v 1369.505n 3.3v 1379.495n 3.3v 1379.505n 3.3v 1389.495n 3.3v 1389.505n 3.3v 1399.495n 3.3v 1399.505n 3.3v 1409.495n 3.3v 1409.505n 3.3v 1419.495n 3.3v 1419.505n 3.3v 1429.495n 3.3v 1429.505n 3.3v 1439.495n 3.3v 1439.505n 3.3v 1449.495n 3.3v 1449.505n 3.3v 1459.495n 3.3v 1459.505n 3.3v 1469.495n 3.3v 1469.505n 3.3v 1479.495n 3.3v 1479.505n 3.3v 1489.495n 3.3v 1489.505n 3.3v 1499.495n 3.3v 1499.505n 3.3v 1509.495n 3.3v 1509.505n 3.3v 1519.495n 3.3v 1519.505n 3.3v 1529.495n 3.3v 1529.505n 0.0v 1539.495n 0.0v 1539.505n 0.0v 1549.495n 0.0v 1549.505n 0.0v 1559.495n 0.0v 1559.505n 0.0v 1569.495n 0.0v 1569.505n 0.0v 1579.495n 0.0v 1579.505n 0.0v 1589.495n 0.0v 1589.505n 3.3v 1599.495n 3.3v 1599.505n 3.3v 1609.495n 3.3v 1609.505n 3.3v 1619.495n 3.3v 1619.505n 3.3v 1629.495n 3.3v 1629.505n 3.3v 1639.495n 3.3v 1639.505n 3.3v 1649.495n 3.3v 1649.505n 3.3v 1659.495n 3.3v 1659.505n 3.3v 1669.495n 3.3v 1669.505n 3.3v 1679.495n 3.3v 1679.505n 3.3v 1689.495n 3.3v 1689.505n 3.3v 1699.495n 3.3v 1699.505n 3.3v 1709.495n 3.3v 1709.505n 0.0v 1719.495n 0.0v 1719.505n 0.0v 1729.495n 0.0v 1729.505n 0.0v 1739.495n 0.0v 1739.505n 0.0v 1749.495n 0.0v 1749.505n 0.0v 1759.495n 0.0v 1759.505n 0.0v 1769.495n 0.0v 1769.505n 3.3v 1779.495n 3.3v 1779.505n 0.0v 1789.495n 0.0v 1789.505n 0.0v 1799.495n 0.0v 1799.505n 0.0v 1809.495n 0.0v 1809.505n 0.0v 1819.495n 0.0v 1819.505n 0.0v 1829.495n 0.0v 1829.505n 0.0v 1839.495n 0.0v 1839.505n 3.3v 1849.495n 3.3v 1849.505n 3.3v 1859.495n 3.3v 1859.505n 3.3v 1869.495n 3.3v 1869.505n 3.3v 1879.495n 3.3v 1879.505n 0.0v 1889.495n 0.0v 1889.505n 3.3v 1899.495n 3.3v 1899.505n 3.3v 1909.495n 3.3v 1909.505n 3.3v 1919.495n 3.3v 1919.505n 3.3v 1929.495n 3.3v 1929.505n 0.0v 1939.495n 0.0v 1939.505n 0.0v 1949.495n 0.0v 1949.505n 0.0v 1959.495n 0.0v 1959.505n 0.0v 1969.495n 0.0v 1969.505n 0.0v 1979.495n 0.0v 1979.505n 0.0v 1989.495n 0.0v 1989.505n 0.0v 1999.495n 0.0v 1999.505n 0.0v 2009.495n 0.0v 2009.505n 3.3v 2019.495n 3.3v 2019.505n 3.3v 2029.495n 3.3v 2029.505n 3.3v 2039.495n 3.3v 2039.505n 3.3v 2049.495n 3.3v 2049.505n 3.3v )
* (time, data): [(0, 0), (10, 0), (20, 1), (30, 0), (40, 0), (50, 0), (60, 0), (70, 0), (80, 0), (90, 0), (100, 0), (110, 0), (120, 0), (130, 0), (140, 0), (150, 0), (160, 0), (170, 1), (180, 0), (190, 0), (200, 1), (210, 1), (220, 0), (230, 0), (240, 0), (250, 0), (260, 0), (270, 1), (280, 1), (290, 1), (300, 1), (310, 0), (320, 0), (330, 0), (340, 0), (350, 0), (360, 0), (370, 0), (380, 0), (390, 0), (400, 0), (410, 0), (420, 1), (430, 1), (440, 1), (450, 1), (460, 1), (470, 1), (480, 1), (490, 1), (500, 0), (510, 0), (520, 0), (530, 0), (540, 0), (550, 0), (560, 0), (570, 1), (580, 1), (590, 1), (600, 1), (610, 1), (620, 1), (630, 1), (640, 1), (650, 0), (660, 0), (670, 1), (680, 1), (690, 1), (700, 1), (710, 1), (720, 1), (730, 1), (740, 0), (750, 0), (760, 0), (770, 0), (780, 0), (790, 0), (800, 0), (810, 0), (820, 0), (830, 0), (840, 0), (850, 0), (860, 0), (870, 0), (880, 0), (890, 1), (900, 1), (910, 1), (920, 0), (930, 0), (940, 0), (950, 1), (960, 1), (970, 1), (980, 1), (990, 1), (1000, 1), (1010, 1), (1020, 1), (1030, 1), (1040, 1), (1050, 1), (1060, 1), (1070, 1), (1080, 1), (1090, 1), (1100, 1), (1110, 0), (1120, 0), (1130, 0), (1140, 0), (1150, 0), (1160, 0), (1170, 0), (1180, 0), (1190, 0), (1200, 0), (1210, 0), (1220, 1), (1230, 1), (1240, 1), (1250, 1), (1260, 0), (1270, 0), (1280, 0), (1290, 0), (1300, 0), (1310, 0), (1320, 0), (1330, 0), (1340, 0), (1350, 0), (1360, 0), (1370, 1), (1380, 1), (1390, 1), (1400, 1), (1410, 1), (1420, 1), (1430, 1), (1440, 0), (1450, 0), (1460, 0), (1470, 0), (1480, 0), (1490, 0), (1500, 0), (1510, 0), (1520, 0), (1530, 1), (1540, 1), (1550, 1), (1560, 1), (1570, 1), (1580, 1), (1590, 0), (1600, 0), (1610, 0), (1620, 1), (1630, 1), (1640, 1), (1650, 1), (1660, 0), (1670, 0), (1680, 0), (1690, 0), (1700, 0), (1710, 0), (1720, 1), (1730, 1), (1740, 1), (1750, 1), (1760, 1), (1770, 1), (1780, 0), (1790, 0), (1800, 0), (1810, 0), (1820, 0), (1830, 0), (1840, 1), (1850, 0), (1860, 0), (1870, 0), (1880, 0), (1890, 0), (1900, 0), (1910, 0), (1920, 0), (1930, 0), (1940, 0), (1950, 0), (1960, 0), (1970, 0), (1980, 1), (1990, 1), (2000, 1), (2010, 0), (2020, 0), (2030, 0), (2040, 0), (2050, 0)]
Vdin0_15  din0_15  0 PWL (0n 0.0v 9.495n 0.0v 9.505n 0.0v 19.495n 0.0v 19.505n 3.3v 29.495n 3.3v 29.505n 0.0v 39.495n 0.0v 39.505n 0.0v 49.495n 0.0v 49.505n 0.0v 59.495n 0.0v 59.505n 0.0v 69.495n 0.0v 69.505n 0.0v 79.495n 0.0v 79.505n 0.0v 89.495n 0.0v 89.505n 0.0v 99.495n 0.0v 99.505n 0.0v 109.495n 0.0v 109.505n 0.0v 119.495n 0.0v 119.505n 0.0v 129.495n 0.0v 129.505n 0.0v 139.495n 0.0v 139.505n 0.0v 149.495n 0.0v 149.505n 0.0v 159.495n 0.0v 159.505n 0.0v 169.495n 0.0v 169.505n 3.3v 179.495n 3.3v 179.505n 0.0v 189.495n 0.0v 189.505n 0.0v 199.495n 0.0v 199.505n 3.3v 209.495n 3.3v 209.505n 3.3v 219.495n 3.3v 219.505n 0.0v 229.495n 0.0v 229.505n 0.0v 239.495n 0.0v 239.505n 0.0v 249.495n 0.0v 249.505n 0.0v 259.495n 0.0v 259.505n 0.0v 269.495n 0.0v 269.505n 3.3v 279.495n 3.3v 279.505n 3.3v 289.495n 3.3v 289.505n 3.3v 299.495n 3.3v 299.505n 3.3v 309.495n 3.3v 309.505n 0.0v 319.495n 0.0v 319.505n 0.0v 329.495n 0.0v 329.505n 0.0v 339.495n 0.0v 339.505n 0.0v 349.495n 0.0v 349.505n 0.0v 359.495n 0.0v 359.505n 0.0v 369.495n 0.0v 369.505n 0.0v 379.495n 0.0v 379.505n 0.0v 389.495n 0.0v 389.505n 0.0v 399.495n 0.0v 399.505n 0.0v 409.495n 0.0v 409.505n 0.0v 419.495n 0.0v 419.505n 3.3v 429.495n 3.3v 429.505n 3.3v 439.495n 3.3v 439.505n 3.3v 449.495n 3.3v 449.505n 3.3v 459.495n 3.3v 459.505n 3.3v 469.495n 3.3v 469.505n 3.3v 479.495n 3.3v 479.505n 3.3v 489.495n 3.3v 489.505n 3.3v 499.495n 3.3v 499.505n 0.0v 509.495n 0.0v 509.505n 0.0v 519.495n 0.0v 519.505n 0.0v 529.495n 0.0v 529.505n 0.0v 539.495n 0.0v 539.505n 0.0v 549.495n 0.0v 549.505n 0.0v 559.495n 0.0v 559.505n 0.0v 569.495n 0.0v 569.505n 3.3v 579.495n 3.3v 579.505n 3.3v 589.495n 3.3v 589.505n 3.3v 599.495n 3.3v 599.505n 3.3v 609.495n 3.3v 609.505n 3.3v 619.495n 3.3v 619.505n 3.3v 629.495n 3.3v 629.505n 3.3v 639.495n 3.3v 639.505n 3.3v 649.495n 3.3v 649.505n 0.0v 659.495n 0.0v 659.505n 0.0v 669.495n 0.0v 669.505n 3.3v 679.495n 3.3v 679.505n 3.3v 689.495n 3.3v 689.505n 3.3v 699.495n 3.3v 699.505n 3.3v 709.495n 3.3v 709.505n 3.3v 719.495n 3.3v 719.505n 3.3v 729.495n 3.3v 729.505n 3.3v 739.495n 3.3v 739.505n 0.0v 749.495n 0.0v 749.505n 0.0v 759.495n 0.0v 759.505n 0.0v 769.495n 0.0v 769.505n 0.0v 779.495n 0.0v 779.505n 0.0v 789.495n 0.0v 789.505n 0.0v 799.495n 0.0v 799.505n 0.0v 809.495n 0.0v 809.505n 0.0v 819.495n 0.0v 819.505n 0.0v 829.495n 0.0v 829.505n 0.0v 839.495n 0.0v 839.505n 0.0v 849.495n 0.0v 849.505n 0.0v 859.495n 0.0v 859.505n 0.0v 869.495n 0.0v 869.505n 0.0v 879.495n 0.0v 879.505n 0.0v 889.495n 0.0v 889.505n 3.3v 899.495n 3.3v 899.505n 3.3v 909.495n 3.3v 909.505n 3.3v 919.495n 3.3v 919.505n 0.0v 929.495n 0.0v 929.505n 0.0v 939.495n 0.0v 939.505n 0.0v 949.495n 0.0v 949.505n 3.3v 959.495n 3.3v 959.505n 3.3v 969.495n 3.3v 969.505n 3.3v 979.495n 3.3v 979.505n 3.3v 989.495n 3.3v 989.505n 3.3v 999.495n 3.3v 999.505n 3.3v 1009.495n 3.3v 1009.505n 3.3v 1019.495n 3.3v 1019.505n 3.3v 1029.495n 3.3v 1029.505n 3.3v 1039.495n 3.3v 1039.505n 3.3v 1049.495n 3.3v 1049.505n 3.3v 1059.495n 3.3v 1059.505n 3.3v 1069.495n 3.3v 1069.505n 3.3v 1079.495n 3.3v 1079.505n 3.3v 1089.495n 3.3v 1089.505n 3.3v 1099.495n 3.3v 1099.505n 3.3v 1109.495n 3.3v 1109.505n 0.0v 1119.495n 0.0v 1119.505n 0.0v 1129.495n 0.0v 1129.505n 0.0v 1139.495n 0.0v 1139.505n 0.0v 1149.495n 0.0v 1149.505n 0.0v 1159.495n 0.0v 1159.505n 0.0v 1169.495n 0.0v 1169.505n 0.0v 1179.495n 0.0v 1179.505n 0.0v 1189.495n 0.0v 1189.505n 0.0v 1199.495n 0.0v 1199.505n 0.0v 1209.495n 0.0v 1209.505n 0.0v 1219.495n 0.0v 1219.505n 3.3v 1229.495n 3.3v 1229.505n 3.3v 1239.495n 3.3v 1239.505n 3.3v 1249.495n 3.3v 1249.505n 3.3v 1259.495n 3.3v 1259.505n 0.0v 1269.495n 0.0v 1269.505n 0.0v 1279.495n 0.0v 1279.505n 0.0v 1289.495n 0.0v 1289.505n 0.0v 1299.495n 0.0v 1299.505n 0.0v 1309.495n 0.0v 1309.505n 0.0v 1319.495n 0.0v 1319.505n 0.0v 1329.495n 0.0v 1329.505n 0.0v 1339.495n 0.0v 1339.505n 0.0v 1349.495n 0.0v 1349.505n 0.0v 1359.495n 0.0v 1359.505n 0.0v 1369.495n 0.0v 1369.505n 3.3v 1379.495n 3.3v 1379.505n 3.3v 1389.495n 3.3v 1389.505n 3.3v 1399.495n 3.3v 1399.505n 3.3v 1409.495n 3.3v 1409.505n 3.3v 1419.495n 3.3v 1419.505n 3.3v 1429.495n 3.3v 1429.505n 3.3v 1439.495n 3.3v 1439.505n 0.0v 1449.495n 0.0v 1449.505n 0.0v 1459.495n 0.0v 1459.505n 0.0v 1469.495n 0.0v 1469.505n 0.0v 1479.495n 0.0v 1479.505n 0.0v 1489.495n 0.0v 1489.505n 0.0v 1499.495n 0.0v 1499.505n 0.0v 1509.495n 0.0v 1509.505n 0.0v 1519.495n 0.0v 1519.505n 0.0v 1529.495n 0.0v 1529.505n 3.3v 1539.495n 3.3v 1539.505n 3.3v 1549.495n 3.3v 1549.505n 3.3v 1559.495n 3.3v 1559.505n 3.3v 1569.495n 3.3v 1569.505n 3.3v 1579.495n 3.3v 1579.505n 3.3v 1589.495n 3.3v 1589.505n 0.0v 1599.495n 0.0v 1599.505n 0.0v 1609.495n 0.0v 1609.505n 0.0v 1619.495n 0.0v 1619.505n 3.3v 1629.495n 3.3v 1629.505n 3.3v 1639.495n 3.3v 1639.505n 3.3v 1649.495n 3.3v 1649.505n 3.3v 1659.495n 3.3v 1659.505n 0.0v 1669.495n 0.0v 1669.505n 0.0v 1679.495n 0.0v 1679.505n 0.0v 1689.495n 0.0v 1689.505n 0.0v 1699.495n 0.0v 1699.505n 0.0v 1709.495n 0.0v 1709.505n 0.0v 1719.495n 0.0v 1719.505n 3.3v 1729.495n 3.3v 1729.505n 3.3v 1739.495n 3.3v 1739.505n 3.3v 1749.495n 3.3v 1749.505n 3.3v 1759.495n 3.3v 1759.505n 3.3v 1769.495n 3.3v 1769.505n 3.3v 1779.495n 3.3v 1779.505n 0.0v 1789.495n 0.0v 1789.505n 0.0v 1799.495n 0.0v 1799.505n 0.0v 1809.495n 0.0v 1809.505n 0.0v 1819.495n 0.0v 1819.505n 0.0v 1829.495n 0.0v 1829.505n 0.0v 1839.495n 0.0v 1839.505n 3.3v 1849.495n 3.3v 1849.505n 0.0v 1859.495n 0.0v 1859.505n 0.0v 1869.495n 0.0v 1869.505n 0.0v 1879.495n 0.0v 1879.505n 0.0v 1889.495n 0.0v 1889.505n 0.0v 1899.495n 0.0v 1899.505n 0.0v 1909.495n 0.0v 1909.505n 0.0v 1919.495n 0.0v 1919.505n 0.0v 1929.495n 0.0v 1929.505n 0.0v 1939.495n 0.0v 1939.505n 0.0v 1949.495n 0.0v 1949.505n 0.0v 1959.495n 0.0v 1959.505n 0.0v 1969.495n 0.0v 1969.505n 0.0v 1979.495n 0.0v 1979.505n 3.3v 1989.495n 3.3v 1989.505n 3.3v 1999.495n 3.3v 1999.505n 3.3v 2009.495n 3.3v 2009.505n 0.0v 2019.495n 0.0v 2019.505n 0.0v 2029.495n 0.0v 2029.505n 0.0v 2039.495n 0.0v 2039.505n 0.0v 2049.495n 0.0v 2049.505n 0.0v )
* (time, data): [(0, 0), (10, 0), (20, 1), (30, 1), (40, 1), (50, 1), (60, 1), (70, 1), (80, 1), (90, 1), (100, 1), (110, 1), (120, 1), (130, 1), (140, 1), (150, 0), (160, 0), (170, 1), (180, 1), (190, 1), (200, 0), (210, 0), (220, 0), (230, 0), (240, 1), (250, 1), (260, 1), (270, 1), (280, 1), (290, 1), (300, 1), (310, 1), (320, 0), (330, 0), (340, 0), (350, 0), (360, 0), (370, 0), (380, 0), (390, 0), (400, 0), (410, 0), (420, 1), (430, 1), (440, 1), (450, 1), (460, 1), (470, 1), (480, 1), (490, 0), (500, 1), (510, 0), (520, 1), (530, 1), (540, 1), (550, 0), (560, 0), (570, 0), (580, 0), (590, 0), (600, 0), (610, 0), (620, 0), (630, 0), (640, 0), (650, 0), (660, 0), (670, 0), (680, 0), (690, 0), (700, 0), (710, 0), (720, 0), (730, 0), (740, 1), (750, 1), (760, 1), (770, 1), (780, 1), (790, 1), (800, 1), (810, 1), (820, 1), (830, 1), (840, 1), (850, 1), (860, 1), (870, 1), (880, 1), (890, 1), (900, 1), (910, 1), (920, 0), (930, 0), (940, 0), (950, 1), (960, 1), (970, 1), (980, 1), (990, 1), (1000, 1), (1010, 1), (1020, 1), (1030, 1), (1040, 0), (1050, 0), (1060, 0), (1070, 0), (1080, 0), (1090, 0), (1100, 0), (1110, 1), (1120, 1), (1130, 1), (1140, 1), (1150, 1), (1160, 1), (1170, 1), (1180, 1), (1190, 1), (1200, 1), (1210, 1), (1220, 0), (1230, 0), (1240, 0), (1250, 0), (1260, 0), (1270, 0), (1280, 0), (1290, 0), (1300, 0), (1310, 0), (1320, 0), (1330, 0), (1340, 0), (1350, 0), (1360, 0), (1370, 0), (1380, 0), (1390, 0), (1400, 0), (1410, 0), (1420, 0), (1430, 0), (1440, 0), (1450, 0), (1460, 0), (1470, 0), (1480, 0), (1490, 0), (1500, 0), (1510, 0), (1520, 0), (1530, 1), (1540, 1), (1550, 1), (1560, 1), (1570, 1), (1580, 1), (1590, 1), (1600, 1), (1610, 1), (1620, 0), (1630, 0), (1640, 0), (1650, 0), (1660, 1), (1670, 1), (1680, 1), (1690, 1), (1700, 0), (1710, 1), (1720, 1), (1730, 1), (1740, 1), (1750, 1), (1760, 1), (1770, 1), (1780, 1), (1790, 1), (1800, 1), (1810, 1), (1820, 1), (1830, 1), (1840, 1), (1850, 1), (1860, 1), (1870, 1), (1880, 1), (1890, 0), (1900, 0), (1910, 0), (1920, 0), (1930, 0), (1940, 0), (1950, 0), (1960, 0), (1970, 0), (1980, 1), (1990, 1), (2000, 1), (2010, 1), (2020, 1), (2030, 1), (2040, 1), (2050, 1)]
Vdin0_16  din0_16  0 PWL (0n 0.0v 9.495n 0.0v 9.505n 0.0v 19.495n 0.0v 19.505n 3.3v 29.495n 3.3v 29.505n 3.3v 39.495n 3.3v 39.505n 3.3v 49.495n 3.3v 49.505n 3.3v 59.495n 3.3v 59.505n 3.3v 69.495n 3.3v 69.505n 3.3v 79.495n 3.3v 79.505n 3.3v 89.495n 3.3v 89.505n 3.3v 99.495n 3.3v 99.505n 3.3v 109.495n 3.3v 109.505n 3.3v 119.495n 3.3v 119.505n 3.3v 129.495n 3.3v 129.505n 3.3v 139.495n 3.3v 139.505n 3.3v 149.495n 3.3v 149.505n 0.0v 159.495n 0.0v 159.505n 0.0v 169.495n 0.0v 169.505n 3.3v 179.495n 3.3v 179.505n 3.3v 189.495n 3.3v 189.505n 3.3v 199.495n 3.3v 199.505n 0.0v 209.495n 0.0v 209.505n 0.0v 219.495n 0.0v 219.505n 0.0v 229.495n 0.0v 229.505n 0.0v 239.495n 0.0v 239.505n 3.3v 249.495n 3.3v 249.505n 3.3v 259.495n 3.3v 259.505n 3.3v 269.495n 3.3v 269.505n 3.3v 279.495n 3.3v 279.505n 3.3v 289.495n 3.3v 289.505n 3.3v 299.495n 3.3v 299.505n 3.3v 309.495n 3.3v 309.505n 3.3v 319.495n 3.3v 319.505n 0.0v 329.495n 0.0v 329.505n 0.0v 339.495n 0.0v 339.505n 0.0v 349.495n 0.0v 349.505n 0.0v 359.495n 0.0v 359.505n 0.0v 369.495n 0.0v 369.505n 0.0v 379.495n 0.0v 379.505n 0.0v 389.495n 0.0v 389.505n 0.0v 399.495n 0.0v 399.505n 0.0v 409.495n 0.0v 409.505n 0.0v 419.495n 0.0v 419.505n 3.3v 429.495n 3.3v 429.505n 3.3v 439.495n 3.3v 439.505n 3.3v 449.495n 3.3v 449.505n 3.3v 459.495n 3.3v 459.505n 3.3v 469.495n 3.3v 469.505n 3.3v 479.495n 3.3v 479.505n 3.3v 489.495n 3.3v 489.505n 0.0v 499.495n 0.0v 499.505n 3.3v 509.495n 3.3v 509.505n 0.0v 519.495n 0.0v 519.505n 3.3v 529.495n 3.3v 529.505n 3.3v 539.495n 3.3v 539.505n 3.3v 549.495n 3.3v 549.505n 0.0v 559.495n 0.0v 559.505n 0.0v 569.495n 0.0v 569.505n 0.0v 579.495n 0.0v 579.505n 0.0v 589.495n 0.0v 589.505n 0.0v 599.495n 0.0v 599.505n 0.0v 609.495n 0.0v 609.505n 0.0v 619.495n 0.0v 619.505n 0.0v 629.495n 0.0v 629.505n 0.0v 639.495n 0.0v 639.505n 0.0v 649.495n 0.0v 649.505n 0.0v 659.495n 0.0v 659.505n 0.0v 669.495n 0.0v 669.505n 0.0v 679.495n 0.0v 679.505n 0.0v 689.495n 0.0v 689.505n 0.0v 699.495n 0.0v 699.505n 0.0v 709.495n 0.0v 709.505n 0.0v 719.495n 0.0v 719.505n 0.0v 729.495n 0.0v 729.505n 0.0v 739.495n 0.0v 739.505n 3.3v 749.495n 3.3v 749.505n 3.3v 759.495n 3.3v 759.505n 3.3v 769.495n 3.3v 769.505n 3.3v 779.495n 3.3v 779.505n 3.3v 789.495n 3.3v 789.505n 3.3v 799.495n 3.3v 799.505n 3.3v 809.495n 3.3v 809.505n 3.3v 819.495n 3.3v 819.505n 3.3v 829.495n 3.3v 829.505n 3.3v 839.495n 3.3v 839.505n 3.3v 849.495n 3.3v 849.505n 3.3v 859.495n 3.3v 859.505n 3.3v 869.495n 3.3v 869.505n 3.3v 879.495n 3.3v 879.505n 3.3v 889.495n 3.3v 889.505n 3.3v 899.495n 3.3v 899.505n 3.3v 909.495n 3.3v 909.505n 3.3v 919.495n 3.3v 919.505n 0.0v 929.495n 0.0v 929.505n 0.0v 939.495n 0.0v 939.505n 0.0v 949.495n 0.0v 949.505n 3.3v 959.495n 3.3v 959.505n 3.3v 969.495n 3.3v 969.505n 3.3v 979.495n 3.3v 979.505n 3.3v 989.495n 3.3v 989.505n 3.3v 999.495n 3.3v 999.505n 3.3v 1009.495n 3.3v 1009.505n 3.3v 1019.495n 3.3v 1019.505n 3.3v 1029.495n 3.3v 1029.505n 3.3v 1039.495n 3.3v 1039.505n 0.0v 1049.495n 0.0v 1049.505n 0.0v 1059.495n 0.0v 1059.505n 0.0v 1069.495n 0.0v 1069.505n 0.0v 1079.495n 0.0v 1079.505n 0.0v 1089.495n 0.0v 1089.505n 0.0v 1099.495n 0.0v 1099.505n 0.0v 1109.495n 0.0v 1109.505n 3.3v 1119.495n 3.3v 1119.505n 3.3v 1129.495n 3.3v 1129.505n 3.3v 1139.495n 3.3v 1139.505n 3.3v 1149.495n 3.3v 1149.505n 3.3v 1159.495n 3.3v 1159.505n 3.3v 1169.495n 3.3v 1169.505n 3.3v 1179.495n 3.3v 1179.505n 3.3v 1189.495n 3.3v 1189.505n 3.3v 1199.495n 3.3v 1199.505n 3.3v 1209.495n 3.3v 1209.505n 3.3v 1219.495n 3.3v 1219.505n 0.0v 1229.495n 0.0v 1229.505n 0.0v 1239.495n 0.0v 1239.505n 0.0v 1249.495n 0.0v 1249.505n 0.0v 1259.495n 0.0v 1259.505n 0.0v 1269.495n 0.0v 1269.505n 0.0v 1279.495n 0.0v 1279.505n 0.0v 1289.495n 0.0v 1289.505n 0.0v 1299.495n 0.0v 1299.505n 0.0v 1309.495n 0.0v 1309.505n 0.0v 1319.495n 0.0v 1319.505n 0.0v 1329.495n 0.0v 1329.505n 0.0v 1339.495n 0.0v 1339.505n 0.0v 1349.495n 0.0v 1349.505n 0.0v 1359.495n 0.0v 1359.505n 0.0v 1369.495n 0.0v 1369.505n 0.0v 1379.495n 0.0v 1379.505n 0.0v 1389.495n 0.0v 1389.505n 0.0v 1399.495n 0.0v 1399.505n 0.0v 1409.495n 0.0v 1409.505n 0.0v 1419.495n 0.0v 1419.505n 0.0v 1429.495n 0.0v 1429.505n 0.0v 1439.495n 0.0v 1439.505n 0.0v 1449.495n 0.0v 1449.505n 0.0v 1459.495n 0.0v 1459.505n 0.0v 1469.495n 0.0v 1469.505n 0.0v 1479.495n 0.0v 1479.505n 0.0v 1489.495n 0.0v 1489.505n 0.0v 1499.495n 0.0v 1499.505n 0.0v 1509.495n 0.0v 1509.505n 0.0v 1519.495n 0.0v 1519.505n 0.0v 1529.495n 0.0v 1529.505n 3.3v 1539.495n 3.3v 1539.505n 3.3v 1549.495n 3.3v 1549.505n 3.3v 1559.495n 3.3v 1559.505n 3.3v 1569.495n 3.3v 1569.505n 3.3v 1579.495n 3.3v 1579.505n 3.3v 1589.495n 3.3v 1589.505n 3.3v 1599.495n 3.3v 1599.505n 3.3v 1609.495n 3.3v 1609.505n 3.3v 1619.495n 3.3v 1619.505n 0.0v 1629.495n 0.0v 1629.505n 0.0v 1639.495n 0.0v 1639.505n 0.0v 1649.495n 0.0v 1649.505n 0.0v 1659.495n 0.0v 1659.505n 3.3v 1669.495n 3.3v 1669.505n 3.3v 1679.495n 3.3v 1679.505n 3.3v 1689.495n 3.3v 1689.505n 3.3v 1699.495n 3.3v 1699.505n 0.0v 1709.495n 0.0v 1709.505n 3.3v 1719.495n 3.3v 1719.505n 3.3v 1729.495n 3.3v 1729.505n 3.3v 1739.495n 3.3v 1739.505n 3.3v 1749.495n 3.3v 1749.505n 3.3v 1759.495n 3.3v 1759.505n 3.3v 1769.495n 3.3v 1769.505n 3.3v 1779.495n 3.3v 1779.505n 3.3v 1789.495n 3.3v 1789.505n 3.3v 1799.495n 3.3v 1799.505n 3.3v 1809.495n 3.3v 1809.505n 3.3v 1819.495n 3.3v 1819.505n 3.3v 1829.495n 3.3v 1829.505n 3.3v 1839.495n 3.3v 1839.505n 3.3v 1849.495n 3.3v 1849.505n 3.3v 1859.495n 3.3v 1859.505n 3.3v 1869.495n 3.3v 1869.505n 3.3v 1879.495n 3.3v 1879.505n 3.3v 1889.495n 3.3v 1889.505n 0.0v 1899.495n 0.0v 1899.505n 0.0v 1909.495n 0.0v 1909.505n 0.0v 1919.495n 0.0v 1919.505n 0.0v 1929.495n 0.0v 1929.505n 0.0v 1939.495n 0.0v 1939.505n 0.0v 1949.495n 0.0v 1949.505n 0.0v 1959.495n 0.0v 1959.505n 0.0v 1969.495n 0.0v 1969.505n 0.0v 1979.495n 0.0v 1979.505n 3.3v 1989.495n 3.3v 1989.505n 3.3v 1999.495n 3.3v 1999.505n 3.3v 2009.495n 3.3v 2009.505n 3.3v 2019.495n 3.3v 2019.505n 3.3v 2029.495n 3.3v 2029.505n 3.3v 2039.495n 3.3v 2039.505n 3.3v 2049.495n 3.3v 2049.505n 3.3v )
* (time, data): [(0, 0), (10, 0), (20, 1), (30, 0), (40, 0), (50, 0), (60, 0), (70, 0), (80, 0), (90, 0), (100, 0), (110, 0), (120, 1), (130, 1), (140, 0), (150, 1), (160, 1), (170, 0), (180, 1), (190, 1), (200, 0), (210, 0), (220, 1), (230, 1), (240, 0), (250, 0), (260, 0), (270, 1), (280, 1), (290, 1), (300, 1), (310, 1), (320, 1), (330, 1), (340, 1), (350, 1), (360, 1), (370, 1), (380, 1), (390, 1), (400, 1), (410, 1), (420, 0), (430, 1), (440, 1), (450, 0), (460, 0), (470, 0), (480, 0), (490, 0), (500, 0), (510, 1), (520, 0), (530, 0), (540, 0), (550, 1), (560, 0), (570, 0), (580, 0), (590, 0), (600, 0), (610, 0), (620, 0), (630, 0), (640, 0), (650, 1), (660, 1), (670, 0), (680, 0), (690, 0), (700, 0), (710, 0), (720, 0), (730, 0), (740, 0), (750, 0), (760, 0), (770, 0), (780, 0), (790, 0), (800, 0), (810, 0), (820, 0), (830, 0), (840, 0), (850, 0), (860, 0), (870, 0), (880, 0), (890, 0), (900, 0), (910, 0), (920, 1), (930, 1), (940, 1), (950, 0), (960, 0), (970, 0), (980, 0), (990, 0), (1000, 0), (1010, 0), (1020, 0), (1030, 1), (1040, 1), (1050, 1), (1060, 1), (1070, 1), (1080, 1), (1090, 1), (1100, 1), (1110, 0), (1120, 0), (1130, 0), (1140, 0), (1150, 0), (1160, 0), (1170, 0), (1180, 1), (1190, 1), (1200, 1), (1210, 1), (1220, 1), (1230, 1), (1240, 1), (1250, 1), (1260, 0), (1270, 0), (1280, 0), (1290, 0), (1300, 0), (1310, 0), (1320, 0), (1330, 0), (1340, 0), (1350, 0), (1360, 0), (1370, 1), (1380, 1), (1390, 1), (1400, 1), (1410, 1), (1420, 1), (1430, 1), (1440, 0), (1450, 0), (1460, 0), (1470, 0), (1480, 0), (1490, 0), (1500, 1), (1510, 0), (1520, 0), (1530, 1), (1540, 1), (1550, 1), (1560, 1), (1570, 1), (1580, 1), (1590, 0), (1600, 0), (1610, 0), (1620, 1), (1630, 1), (1640, 1), (1650, 1), (1660, 0), (1670, 0), (1680, 0), (1690, 0), (1700, 1), (1710, 0), (1720, 0), (1730, 0), (1740, 0), (1750, 0), (1760, 0), (1770, 0), (1780, 1), (1790, 1), (1800, 1), (1810, 1), (1820, 1), (1830, 1), (1840, 1), (1850, 0), (1860, 0), (1870, 0), (1880, 0), (1890, 1), (1900, 1), (1910, 1), (1920, 1), (1930, 1), (1940, 1), (1950, 1), (1960, 1), (1970, 1), (1980, 0), (1990, 0), (2000, 0), (2010, 1), (2020, 1), (2030, 1), (2040, 1), (2050, 1)]
Vdin0_17  din0_17  0 PWL (0n 0.0v 9.495n 0.0v 9.505n 0.0v 19.495n 0.0v 19.505n 3.3v 29.495n 3.3v 29.505n 0.0v 39.495n 0.0v 39.505n 0.0v 49.495n 0.0v 49.505n 0.0v 59.495n 0.0v 59.505n 0.0v 69.495n 0.0v 69.505n 0.0v 79.495n 0.0v 79.505n 0.0v 89.495n 0.0v 89.505n 0.0v 99.495n 0.0v 99.505n 0.0v 109.495n 0.0v 109.505n 0.0v 119.495n 0.0v 119.505n 3.3v 129.495n 3.3v 129.505n 3.3v 139.495n 3.3v 139.505n 0.0v 149.495n 0.0v 149.505n 3.3v 159.495n 3.3v 159.505n 3.3v 169.495n 3.3v 169.505n 0.0v 179.495n 0.0v 179.505n 3.3v 189.495n 3.3v 189.505n 3.3v 199.495n 3.3v 199.505n 0.0v 209.495n 0.0v 209.505n 0.0v 219.495n 0.0v 219.505n 3.3v 229.495n 3.3v 229.505n 3.3v 239.495n 3.3v 239.505n 0.0v 249.495n 0.0v 249.505n 0.0v 259.495n 0.0v 259.505n 0.0v 269.495n 0.0v 269.505n 3.3v 279.495n 3.3v 279.505n 3.3v 289.495n 3.3v 289.505n 3.3v 299.495n 3.3v 299.505n 3.3v 309.495n 3.3v 309.505n 3.3v 319.495n 3.3v 319.505n 3.3v 329.495n 3.3v 329.505n 3.3v 339.495n 3.3v 339.505n 3.3v 349.495n 3.3v 349.505n 3.3v 359.495n 3.3v 359.505n 3.3v 369.495n 3.3v 369.505n 3.3v 379.495n 3.3v 379.505n 3.3v 389.495n 3.3v 389.505n 3.3v 399.495n 3.3v 399.505n 3.3v 409.495n 3.3v 409.505n 3.3v 419.495n 3.3v 419.505n 0.0v 429.495n 0.0v 429.505n 3.3v 439.495n 3.3v 439.505n 3.3v 449.495n 3.3v 449.505n 0.0v 459.495n 0.0v 459.505n 0.0v 469.495n 0.0v 469.505n 0.0v 479.495n 0.0v 479.505n 0.0v 489.495n 0.0v 489.505n 0.0v 499.495n 0.0v 499.505n 0.0v 509.495n 0.0v 509.505n 3.3v 519.495n 3.3v 519.505n 0.0v 529.495n 0.0v 529.505n 0.0v 539.495n 0.0v 539.505n 0.0v 549.495n 0.0v 549.505n 3.3v 559.495n 3.3v 559.505n 0.0v 569.495n 0.0v 569.505n 0.0v 579.495n 0.0v 579.505n 0.0v 589.495n 0.0v 589.505n 0.0v 599.495n 0.0v 599.505n 0.0v 609.495n 0.0v 609.505n 0.0v 619.495n 0.0v 619.505n 0.0v 629.495n 0.0v 629.505n 0.0v 639.495n 0.0v 639.505n 0.0v 649.495n 0.0v 649.505n 3.3v 659.495n 3.3v 659.505n 3.3v 669.495n 3.3v 669.505n 0.0v 679.495n 0.0v 679.505n 0.0v 689.495n 0.0v 689.505n 0.0v 699.495n 0.0v 699.505n 0.0v 709.495n 0.0v 709.505n 0.0v 719.495n 0.0v 719.505n 0.0v 729.495n 0.0v 729.505n 0.0v 739.495n 0.0v 739.505n 0.0v 749.495n 0.0v 749.505n 0.0v 759.495n 0.0v 759.505n 0.0v 769.495n 0.0v 769.505n 0.0v 779.495n 0.0v 779.505n 0.0v 789.495n 0.0v 789.505n 0.0v 799.495n 0.0v 799.505n 0.0v 809.495n 0.0v 809.505n 0.0v 819.495n 0.0v 819.505n 0.0v 829.495n 0.0v 829.505n 0.0v 839.495n 0.0v 839.505n 0.0v 849.495n 0.0v 849.505n 0.0v 859.495n 0.0v 859.505n 0.0v 869.495n 0.0v 869.505n 0.0v 879.495n 0.0v 879.505n 0.0v 889.495n 0.0v 889.505n 0.0v 899.495n 0.0v 899.505n 0.0v 909.495n 0.0v 909.505n 0.0v 919.495n 0.0v 919.505n 3.3v 929.495n 3.3v 929.505n 3.3v 939.495n 3.3v 939.505n 3.3v 949.495n 3.3v 949.505n 0.0v 959.495n 0.0v 959.505n 0.0v 969.495n 0.0v 969.505n 0.0v 979.495n 0.0v 979.505n 0.0v 989.495n 0.0v 989.505n 0.0v 999.495n 0.0v 999.505n 0.0v 1009.495n 0.0v 1009.505n 0.0v 1019.495n 0.0v 1019.505n 0.0v 1029.495n 0.0v 1029.505n 3.3v 1039.495n 3.3v 1039.505n 3.3v 1049.495n 3.3v 1049.505n 3.3v 1059.495n 3.3v 1059.505n 3.3v 1069.495n 3.3v 1069.505n 3.3v 1079.495n 3.3v 1079.505n 3.3v 1089.495n 3.3v 1089.505n 3.3v 1099.495n 3.3v 1099.505n 3.3v 1109.495n 3.3v 1109.505n 0.0v 1119.495n 0.0v 1119.505n 0.0v 1129.495n 0.0v 1129.505n 0.0v 1139.495n 0.0v 1139.505n 0.0v 1149.495n 0.0v 1149.505n 0.0v 1159.495n 0.0v 1159.505n 0.0v 1169.495n 0.0v 1169.505n 0.0v 1179.495n 0.0v 1179.505n 3.3v 1189.495n 3.3v 1189.505n 3.3v 1199.495n 3.3v 1199.505n 3.3v 1209.495n 3.3v 1209.505n 3.3v 1219.495n 3.3v 1219.505n 3.3v 1229.495n 3.3v 1229.505n 3.3v 1239.495n 3.3v 1239.505n 3.3v 1249.495n 3.3v 1249.505n 3.3v 1259.495n 3.3v 1259.505n 0.0v 1269.495n 0.0v 1269.505n 0.0v 1279.495n 0.0v 1279.505n 0.0v 1289.495n 0.0v 1289.505n 0.0v 1299.495n 0.0v 1299.505n 0.0v 1309.495n 0.0v 1309.505n 0.0v 1319.495n 0.0v 1319.505n 0.0v 1329.495n 0.0v 1329.505n 0.0v 1339.495n 0.0v 1339.505n 0.0v 1349.495n 0.0v 1349.505n 0.0v 1359.495n 0.0v 1359.505n 0.0v 1369.495n 0.0v 1369.505n 3.3v 1379.495n 3.3v 1379.505n 3.3v 1389.495n 3.3v 1389.505n 3.3v 1399.495n 3.3v 1399.505n 3.3v 1409.495n 3.3v 1409.505n 3.3v 1419.495n 3.3v 1419.505n 3.3v 1429.495n 3.3v 1429.505n 3.3v 1439.495n 3.3v 1439.505n 0.0v 1449.495n 0.0v 1449.505n 0.0v 1459.495n 0.0v 1459.505n 0.0v 1469.495n 0.0v 1469.505n 0.0v 1479.495n 0.0v 1479.505n 0.0v 1489.495n 0.0v 1489.505n 0.0v 1499.495n 0.0v 1499.505n 3.3v 1509.495n 3.3v 1509.505n 0.0v 1519.495n 0.0v 1519.505n 0.0v 1529.495n 0.0v 1529.505n 3.3v 1539.495n 3.3v 1539.505n 3.3v 1549.495n 3.3v 1549.505n 3.3v 1559.495n 3.3v 1559.505n 3.3v 1569.495n 3.3v 1569.505n 3.3v 1579.495n 3.3v 1579.505n 3.3v 1589.495n 3.3v 1589.505n 0.0v 1599.495n 0.0v 1599.505n 0.0v 1609.495n 0.0v 1609.505n 0.0v 1619.495n 0.0v 1619.505n 3.3v 1629.495n 3.3v 1629.505n 3.3v 1639.495n 3.3v 1639.505n 3.3v 1649.495n 3.3v 1649.505n 3.3v 1659.495n 3.3v 1659.505n 0.0v 1669.495n 0.0v 1669.505n 0.0v 1679.495n 0.0v 1679.505n 0.0v 1689.495n 0.0v 1689.505n 0.0v 1699.495n 0.0v 1699.505n 3.3v 1709.495n 3.3v 1709.505n 0.0v 1719.495n 0.0v 1719.505n 0.0v 1729.495n 0.0v 1729.505n 0.0v 1739.495n 0.0v 1739.505n 0.0v 1749.495n 0.0v 1749.505n 0.0v 1759.495n 0.0v 1759.505n 0.0v 1769.495n 0.0v 1769.505n 0.0v 1779.495n 0.0v 1779.505n 3.3v 1789.495n 3.3v 1789.505n 3.3v 1799.495n 3.3v 1799.505n 3.3v 1809.495n 3.3v 1809.505n 3.3v 1819.495n 3.3v 1819.505n 3.3v 1829.495n 3.3v 1829.505n 3.3v 1839.495n 3.3v 1839.505n 3.3v 1849.495n 3.3v 1849.505n 0.0v 1859.495n 0.0v 1859.505n 0.0v 1869.495n 0.0v 1869.505n 0.0v 1879.495n 0.0v 1879.505n 0.0v 1889.495n 0.0v 1889.505n 3.3v 1899.495n 3.3v 1899.505n 3.3v 1909.495n 3.3v 1909.505n 3.3v 1919.495n 3.3v 1919.505n 3.3v 1929.495n 3.3v 1929.505n 3.3v 1939.495n 3.3v 1939.505n 3.3v 1949.495n 3.3v 1949.505n 3.3v 1959.495n 3.3v 1959.505n 3.3v 1969.495n 3.3v 1969.505n 3.3v 1979.495n 3.3v 1979.505n 0.0v 1989.495n 0.0v 1989.505n 0.0v 1999.495n 0.0v 1999.505n 0.0v 2009.495n 0.0v 2009.505n 3.3v 2019.495n 3.3v 2019.505n 3.3v 2029.495n 3.3v 2029.505n 3.3v 2039.495n 3.3v 2039.505n 3.3v 2049.495n 3.3v 2049.505n 3.3v )
* (time, data): [(0, 0), (10, 1), (20, 1), (30, 0), (40, 0), (50, 0), (60, 0), (70, 0), (80, 0), (90, 0), (100, 0), (110, 0), (120, 1), (130, 1), (140, 1), (150, 0), (160, 0), (170, 1), (180, 0), (190, 1), (200, 1), (210, 0), (220, 0), (230, 0), (240, 1), (250, 0), (260, 0), (270, 1), (280, 1), (290, 1), (300, 1), (310, 0), (320, 0), (330, 0), (340, 0), (350, 1), (360, 1), (370, 1), (380, 1), (390, 1), (400, 1), (410, 1), (420, 0), (430, 1), (440, 1), (450, 1), (460, 1), (470, 1), (480, 1), (490, 1), (500, 0), (510, 1), (520, 0), (530, 0), (540, 0), (550, 1), (560, 0), (570, 0), (580, 0), (590, 0), (600, 0), (610, 0), (620, 0), (630, 0), (640, 0), (650, 1), (660, 1), (670, 1), (680, 1), (690, 1), (700, 1), (710, 1), (720, 1), (730, 1), (740, 1), (750, 1), (760, 1), (770, 1), (780, 1), (790, 1), (800, 1), (810, 1), (820, 1), (830, 1), (840, 1), (850, 1), (860, 1), (870, 1), (880, 0), (890, 1), (900, 1), (910, 1), (920, 0), (930, 1), (940, 1), (950, 1), (960, 1), (970, 1), (980, 0), (990, 0), (1000, 0), (1010, 0), (1020, 0), (1030, 0), (1040, 1), (1050, 1), (1060, 1), (1070, 1), (1080, 1), (1090, 1), (1100, 1), (1110, 0), (1120, 0), (1130, 0), (1140, 0), (1150, 0), (1160, 0), (1170, 0), (1180, 0), (1190, 0), (1200, 0), (1210, 0), (1220, 1), (1230, 1), (1240, 1), (1250, 1), (1260, 1), (1270, 1), (1280, 1), (1290, 1), (1300, 1), (1310, 1), (1320, 1), (1330, 1), (1340, 1), (1350, 1), (1360, 0), (1370, 1), (1380, 1), (1390, 1), (1400, 1), (1410, 1), (1420, 1), (1430, 1), (1440, 0), (1450, 0), (1460, 1), (1470, 1), (1480, 1), (1490, 1), (1500, 1), (1510, 1), (1520, 1), (1530, 0), (1540, 0), (1550, 0), (1560, 0), (1570, 0), (1580, 0), (1590, 0), (1600, 0), (1610, 0), (1620, 1), (1630, 1), (1640, 1), (1650, 1), (1660, 0), (1670, 0), (1680, 0), (1690, 0), (1700, 0), (1710, 0), (1720, 0), (1730, 0), (1740, 0), (1750, 0), (1760, 0), (1770, 0), (1780, 0), (1790, 0), (1800, 0), (1810, 0), (1820, 0), (1830, 0), (1840, 0), (1850, 1), (1860, 1), (1870, 1), (1880, 1), (1890, 1), (1900, 1), (1910, 1), (1920, 1), (1930, 1), (1940, 1), (1950, 1), (1960, 1), (1970, 1), (1980, 0), (1990, 0), (2000, 0), (2010, 1), (2020, 1), (2030, 1), (2040, 1), (2050, 1)]
Vdin0_18  din0_18  0 PWL (0n 0.0v 9.495n 0.0v 9.505n 3.3v 19.495n 3.3v 19.505n 3.3v 29.495n 3.3v 29.505n 0.0v 39.495n 0.0v 39.505n 0.0v 49.495n 0.0v 49.505n 0.0v 59.495n 0.0v 59.505n 0.0v 69.495n 0.0v 69.505n 0.0v 79.495n 0.0v 79.505n 0.0v 89.495n 0.0v 89.505n 0.0v 99.495n 0.0v 99.505n 0.0v 109.495n 0.0v 109.505n 0.0v 119.495n 0.0v 119.505n 3.3v 129.495n 3.3v 129.505n 3.3v 139.495n 3.3v 139.505n 3.3v 149.495n 3.3v 149.505n 0.0v 159.495n 0.0v 159.505n 0.0v 169.495n 0.0v 169.505n 3.3v 179.495n 3.3v 179.505n 0.0v 189.495n 0.0v 189.505n 3.3v 199.495n 3.3v 199.505n 3.3v 209.495n 3.3v 209.505n 0.0v 219.495n 0.0v 219.505n 0.0v 229.495n 0.0v 229.505n 0.0v 239.495n 0.0v 239.505n 3.3v 249.495n 3.3v 249.505n 0.0v 259.495n 0.0v 259.505n 0.0v 269.495n 0.0v 269.505n 3.3v 279.495n 3.3v 279.505n 3.3v 289.495n 3.3v 289.505n 3.3v 299.495n 3.3v 299.505n 3.3v 309.495n 3.3v 309.505n 0.0v 319.495n 0.0v 319.505n 0.0v 329.495n 0.0v 329.505n 0.0v 339.495n 0.0v 339.505n 0.0v 349.495n 0.0v 349.505n 3.3v 359.495n 3.3v 359.505n 3.3v 369.495n 3.3v 369.505n 3.3v 379.495n 3.3v 379.505n 3.3v 389.495n 3.3v 389.505n 3.3v 399.495n 3.3v 399.505n 3.3v 409.495n 3.3v 409.505n 3.3v 419.495n 3.3v 419.505n 0.0v 429.495n 0.0v 429.505n 3.3v 439.495n 3.3v 439.505n 3.3v 449.495n 3.3v 449.505n 3.3v 459.495n 3.3v 459.505n 3.3v 469.495n 3.3v 469.505n 3.3v 479.495n 3.3v 479.505n 3.3v 489.495n 3.3v 489.505n 3.3v 499.495n 3.3v 499.505n 0.0v 509.495n 0.0v 509.505n 3.3v 519.495n 3.3v 519.505n 0.0v 529.495n 0.0v 529.505n 0.0v 539.495n 0.0v 539.505n 0.0v 549.495n 0.0v 549.505n 3.3v 559.495n 3.3v 559.505n 0.0v 569.495n 0.0v 569.505n 0.0v 579.495n 0.0v 579.505n 0.0v 589.495n 0.0v 589.505n 0.0v 599.495n 0.0v 599.505n 0.0v 609.495n 0.0v 609.505n 0.0v 619.495n 0.0v 619.505n 0.0v 629.495n 0.0v 629.505n 0.0v 639.495n 0.0v 639.505n 0.0v 649.495n 0.0v 649.505n 3.3v 659.495n 3.3v 659.505n 3.3v 669.495n 3.3v 669.505n 3.3v 679.495n 3.3v 679.505n 3.3v 689.495n 3.3v 689.505n 3.3v 699.495n 3.3v 699.505n 3.3v 709.495n 3.3v 709.505n 3.3v 719.495n 3.3v 719.505n 3.3v 729.495n 3.3v 729.505n 3.3v 739.495n 3.3v 739.505n 3.3v 749.495n 3.3v 749.505n 3.3v 759.495n 3.3v 759.505n 3.3v 769.495n 3.3v 769.505n 3.3v 779.495n 3.3v 779.505n 3.3v 789.495n 3.3v 789.505n 3.3v 799.495n 3.3v 799.505n 3.3v 809.495n 3.3v 809.505n 3.3v 819.495n 3.3v 819.505n 3.3v 829.495n 3.3v 829.505n 3.3v 839.495n 3.3v 839.505n 3.3v 849.495n 3.3v 849.505n 3.3v 859.495n 3.3v 859.505n 3.3v 869.495n 3.3v 869.505n 3.3v 879.495n 3.3v 879.505n 0.0v 889.495n 0.0v 889.505n 3.3v 899.495n 3.3v 899.505n 3.3v 909.495n 3.3v 909.505n 3.3v 919.495n 3.3v 919.505n 0.0v 929.495n 0.0v 929.505n 3.3v 939.495n 3.3v 939.505n 3.3v 949.495n 3.3v 949.505n 3.3v 959.495n 3.3v 959.505n 3.3v 969.495n 3.3v 969.505n 3.3v 979.495n 3.3v 979.505n 0.0v 989.495n 0.0v 989.505n 0.0v 999.495n 0.0v 999.505n 0.0v 1009.495n 0.0v 1009.505n 0.0v 1019.495n 0.0v 1019.505n 0.0v 1029.495n 0.0v 1029.505n 0.0v 1039.495n 0.0v 1039.505n 3.3v 1049.495n 3.3v 1049.505n 3.3v 1059.495n 3.3v 1059.505n 3.3v 1069.495n 3.3v 1069.505n 3.3v 1079.495n 3.3v 1079.505n 3.3v 1089.495n 3.3v 1089.505n 3.3v 1099.495n 3.3v 1099.505n 3.3v 1109.495n 3.3v 1109.505n 0.0v 1119.495n 0.0v 1119.505n 0.0v 1129.495n 0.0v 1129.505n 0.0v 1139.495n 0.0v 1139.505n 0.0v 1149.495n 0.0v 1149.505n 0.0v 1159.495n 0.0v 1159.505n 0.0v 1169.495n 0.0v 1169.505n 0.0v 1179.495n 0.0v 1179.505n 0.0v 1189.495n 0.0v 1189.505n 0.0v 1199.495n 0.0v 1199.505n 0.0v 1209.495n 0.0v 1209.505n 0.0v 1219.495n 0.0v 1219.505n 3.3v 1229.495n 3.3v 1229.505n 3.3v 1239.495n 3.3v 1239.505n 3.3v 1249.495n 3.3v 1249.505n 3.3v 1259.495n 3.3v 1259.505n 3.3v 1269.495n 3.3v 1269.505n 3.3v 1279.495n 3.3v 1279.505n 3.3v 1289.495n 3.3v 1289.505n 3.3v 1299.495n 3.3v 1299.505n 3.3v 1309.495n 3.3v 1309.505n 3.3v 1319.495n 3.3v 1319.505n 3.3v 1329.495n 3.3v 1329.505n 3.3v 1339.495n 3.3v 1339.505n 3.3v 1349.495n 3.3v 1349.505n 3.3v 1359.495n 3.3v 1359.505n 0.0v 1369.495n 0.0v 1369.505n 3.3v 1379.495n 3.3v 1379.505n 3.3v 1389.495n 3.3v 1389.505n 3.3v 1399.495n 3.3v 1399.505n 3.3v 1409.495n 3.3v 1409.505n 3.3v 1419.495n 3.3v 1419.505n 3.3v 1429.495n 3.3v 1429.505n 3.3v 1439.495n 3.3v 1439.505n 0.0v 1449.495n 0.0v 1449.505n 0.0v 1459.495n 0.0v 1459.505n 3.3v 1469.495n 3.3v 1469.505n 3.3v 1479.495n 3.3v 1479.505n 3.3v 1489.495n 3.3v 1489.505n 3.3v 1499.495n 3.3v 1499.505n 3.3v 1509.495n 3.3v 1509.505n 3.3v 1519.495n 3.3v 1519.505n 3.3v 1529.495n 3.3v 1529.505n 0.0v 1539.495n 0.0v 1539.505n 0.0v 1549.495n 0.0v 1549.505n 0.0v 1559.495n 0.0v 1559.505n 0.0v 1569.495n 0.0v 1569.505n 0.0v 1579.495n 0.0v 1579.505n 0.0v 1589.495n 0.0v 1589.505n 0.0v 1599.495n 0.0v 1599.505n 0.0v 1609.495n 0.0v 1609.505n 0.0v 1619.495n 0.0v 1619.505n 3.3v 1629.495n 3.3v 1629.505n 3.3v 1639.495n 3.3v 1639.505n 3.3v 1649.495n 3.3v 1649.505n 3.3v 1659.495n 3.3v 1659.505n 0.0v 1669.495n 0.0v 1669.505n 0.0v 1679.495n 0.0v 1679.505n 0.0v 1689.495n 0.0v 1689.505n 0.0v 1699.495n 0.0v 1699.505n 0.0v 1709.495n 0.0v 1709.505n 0.0v 1719.495n 0.0v 1719.505n 0.0v 1729.495n 0.0v 1729.505n 0.0v 1739.495n 0.0v 1739.505n 0.0v 1749.495n 0.0v 1749.505n 0.0v 1759.495n 0.0v 1759.505n 0.0v 1769.495n 0.0v 1769.505n 0.0v 1779.495n 0.0v 1779.505n 0.0v 1789.495n 0.0v 1789.505n 0.0v 1799.495n 0.0v 1799.505n 0.0v 1809.495n 0.0v 1809.505n 0.0v 1819.495n 0.0v 1819.505n 0.0v 1829.495n 0.0v 1829.505n 0.0v 1839.495n 0.0v 1839.505n 0.0v 1849.495n 0.0v 1849.505n 3.3v 1859.495n 3.3v 1859.505n 3.3v 1869.495n 3.3v 1869.505n 3.3v 1879.495n 3.3v 1879.505n 3.3v 1889.495n 3.3v 1889.505n 3.3v 1899.495n 3.3v 1899.505n 3.3v 1909.495n 3.3v 1909.505n 3.3v 1919.495n 3.3v 1919.505n 3.3v 1929.495n 3.3v 1929.505n 3.3v 1939.495n 3.3v 1939.505n 3.3v 1949.495n 3.3v 1949.505n 3.3v 1959.495n 3.3v 1959.505n 3.3v 1969.495n 3.3v 1969.505n 3.3v 1979.495n 3.3v 1979.505n 0.0v 1989.495n 0.0v 1989.505n 0.0v 1999.495n 0.0v 1999.505n 0.0v 2009.495n 0.0v 2009.505n 3.3v 2019.495n 3.3v 2019.505n 3.3v 2029.495n 3.3v 2029.505n 3.3v 2039.495n 3.3v 2039.505n 3.3v 2049.495n 3.3v 2049.505n 3.3v )
* (time, data): [(0, 0), (10, 1), (20, 0), (30, 1), (40, 1), (50, 1), (60, 1), (70, 1), (80, 1), (90, 1), (100, 1), (110, 1), (120, 1), (130, 1), (140, 1), (150, 1), (160, 1), (170, 1), (180, 1), (190, 1), (200, 0), (210, 0), (220, 0), (230, 0), (240, 0), (250, 0), (260, 0), (270, 1), (280, 1), (290, 1), (300, 1), (310, 0), (320, 0), (330, 0), (340, 0), (350, 0), (360, 0), (370, 0), (380, 0), (390, 0), (400, 0), (410, 0), (420, 0), (430, 0), (440, 0), (450, 0), (460, 0), (470, 0), (480, 0), (490, 0), (500, 0), (510, 0), (520, 1), (530, 1), (540, 1), (550, 0), (560, 0), (570, 0), (580, 0), (590, 0), (600, 0), (610, 0), (620, 0), (630, 0), (640, 0), (650, 0), (660, 0), (670, 0), (680, 0), (690, 0), (700, 0), (710, 0), (720, 0), (730, 0), (740, 1), (750, 1), (760, 1), (770, 1), (780, 1), (790, 1), (800, 1), (810, 1), (820, 1), (830, 1), (840, 0), (850, 0), (860, 0), (870, 0), (880, 0), (890, 0), (900, 0), (910, 0), (920, 0), (930, 0), (940, 0), (950, 0), (960, 0), (970, 0), (980, 0), (990, 0), (1000, 0), (1010, 0), (1020, 0), (1030, 1), (1040, 1), (1050, 1), (1060, 1), (1070, 1), (1080, 1), (1090, 1), (1100, 1), (1110, 0), (1120, 0), (1130, 0), (1140, 0), (1150, 0), (1160, 0), (1170, 0), (1180, 0), (1190, 0), (1200, 0), (1210, 0), (1220, 0), (1230, 0), (1240, 0), (1250, 0), (1260, 0), (1270, 0), (1280, 0), (1290, 0), (1300, 0), (1310, 0), (1320, 0), (1330, 0), (1340, 0), (1350, 0), (1360, 1), (1370, 0), (1380, 0), (1390, 0), (1400, 0), (1410, 0), (1420, 0), (1430, 0), (1440, 0), (1450, 0), (1460, 1), (1470, 1), (1480, 1), (1490, 1), (1500, 0), (1510, 0), (1520, 0), (1530, 1), (1540, 1), (1550, 1), (1560, 1), (1570, 1), (1580, 1), (1590, 1), (1600, 1), (1610, 1), (1620, 1), (1630, 1), (1640, 1), (1650, 1), (1660, 0), (1670, 0), (1680, 0), (1690, 0), (1700, 1), (1710, 1), (1720, 1), (1730, 1), (1740, 1), (1750, 1), (1760, 1), (1770, 0), (1780, 0), (1790, 0), (1800, 0), (1810, 0), (1820, 0), (1830, 0), (1840, 1), (1850, 1), (1860, 1), (1870, 1), (1880, 1), (1890, 0), (1900, 0), (1910, 0), (1920, 0), (1930, 1), (1940, 1), (1950, 1), (1960, 1), (1970, 1), (1980, 1), (1990, 1), (2000, 1), (2010, 0), (2020, 0), (2030, 0), (2040, 0), (2050, 0)]
Vdin0_19  din0_19  0 PWL (0n 0.0v 9.495n 0.0v 9.505n 3.3v 19.495n 3.3v 19.505n 0.0v 29.495n 0.0v 29.505n 3.3v 39.495n 3.3v 39.505n 3.3v 49.495n 3.3v 49.505n 3.3v 59.495n 3.3v 59.505n 3.3v 69.495n 3.3v 69.505n 3.3v 79.495n 3.3v 79.505n 3.3v 89.495n 3.3v 89.505n 3.3v 99.495n 3.3v 99.505n 3.3v 109.495n 3.3v 109.505n 3.3v 119.495n 3.3v 119.505n 3.3v 129.495n 3.3v 129.505n 3.3v 139.495n 3.3v 139.505n 3.3v 149.495n 3.3v 149.505n 3.3v 159.495n 3.3v 159.505n 3.3v 169.495n 3.3v 169.505n 3.3v 179.495n 3.3v 179.505n 3.3v 189.495n 3.3v 189.505n 3.3v 199.495n 3.3v 199.505n 0.0v 209.495n 0.0v 209.505n 0.0v 219.495n 0.0v 219.505n 0.0v 229.495n 0.0v 229.505n 0.0v 239.495n 0.0v 239.505n 0.0v 249.495n 0.0v 249.505n 0.0v 259.495n 0.0v 259.505n 0.0v 269.495n 0.0v 269.505n 3.3v 279.495n 3.3v 279.505n 3.3v 289.495n 3.3v 289.505n 3.3v 299.495n 3.3v 299.505n 3.3v 309.495n 3.3v 309.505n 0.0v 319.495n 0.0v 319.505n 0.0v 329.495n 0.0v 329.505n 0.0v 339.495n 0.0v 339.505n 0.0v 349.495n 0.0v 349.505n 0.0v 359.495n 0.0v 359.505n 0.0v 369.495n 0.0v 369.505n 0.0v 379.495n 0.0v 379.505n 0.0v 389.495n 0.0v 389.505n 0.0v 399.495n 0.0v 399.505n 0.0v 409.495n 0.0v 409.505n 0.0v 419.495n 0.0v 419.505n 0.0v 429.495n 0.0v 429.505n 0.0v 439.495n 0.0v 439.505n 0.0v 449.495n 0.0v 449.505n 0.0v 459.495n 0.0v 459.505n 0.0v 469.495n 0.0v 469.505n 0.0v 479.495n 0.0v 479.505n 0.0v 489.495n 0.0v 489.505n 0.0v 499.495n 0.0v 499.505n 0.0v 509.495n 0.0v 509.505n 0.0v 519.495n 0.0v 519.505n 3.3v 529.495n 3.3v 529.505n 3.3v 539.495n 3.3v 539.505n 3.3v 549.495n 3.3v 549.505n 0.0v 559.495n 0.0v 559.505n 0.0v 569.495n 0.0v 569.505n 0.0v 579.495n 0.0v 579.505n 0.0v 589.495n 0.0v 589.505n 0.0v 599.495n 0.0v 599.505n 0.0v 609.495n 0.0v 609.505n 0.0v 619.495n 0.0v 619.505n 0.0v 629.495n 0.0v 629.505n 0.0v 639.495n 0.0v 639.505n 0.0v 649.495n 0.0v 649.505n 0.0v 659.495n 0.0v 659.505n 0.0v 669.495n 0.0v 669.505n 0.0v 679.495n 0.0v 679.505n 0.0v 689.495n 0.0v 689.505n 0.0v 699.495n 0.0v 699.505n 0.0v 709.495n 0.0v 709.505n 0.0v 719.495n 0.0v 719.505n 0.0v 729.495n 0.0v 729.505n 0.0v 739.495n 0.0v 739.505n 3.3v 749.495n 3.3v 749.505n 3.3v 759.495n 3.3v 759.505n 3.3v 769.495n 3.3v 769.505n 3.3v 779.495n 3.3v 779.505n 3.3v 789.495n 3.3v 789.505n 3.3v 799.495n 3.3v 799.505n 3.3v 809.495n 3.3v 809.505n 3.3v 819.495n 3.3v 819.505n 3.3v 829.495n 3.3v 829.505n 3.3v 839.495n 3.3v 839.505n 0.0v 849.495n 0.0v 849.505n 0.0v 859.495n 0.0v 859.505n 0.0v 869.495n 0.0v 869.505n 0.0v 879.495n 0.0v 879.505n 0.0v 889.495n 0.0v 889.505n 0.0v 899.495n 0.0v 899.505n 0.0v 909.495n 0.0v 909.505n 0.0v 919.495n 0.0v 919.505n 0.0v 929.495n 0.0v 929.505n 0.0v 939.495n 0.0v 939.505n 0.0v 949.495n 0.0v 949.505n 0.0v 959.495n 0.0v 959.505n 0.0v 969.495n 0.0v 969.505n 0.0v 979.495n 0.0v 979.505n 0.0v 989.495n 0.0v 989.505n 0.0v 999.495n 0.0v 999.505n 0.0v 1009.495n 0.0v 1009.505n 0.0v 1019.495n 0.0v 1019.505n 0.0v 1029.495n 0.0v 1029.505n 3.3v 1039.495n 3.3v 1039.505n 3.3v 1049.495n 3.3v 1049.505n 3.3v 1059.495n 3.3v 1059.505n 3.3v 1069.495n 3.3v 1069.505n 3.3v 1079.495n 3.3v 1079.505n 3.3v 1089.495n 3.3v 1089.505n 3.3v 1099.495n 3.3v 1099.505n 3.3v 1109.495n 3.3v 1109.505n 0.0v 1119.495n 0.0v 1119.505n 0.0v 1129.495n 0.0v 1129.505n 0.0v 1139.495n 0.0v 1139.505n 0.0v 1149.495n 0.0v 1149.505n 0.0v 1159.495n 0.0v 1159.505n 0.0v 1169.495n 0.0v 1169.505n 0.0v 1179.495n 0.0v 1179.505n 0.0v 1189.495n 0.0v 1189.505n 0.0v 1199.495n 0.0v 1199.505n 0.0v 1209.495n 0.0v 1209.505n 0.0v 1219.495n 0.0v 1219.505n 0.0v 1229.495n 0.0v 1229.505n 0.0v 1239.495n 0.0v 1239.505n 0.0v 1249.495n 0.0v 1249.505n 0.0v 1259.495n 0.0v 1259.505n 0.0v 1269.495n 0.0v 1269.505n 0.0v 1279.495n 0.0v 1279.505n 0.0v 1289.495n 0.0v 1289.505n 0.0v 1299.495n 0.0v 1299.505n 0.0v 1309.495n 0.0v 1309.505n 0.0v 1319.495n 0.0v 1319.505n 0.0v 1329.495n 0.0v 1329.505n 0.0v 1339.495n 0.0v 1339.505n 0.0v 1349.495n 0.0v 1349.505n 0.0v 1359.495n 0.0v 1359.505n 3.3v 1369.495n 3.3v 1369.505n 0.0v 1379.495n 0.0v 1379.505n 0.0v 1389.495n 0.0v 1389.505n 0.0v 1399.495n 0.0v 1399.505n 0.0v 1409.495n 0.0v 1409.505n 0.0v 1419.495n 0.0v 1419.505n 0.0v 1429.495n 0.0v 1429.505n 0.0v 1439.495n 0.0v 1439.505n 0.0v 1449.495n 0.0v 1449.505n 0.0v 1459.495n 0.0v 1459.505n 3.3v 1469.495n 3.3v 1469.505n 3.3v 1479.495n 3.3v 1479.505n 3.3v 1489.495n 3.3v 1489.505n 3.3v 1499.495n 3.3v 1499.505n 0.0v 1509.495n 0.0v 1509.505n 0.0v 1519.495n 0.0v 1519.505n 0.0v 1529.495n 0.0v 1529.505n 3.3v 1539.495n 3.3v 1539.505n 3.3v 1549.495n 3.3v 1549.505n 3.3v 1559.495n 3.3v 1559.505n 3.3v 1569.495n 3.3v 1569.505n 3.3v 1579.495n 3.3v 1579.505n 3.3v 1589.495n 3.3v 1589.505n 3.3v 1599.495n 3.3v 1599.505n 3.3v 1609.495n 3.3v 1609.505n 3.3v 1619.495n 3.3v 1619.505n 3.3v 1629.495n 3.3v 1629.505n 3.3v 1639.495n 3.3v 1639.505n 3.3v 1649.495n 3.3v 1649.505n 3.3v 1659.495n 3.3v 1659.505n 0.0v 1669.495n 0.0v 1669.505n 0.0v 1679.495n 0.0v 1679.505n 0.0v 1689.495n 0.0v 1689.505n 0.0v 1699.495n 0.0v 1699.505n 3.3v 1709.495n 3.3v 1709.505n 3.3v 1719.495n 3.3v 1719.505n 3.3v 1729.495n 3.3v 1729.505n 3.3v 1739.495n 3.3v 1739.505n 3.3v 1749.495n 3.3v 1749.505n 3.3v 1759.495n 3.3v 1759.505n 3.3v 1769.495n 3.3v 1769.505n 0.0v 1779.495n 0.0v 1779.505n 0.0v 1789.495n 0.0v 1789.505n 0.0v 1799.495n 0.0v 1799.505n 0.0v 1809.495n 0.0v 1809.505n 0.0v 1819.495n 0.0v 1819.505n 0.0v 1829.495n 0.0v 1829.505n 0.0v 1839.495n 0.0v 1839.505n 3.3v 1849.495n 3.3v 1849.505n 3.3v 1859.495n 3.3v 1859.505n 3.3v 1869.495n 3.3v 1869.505n 3.3v 1879.495n 3.3v 1879.505n 3.3v 1889.495n 3.3v 1889.505n 0.0v 1899.495n 0.0v 1899.505n 0.0v 1909.495n 0.0v 1909.505n 0.0v 1919.495n 0.0v 1919.505n 0.0v 1929.495n 0.0v 1929.505n 3.3v 1939.495n 3.3v 1939.505n 3.3v 1949.495n 3.3v 1949.505n 3.3v 1959.495n 3.3v 1959.505n 3.3v 1969.495n 3.3v 1969.505n 3.3v 1979.495n 3.3v 1979.505n 3.3v 1989.495n 3.3v 1989.505n 3.3v 1999.495n 3.3v 1999.505n 3.3v 2009.495n 3.3v 2009.505n 0.0v 2019.495n 0.0v 2019.505n 0.0v 2029.495n 0.0v 2029.505n 0.0v 2039.495n 0.0v 2039.505n 0.0v 2049.495n 0.0v 2049.505n 0.0v )
* (time, data): [(0, 0), (10, 1), (20, 0), (30, 0), (40, 0), (50, 0), (60, 0), (70, 0), (80, 0), (90, 0), (100, 0), (110, 0), (120, 1), (130, 1), (140, 1), (150, 1), (160, 1), (170, 1), (180, 1), (190, 1), (200, 0), (210, 1), (220, 0), (230, 0), (240, 0), (250, 1), (260, 1), (270, 1), (280, 1), (290, 1), (300, 1), (310, 0), (320, 1), (330, 1), (340, 1), (350, 1), (360, 1), (370, 1), (380, 1), (390, 1), (400, 1), (410, 1), (420, 0), (430, 1), (440, 1), (450, 1), (460, 1), (470, 1), (480, 1), (490, 1), (500, 1), (510, 1), (520, 0), (530, 0), (540, 0), (550, 1), (560, 1), (570, 1), (580, 1), (590, 1), (600, 1), (610, 1), (620, 1), (630, 1), (640, 1), (650, 0), (660, 0), (670, 1), (680, 1), (690, 1), (700, 1), (710, 1), (720, 1), (730, 1), (740, 1), (750, 1), (760, 1), (770, 1), (780, 1), (790, 1), (800, 1), (810, 1), (820, 1), (830, 1), (840, 0), (850, 0), (860, 0), (870, 0), (880, 1), (890, 1), (900, 1), (910, 1), (920, 0), (930, 0), (940, 0), (950, 1), (960, 1), (970, 1), (980, 0), (990, 0), (1000, 0), (1010, 0), (1020, 0), (1030, 1), (1040, 1), (1050, 1), (1060, 1), (1070, 1), (1080, 1), (1090, 1), (1100, 1), (1110, 0), (1120, 0), (1130, 0), (1140, 0), (1150, 0), (1160, 0), (1170, 0), (1180, 1), (1190, 1), (1200, 1), (1210, 1), (1220, 1), (1230, 1), (1240, 1), (1250, 1), (1260, 0), (1270, 0), (1280, 0), (1290, 0), (1300, 0), (1310, 0), (1320, 0), (1330, 0), (1340, 0), (1350, 0), (1360, 0), (1370, 0), (1380, 0), (1390, 0), (1400, 0), (1410, 0), (1420, 0), (1430, 0), (1440, 1), (1450, 1), (1460, 0), (1470, 0), (1480, 0), (1490, 0), (1500, 0), (1510, 0), (1520, 0), (1530, 1), (1540, 1), (1550, 1), (1560, 1), (1570, 1), (1580, 1), (1590, 1), (1600, 1), (1610, 1), (1620, 0), (1630, 0), (1640, 0), (1650, 0), (1660, 1), (1670, 1), (1680, 1), (1690, 1), (1700, 0), (1710, 1), (1720, 1), (1730, 1), (1740, 1), (1750, 1), (1760, 1), (1770, 0), (1780, 1), (1790, 1), (1800, 1), (1810, 1), (1820, 1), (1830, 1), (1840, 0), (1850, 1), (1860, 1), (1870, 1), (1880, 0), (1890, 1), (1900, 1), (1910, 1), (1920, 1), (1930, 1), (1940, 1), (1950, 1), (1960, 1), (1970, 1), (1980, 1), (1990, 1), (2000, 1), (2010, 0), (2020, 0), (2030, 0), (2040, 0), (2050, 0)]
Vdin0_20  din0_20  0 PWL (0n 0.0v 9.495n 0.0v 9.505n 3.3v 19.495n 3.3v 19.505n 0.0v 29.495n 0.0v 29.505n 0.0v 39.495n 0.0v 39.505n 0.0v 49.495n 0.0v 49.505n 0.0v 59.495n 0.0v 59.505n 0.0v 69.495n 0.0v 69.505n 0.0v 79.495n 0.0v 79.505n 0.0v 89.495n 0.0v 89.505n 0.0v 99.495n 0.0v 99.505n 0.0v 109.495n 0.0v 109.505n 0.0v 119.495n 0.0v 119.505n 3.3v 129.495n 3.3v 129.505n 3.3v 139.495n 3.3v 139.505n 3.3v 149.495n 3.3v 149.505n 3.3v 159.495n 3.3v 159.505n 3.3v 169.495n 3.3v 169.505n 3.3v 179.495n 3.3v 179.505n 3.3v 189.495n 3.3v 189.505n 3.3v 199.495n 3.3v 199.505n 0.0v 209.495n 0.0v 209.505n 3.3v 219.495n 3.3v 219.505n 0.0v 229.495n 0.0v 229.505n 0.0v 239.495n 0.0v 239.505n 0.0v 249.495n 0.0v 249.505n 3.3v 259.495n 3.3v 259.505n 3.3v 269.495n 3.3v 269.505n 3.3v 279.495n 3.3v 279.505n 3.3v 289.495n 3.3v 289.505n 3.3v 299.495n 3.3v 299.505n 3.3v 309.495n 3.3v 309.505n 0.0v 319.495n 0.0v 319.505n 3.3v 329.495n 3.3v 329.505n 3.3v 339.495n 3.3v 339.505n 3.3v 349.495n 3.3v 349.505n 3.3v 359.495n 3.3v 359.505n 3.3v 369.495n 3.3v 369.505n 3.3v 379.495n 3.3v 379.505n 3.3v 389.495n 3.3v 389.505n 3.3v 399.495n 3.3v 399.505n 3.3v 409.495n 3.3v 409.505n 3.3v 419.495n 3.3v 419.505n 0.0v 429.495n 0.0v 429.505n 3.3v 439.495n 3.3v 439.505n 3.3v 449.495n 3.3v 449.505n 3.3v 459.495n 3.3v 459.505n 3.3v 469.495n 3.3v 469.505n 3.3v 479.495n 3.3v 479.505n 3.3v 489.495n 3.3v 489.505n 3.3v 499.495n 3.3v 499.505n 3.3v 509.495n 3.3v 509.505n 3.3v 519.495n 3.3v 519.505n 0.0v 529.495n 0.0v 529.505n 0.0v 539.495n 0.0v 539.505n 0.0v 549.495n 0.0v 549.505n 3.3v 559.495n 3.3v 559.505n 3.3v 569.495n 3.3v 569.505n 3.3v 579.495n 3.3v 579.505n 3.3v 589.495n 3.3v 589.505n 3.3v 599.495n 3.3v 599.505n 3.3v 609.495n 3.3v 609.505n 3.3v 619.495n 3.3v 619.505n 3.3v 629.495n 3.3v 629.505n 3.3v 639.495n 3.3v 639.505n 3.3v 649.495n 3.3v 649.505n 0.0v 659.495n 0.0v 659.505n 0.0v 669.495n 0.0v 669.505n 3.3v 679.495n 3.3v 679.505n 3.3v 689.495n 3.3v 689.505n 3.3v 699.495n 3.3v 699.505n 3.3v 709.495n 3.3v 709.505n 3.3v 719.495n 3.3v 719.505n 3.3v 729.495n 3.3v 729.505n 3.3v 739.495n 3.3v 739.505n 3.3v 749.495n 3.3v 749.505n 3.3v 759.495n 3.3v 759.505n 3.3v 769.495n 3.3v 769.505n 3.3v 779.495n 3.3v 779.505n 3.3v 789.495n 3.3v 789.505n 3.3v 799.495n 3.3v 799.505n 3.3v 809.495n 3.3v 809.505n 3.3v 819.495n 3.3v 819.505n 3.3v 829.495n 3.3v 829.505n 3.3v 839.495n 3.3v 839.505n 0.0v 849.495n 0.0v 849.505n 0.0v 859.495n 0.0v 859.505n 0.0v 869.495n 0.0v 869.505n 0.0v 879.495n 0.0v 879.505n 3.3v 889.495n 3.3v 889.505n 3.3v 899.495n 3.3v 899.505n 3.3v 909.495n 3.3v 909.505n 3.3v 919.495n 3.3v 919.505n 0.0v 929.495n 0.0v 929.505n 0.0v 939.495n 0.0v 939.505n 0.0v 949.495n 0.0v 949.505n 3.3v 959.495n 3.3v 959.505n 3.3v 969.495n 3.3v 969.505n 3.3v 979.495n 3.3v 979.505n 0.0v 989.495n 0.0v 989.505n 0.0v 999.495n 0.0v 999.505n 0.0v 1009.495n 0.0v 1009.505n 0.0v 1019.495n 0.0v 1019.505n 0.0v 1029.495n 0.0v 1029.505n 3.3v 1039.495n 3.3v 1039.505n 3.3v 1049.495n 3.3v 1049.505n 3.3v 1059.495n 3.3v 1059.505n 3.3v 1069.495n 3.3v 1069.505n 3.3v 1079.495n 3.3v 1079.505n 3.3v 1089.495n 3.3v 1089.505n 3.3v 1099.495n 3.3v 1099.505n 3.3v 1109.495n 3.3v 1109.505n 0.0v 1119.495n 0.0v 1119.505n 0.0v 1129.495n 0.0v 1129.505n 0.0v 1139.495n 0.0v 1139.505n 0.0v 1149.495n 0.0v 1149.505n 0.0v 1159.495n 0.0v 1159.505n 0.0v 1169.495n 0.0v 1169.505n 0.0v 1179.495n 0.0v 1179.505n 3.3v 1189.495n 3.3v 1189.505n 3.3v 1199.495n 3.3v 1199.505n 3.3v 1209.495n 3.3v 1209.505n 3.3v 1219.495n 3.3v 1219.505n 3.3v 1229.495n 3.3v 1229.505n 3.3v 1239.495n 3.3v 1239.505n 3.3v 1249.495n 3.3v 1249.505n 3.3v 1259.495n 3.3v 1259.505n 0.0v 1269.495n 0.0v 1269.505n 0.0v 1279.495n 0.0v 1279.505n 0.0v 1289.495n 0.0v 1289.505n 0.0v 1299.495n 0.0v 1299.505n 0.0v 1309.495n 0.0v 1309.505n 0.0v 1319.495n 0.0v 1319.505n 0.0v 1329.495n 0.0v 1329.505n 0.0v 1339.495n 0.0v 1339.505n 0.0v 1349.495n 0.0v 1349.505n 0.0v 1359.495n 0.0v 1359.505n 0.0v 1369.495n 0.0v 1369.505n 0.0v 1379.495n 0.0v 1379.505n 0.0v 1389.495n 0.0v 1389.505n 0.0v 1399.495n 0.0v 1399.505n 0.0v 1409.495n 0.0v 1409.505n 0.0v 1419.495n 0.0v 1419.505n 0.0v 1429.495n 0.0v 1429.505n 0.0v 1439.495n 0.0v 1439.505n 3.3v 1449.495n 3.3v 1449.505n 3.3v 1459.495n 3.3v 1459.505n 0.0v 1469.495n 0.0v 1469.505n 0.0v 1479.495n 0.0v 1479.505n 0.0v 1489.495n 0.0v 1489.505n 0.0v 1499.495n 0.0v 1499.505n 0.0v 1509.495n 0.0v 1509.505n 0.0v 1519.495n 0.0v 1519.505n 0.0v 1529.495n 0.0v 1529.505n 3.3v 1539.495n 3.3v 1539.505n 3.3v 1549.495n 3.3v 1549.505n 3.3v 1559.495n 3.3v 1559.505n 3.3v 1569.495n 3.3v 1569.505n 3.3v 1579.495n 3.3v 1579.505n 3.3v 1589.495n 3.3v 1589.505n 3.3v 1599.495n 3.3v 1599.505n 3.3v 1609.495n 3.3v 1609.505n 3.3v 1619.495n 3.3v 1619.505n 0.0v 1629.495n 0.0v 1629.505n 0.0v 1639.495n 0.0v 1639.505n 0.0v 1649.495n 0.0v 1649.505n 0.0v 1659.495n 0.0v 1659.505n 3.3v 1669.495n 3.3v 1669.505n 3.3v 1679.495n 3.3v 1679.505n 3.3v 1689.495n 3.3v 1689.505n 3.3v 1699.495n 3.3v 1699.505n 0.0v 1709.495n 0.0v 1709.505n 3.3v 1719.495n 3.3v 1719.505n 3.3v 1729.495n 3.3v 1729.505n 3.3v 1739.495n 3.3v 1739.505n 3.3v 1749.495n 3.3v 1749.505n 3.3v 1759.495n 3.3v 1759.505n 3.3v 1769.495n 3.3v 1769.505n 0.0v 1779.495n 0.0v 1779.505n 3.3v 1789.495n 3.3v 1789.505n 3.3v 1799.495n 3.3v 1799.505n 3.3v 1809.495n 3.3v 1809.505n 3.3v 1819.495n 3.3v 1819.505n 3.3v 1829.495n 3.3v 1829.505n 3.3v 1839.495n 3.3v 1839.505n 0.0v 1849.495n 0.0v 1849.505n 3.3v 1859.495n 3.3v 1859.505n 3.3v 1869.495n 3.3v 1869.505n 3.3v 1879.495n 3.3v 1879.505n 0.0v 1889.495n 0.0v 1889.505n 3.3v 1899.495n 3.3v 1899.505n 3.3v 1909.495n 3.3v 1909.505n 3.3v 1919.495n 3.3v 1919.505n 3.3v 1929.495n 3.3v 1929.505n 3.3v 1939.495n 3.3v 1939.505n 3.3v 1949.495n 3.3v 1949.505n 3.3v 1959.495n 3.3v 1959.505n 3.3v 1969.495n 3.3v 1969.505n 3.3v 1979.495n 3.3v 1979.505n 3.3v 1989.495n 3.3v 1989.505n 3.3v 1999.495n 3.3v 1999.505n 3.3v 2009.495n 3.3v 2009.505n 0.0v 2019.495n 0.0v 2019.505n 0.0v 2029.495n 0.0v 2029.505n 0.0v 2039.495n 0.0v 2039.505n 0.0v 2049.495n 0.0v 2049.505n 0.0v )
* (time, data): [(0, 0), (10, 0), (20, 0), (30, 0), (40, 0), (50, 0), (60, 0), (70, 0), (80, 0), (90, 0), (100, 0), (110, 0), (120, 0), (130, 0), (140, 1), (150, 1), (160, 1), (170, 0), (180, 0), (190, 1), (200, 0), (210, 0), (220, 1), (230, 1), (240, 0), (250, 1), (260, 1), (270, 1), (280, 1), (290, 1), (300, 1), (310, 1), (320, 1), (330, 1), (340, 1), (350, 0), (360, 0), (370, 0), (380, 0), (390, 0), (400, 0), (410, 0), (420, 1), (430, 1), (440, 1), (450, 1), (460, 1), (470, 1), (480, 1), (490, 1), (500, 0), (510, 0), (520, 1), (530, 1), (540, 1), (550, 0), (560, 0), (570, 1), (580, 1), (590, 1), (600, 1), (610, 1), (620, 1), (630, 1), (640, 1), (650, 0), (660, 0), (670, 0), (680, 0), (690, 0), (700, 0), (710, 0), (720, 0), (730, 0), (740, 1), (750, 1), (760, 1), (770, 1), (780, 1), (790, 1), (800, 1), (810, 1), (820, 1), (830, 1), (840, 1), (850, 1), (860, 1), (870, 1), (880, 1), (890, 0), (900, 0), (910, 0), (920, 1), (930, 1), (940, 1), (950, 0), (960, 0), (970, 0), (980, 1), (990, 1), (1000, 1), (1010, 1), (1020, 1), (1030, 0), (1040, 1), (1050, 1), (1060, 1), (1070, 1), (1080, 1), (1090, 1), (1100, 1), (1110, 0), (1120, 0), (1130, 0), (1140, 0), (1150, 0), (1160, 0), (1170, 0), (1180, 0), (1190, 0), (1200, 0), (1210, 0), (1220, 0), (1230, 0), (1240, 0), (1250, 0), (1260, 0), (1270, 0), (1280, 0), (1290, 0), (1300, 0), (1310, 0), (1320, 0), (1330, 0), (1340, 0), (1350, 0), (1360, 0), (1370, 0), (1380, 0), (1390, 0), (1400, 0), (1410, 0), (1420, 0), (1430, 0), (1440, 0), (1450, 0), (1460, 0), (1470, 0), (1480, 0), (1490, 0), (1500, 1), (1510, 1), (1520, 1), (1530, 0), (1540, 0), (1550, 0), (1560, 0), (1570, 0), (1580, 0), (1590, 1), (1600, 1), (1610, 1), (1620, 1), (1630, 1), (1640, 1), (1650, 1), (1660, 0), (1670, 0), (1680, 0), (1690, 0), (1700, 1), (1710, 0), (1720, 1), (1730, 1), (1740, 1), (1750, 1), (1760, 1), (1770, 1), (1780, 0), (1790, 0), (1800, 0), (1810, 0), (1820, 0), (1830, 0), (1840, 0), (1850, 1), (1860, 1), (1870, 1), (1880, 0), (1890, 0), (1900, 0), (1910, 0), (1920, 0), (1930, 1), (1940, 1), (1950, 1), (1960, 1), (1970, 1), (1980, 1), (1990, 1), (2000, 1), (2010, 0), (2020, 0), (2030, 0), (2040, 0), (2050, 0)]
Vdin0_21  din0_21  0 PWL (0n 0.0v 9.495n 0.0v 9.505n 0.0v 19.495n 0.0v 19.505n 0.0v 29.495n 0.0v 29.505n 0.0v 39.495n 0.0v 39.505n 0.0v 49.495n 0.0v 49.505n 0.0v 59.495n 0.0v 59.505n 0.0v 69.495n 0.0v 69.505n 0.0v 79.495n 0.0v 79.505n 0.0v 89.495n 0.0v 89.505n 0.0v 99.495n 0.0v 99.505n 0.0v 109.495n 0.0v 109.505n 0.0v 119.495n 0.0v 119.505n 0.0v 129.495n 0.0v 129.505n 0.0v 139.495n 0.0v 139.505n 3.3v 149.495n 3.3v 149.505n 3.3v 159.495n 3.3v 159.505n 3.3v 169.495n 3.3v 169.505n 0.0v 179.495n 0.0v 179.505n 0.0v 189.495n 0.0v 189.505n 3.3v 199.495n 3.3v 199.505n 0.0v 209.495n 0.0v 209.505n 0.0v 219.495n 0.0v 219.505n 3.3v 229.495n 3.3v 229.505n 3.3v 239.495n 3.3v 239.505n 0.0v 249.495n 0.0v 249.505n 3.3v 259.495n 3.3v 259.505n 3.3v 269.495n 3.3v 269.505n 3.3v 279.495n 3.3v 279.505n 3.3v 289.495n 3.3v 289.505n 3.3v 299.495n 3.3v 299.505n 3.3v 309.495n 3.3v 309.505n 3.3v 319.495n 3.3v 319.505n 3.3v 329.495n 3.3v 329.505n 3.3v 339.495n 3.3v 339.505n 3.3v 349.495n 3.3v 349.505n 0.0v 359.495n 0.0v 359.505n 0.0v 369.495n 0.0v 369.505n 0.0v 379.495n 0.0v 379.505n 0.0v 389.495n 0.0v 389.505n 0.0v 399.495n 0.0v 399.505n 0.0v 409.495n 0.0v 409.505n 0.0v 419.495n 0.0v 419.505n 3.3v 429.495n 3.3v 429.505n 3.3v 439.495n 3.3v 439.505n 3.3v 449.495n 3.3v 449.505n 3.3v 459.495n 3.3v 459.505n 3.3v 469.495n 3.3v 469.505n 3.3v 479.495n 3.3v 479.505n 3.3v 489.495n 3.3v 489.505n 3.3v 499.495n 3.3v 499.505n 0.0v 509.495n 0.0v 509.505n 0.0v 519.495n 0.0v 519.505n 3.3v 529.495n 3.3v 529.505n 3.3v 539.495n 3.3v 539.505n 3.3v 549.495n 3.3v 549.505n 0.0v 559.495n 0.0v 559.505n 0.0v 569.495n 0.0v 569.505n 3.3v 579.495n 3.3v 579.505n 3.3v 589.495n 3.3v 589.505n 3.3v 599.495n 3.3v 599.505n 3.3v 609.495n 3.3v 609.505n 3.3v 619.495n 3.3v 619.505n 3.3v 629.495n 3.3v 629.505n 3.3v 639.495n 3.3v 639.505n 3.3v 649.495n 3.3v 649.505n 0.0v 659.495n 0.0v 659.505n 0.0v 669.495n 0.0v 669.505n 0.0v 679.495n 0.0v 679.505n 0.0v 689.495n 0.0v 689.505n 0.0v 699.495n 0.0v 699.505n 0.0v 709.495n 0.0v 709.505n 0.0v 719.495n 0.0v 719.505n 0.0v 729.495n 0.0v 729.505n 0.0v 739.495n 0.0v 739.505n 3.3v 749.495n 3.3v 749.505n 3.3v 759.495n 3.3v 759.505n 3.3v 769.495n 3.3v 769.505n 3.3v 779.495n 3.3v 779.505n 3.3v 789.495n 3.3v 789.505n 3.3v 799.495n 3.3v 799.505n 3.3v 809.495n 3.3v 809.505n 3.3v 819.495n 3.3v 819.505n 3.3v 829.495n 3.3v 829.505n 3.3v 839.495n 3.3v 839.505n 3.3v 849.495n 3.3v 849.505n 3.3v 859.495n 3.3v 859.505n 3.3v 869.495n 3.3v 869.505n 3.3v 879.495n 3.3v 879.505n 3.3v 889.495n 3.3v 889.505n 0.0v 899.495n 0.0v 899.505n 0.0v 909.495n 0.0v 909.505n 0.0v 919.495n 0.0v 919.505n 3.3v 929.495n 3.3v 929.505n 3.3v 939.495n 3.3v 939.505n 3.3v 949.495n 3.3v 949.505n 0.0v 959.495n 0.0v 959.505n 0.0v 969.495n 0.0v 969.505n 0.0v 979.495n 0.0v 979.505n 3.3v 989.495n 3.3v 989.505n 3.3v 999.495n 3.3v 999.505n 3.3v 1009.495n 3.3v 1009.505n 3.3v 1019.495n 3.3v 1019.505n 3.3v 1029.495n 3.3v 1029.505n 0.0v 1039.495n 0.0v 1039.505n 3.3v 1049.495n 3.3v 1049.505n 3.3v 1059.495n 3.3v 1059.505n 3.3v 1069.495n 3.3v 1069.505n 3.3v 1079.495n 3.3v 1079.505n 3.3v 1089.495n 3.3v 1089.505n 3.3v 1099.495n 3.3v 1099.505n 3.3v 1109.495n 3.3v 1109.505n 0.0v 1119.495n 0.0v 1119.505n 0.0v 1129.495n 0.0v 1129.505n 0.0v 1139.495n 0.0v 1139.505n 0.0v 1149.495n 0.0v 1149.505n 0.0v 1159.495n 0.0v 1159.505n 0.0v 1169.495n 0.0v 1169.505n 0.0v 1179.495n 0.0v 1179.505n 0.0v 1189.495n 0.0v 1189.505n 0.0v 1199.495n 0.0v 1199.505n 0.0v 1209.495n 0.0v 1209.505n 0.0v 1219.495n 0.0v 1219.505n 0.0v 1229.495n 0.0v 1229.505n 0.0v 1239.495n 0.0v 1239.505n 0.0v 1249.495n 0.0v 1249.505n 0.0v 1259.495n 0.0v 1259.505n 0.0v 1269.495n 0.0v 1269.505n 0.0v 1279.495n 0.0v 1279.505n 0.0v 1289.495n 0.0v 1289.505n 0.0v 1299.495n 0.0v 1299.505n 0.0v 1309.495n 0.0v 1309.505n 0.0v 1319.495n 0.0v 1319.505n 0.0v 1329.495n 0.0v 1329.505n 0.0v 1339.495n 0.0v 1339.505n 0.0v 1349.495n 0.0v 1349.505n 0.0v 1359.495n 0.0v 1359.505n 0.0v 1369.495n 0.0v 1369.505n 0.0v 1379.495n 0.0v 1379.505n 0.0v 1389.495n 0.0v 1389.505n 0.0v 1399.495n 0.0v 1399.505n 0.0v 1409.495n 0.0v 1409.505n 0.0v 1419.495n 0.0v 1419.505n 0.0v 1429.495n 0.0v 1429.505n 0.0v 1439.495n 0.0v 1439.505n 0.0v 1449.495n 0.0v 1449.505n 0.0v 1459.495n 0.0v 1459.505n 0.0v 1469.495n 0.0v 1469.505n 0.0v 1479.495n 0.0v 1479.505n 0.0v 1489.495n 0.0v 1489.505n 0.0v 1499.495n 0.0v 1499.505n 3.3v 1509.495n 3.3v 1509.505n 3.3v 1519.495n 3.3v 1519.505n 3.3v 1529.495n 3.3v 1529.505n 0.0v 1539.495n 0.0v 1539.505n 0.0v 1549.495n 0.0v 1549.505n 0.0v 1559.495n 0.0v 1559.505n 0.0v 1569.495n 0.0v 1569.505n 0.0v 1579.495n 0.0v 1579.505n 0.0v 1589.495n 0.0v 1589.505n 3.3v 1599.495n 3.3v 1599.505n 3.3v 1609.495n 3.3v 1609.505n 3.3v 1619.495n 3.3v 1619.505n 3.3v 1629.495n 3.3v 1629.505n 3.3v 1639.495n 3.3v 1639.505n 3.3v 1649.495n 3.3v 1649.505n 3.3v 1659.495n 3.3v 1659.505n 0.0v 1669.495n 0.0v 1669.505n 0.0v 1679.495n 0.0v 1679.505n 0.0v 1689.495n 0.0v 1689.505n 0.0v 1699.495n 0.0v 1699.505n 3.3v 1709.495n 3.3v 1709.505n 0.0v 1719.495n 0.0v 1719.505n 3.3v 1729.495n 3.3v 1729.505n 3.3v 1739.495n 3.3v 1739.505n 3.3v 1749.495n 3.3v 1749.505n 3.3v 1759.495n 3.3v 1759.505n 3.3v 1769.495n 3.3v 1769.505n 3.3v 1779.495n 3.3v 1779.505n 0.0v 1789.495n 0.0v 1789.505n 0.0v 1799.495n 0.0v 1799.505n 0.0v 1809.495n 0.0v 1809.505n 0.0v 1819.495n 0.0v 1819.505n 0.0v 1829.495n 0.0v 1829.505n 0.0v 1839.495n 0.0v 1839.505n 0.0v 1849.495n 0.0v 1849.505n 3.3v 1859.495n 3.3v 1859.505n 3.3v 1869.495n 3.3v 1869.505n 3.3v 1879.495n 3.3v 1879.505n 0.0v 1889.495n 0.0v 1889.505n 0.0v 1899.495n 0.0v 1899.505n 0.0v 1909.495n 0.0v 1909.505n 0.0v 1919.495n 0.0v 1919.505n 0.0v 1929.495n 0.0v 1929.505n 3.3v 1939.495n 3.3v 1939.505n 3.3v 1949.495n 3.3v 1949.505n 3.3v 1959.495n 3.3v 1959.505n 3.3v 1969.495n 3.3v 1969.505n 3.3v 1979.495n 3.3v 1979.505n 3.3v 1989.495n 3.3v 1989.505n 3.3v 1999.495n 3.3v 1999.505n 3.3v 2009.495n 3.3v 2009.505n 0.0v 2019.495n 0.0v 2019.505n 0.0v 2029.495n 0.0v 2029.505n 0.0v 2039.495n 0.0v 2039.505n 0.0v 2049.495n 0.0v 2049.505n 0.0v )
* (time, data): [(0, 0), (10, 1), (20, 0), (30, 0), (40, 0), (50, 0), (60, 0), (70, 0), (80, 0), (90, 0), (100, 0), (110, 0), (120, 1), (130, 1), (140, 1), (150, 1), (160, 1), (170, 0), (180, 0), (190, 1), (200, 1), (210, 1), (220, 1), (230, 1), (240, 1), (250, 1), (260, 1), (270, 0), (280, 0), (290, 0), (300, 0), (310, 0), (320, 0), (330, 0), (340, 0), (350, 0), (360, 0), (370, 0), (380, 0), (390, 0), (400, 0), (410, 0), (420, 0), (430, 1), (440, 1), (450, 0), (460, 0), (470, 0), (480, 0), (490, 0), (500, 0), (510, 0), (520, 0), (530, 0), (540, 0), (550, 0), (560, 1), (570, 0), (580, 0), (590, 0), (600, 0), (610, 0), (620, 0), (630, 0), (640, 0), (650, 0), (660, 0), (670, 1), (680, 1), (690, 1), (700, 1), (710, 1), (720, 1), (730, 1), (740, 1), (750, 1), (760, 1), (770, 1), (780, 1), (790, 1), (800, 1), (810, 1), (820, 1), (830, 1), (840, 1), (850, 1), (860, 1), (870, 1), (880, 0), (890, 0), (900, 0), (910, 0), (920, 1), (930, 0), (940, 0), (950, 0), (960, 0), (970, 0), (980, 0), (990, 0), (1000, 0), (1010, 0), (1020, 0), (1030, 0), (1040, 1), (1050, 1), (1060, 1), (1070, 1), (1080, 1), (1090, 1), (1100, 1), (1110, 0), (1120, 0), (1130, 0), (1140, 0), (1150, 0), (1160, 0), (1170, 0), (1180, 1), (1190, 1), (1200, 1), (1210, 1), (1220, 1), (1230, 1), (1240, 1), (1250, 1), (1260, 0), (1270, 0), (1280, 0), (1290, 0), (1300, 0), (1310, 0), (1320, 0), (1330, 0), (1340, 0), (1350, 0), (1360, 0), (1370, 0), (1380, 0), (1390, 0), (1400, 0), (1410, 0), (1420, 0), (1430, 0), (1440, 0), (1450, 0), (1460, 1), (1470, 1), (1480, 1), (1490, 1), (1500, 0), (1510, 1), (1520, 1), (1530, 1), (1540, 1), (1550, 1), (1560, 1), (1570, 1), (1580, 1), (1590, 0), (1600, 0), (1610, 0), (1620, 1), (1630, 1), (1640, 1), (1650, 1), (1660, 0), (1670, 0), (1680, 0), (1690, 0), (1700, 1), (1710, 1), (1720, 1), (1730, 1), (1740, 1), (1750, 1), (1760, 1), (1770, 0), (1780, 0), (1790, 0), (1800, 0), (1810, 0), (1820, 0), (1830, 0), (1840, 0), (1850, 1), (1860, 1), (1870, 1), (1880, 0), (1890, 0), (1900, 0), (1910, 0), (1920, 0), (1930, 1), (1940, 1), (1950, 1), (1960, 1), (1970, 1), (1980, 1), (1990, 1), (2000, 1), (2010, 0), (2020, 0), (2030, 0), (2040, 0), (2050, 0)]
Vdin0_22  din0_22  0 PWL (0n 0.0v 9.495n 0.0v 9.505n 3.3v 19.495n 3.3v 19.505n 0.0v 29.495n 0.0v 29.505n 0.0v 39.495n 0.0v 39.505n 0.0v 49.495n 0.0v 49.505n 0.0v 59.495n 0.0v 59.505n 0.0v 69.495n 0.0v 69.505n 0.0v 79.495n 0.0v 79.505n 0.0v 89.495n 0.0v 89.505n 0.0v 99.495n 0.0v 99.505n 0.0v 109.495n 0.0v 109.505n 0.0v 119.495n 0.0v 119.505n 3.3v 129.495n 3.3v 129.505n 3.3v 139.495n 3.3v 139.505n 3.3v 149.495n 3.3v 149.505n 3.3v 159.495n 3.3v 159.505n 3.3v 169.495n 3.3v 169.505n 0.0v 179.495n 0.0v 179.505n 0.0v 189.495n 0.0v 189.505n 3.3v 199.495n 3.3v 199.505n 3.3v 209.495n 3.3v 209.505n 3.3v 219.495n 3.3v 219.505n 3.3v 229.495n 3.3v 229.505n 3.3v 239.495n 3.3v 239.505n 3.3v 249.495n 3.3v 249.505n 3.3v 259.495n 3.3v 259.505n 3.3v 269.495n 3.3v 269.505n 0.0v 279.495n 0.0v 279.505n 0.0v 289.495n 0.0v 289.505n 0.0v 299.495n 0.0v 299.505n 0.0v 309.495n 0.0v 309.505n 0.0v 319.495n 0.0v 319.505n 0.0v 329.495n 0.0v 329.505n 0.0v 339.495n 0.0v 339.505n 0.0v 349.495n 0.0v 349.505n 0.0v 359.495n 0.0v 359.505n 0.0v 369.495n 0.0v 369.505n 0.0v 379.495n 0.0v 379.505n 0.0v 389.495n 0.0v 389.505n 0.0v 399.495n 0.0v 399.505n 0.0v 409.495n 0.0v 409.505n 0.0v 419.495n 0.0v 419.505n 0.0v 429.495n 0.0v 429.505n 3.3v 439.495n 3.3v 439.505n 3.3v 449.495n 3.3v 449.505n 0.0v 459.495n 0.0v 459.505n 0.0v 469.495n 0.0v 469.505n 0.0v 479.495n 0.0v 479.505n 0.0v 489.495n 0.0v 489.505n 0.0v 499.495n 0.0v 499.505n 0.0v 509.495n 0.0v 509.505n 0.0v 519.495n 0.0v 519.505n 0.0v 529.495n 0.0v 529.505n 0.0v 539.495n 0.0v 539.505n 0.0v 549.495n 0.0v 549.505n 0.0v 559.495n 0.0v 559.505n 3.3v 569.495n 3.3v 569.505n 0.0v 579.495n 0.0v 579.505n 0.0v 589.495n 0.0v 589.505n 0.0v 599.495n 0.0v 599.505n 0.0v 609.495n 0.0v 609.505n 0.0v 619.495n 0.0v 619.505n 0.0v 629.495n 0.0v 629.505n 0.0v 639.495n 0.0v 639.505n 0.0v 649.495n 0.0v 649.505n 0.0v 659.495n 0.0v 659.505n 0.0v 669.495n 0.0v 669.505n 3.3v 679.495n 3.3v 679.505n 3.3v 689.495n 3.3v 689.505n 3.3v 699.495n 3.3v 699.505n 3.3v 709.495n 3.3v 709.505n 3.3v 719.495n 3.3v 719.505n 3.3v 729.495n 3.3v 729.505n 3.3v 739.495n 3.3v 739.505n 3.3v 749.495n 3.3v 749.505n 3.3v 759.495n 3.3v 759.505n 3.3v 769.495n 3.3v 769.505n 3.3v 779.495n 3.3v 779.505n 3.3v 789.495n 3.3v 789.505n 3.3v 799.495n 3.3v 799.505n 3.3v 809.495n 3.3v 809.505n 3.3v 819.495n 3.3v 819.505n 3.3v 829.495n 3.3v 829.505n 3.3v 839.495n 3.3v 839.505n 3.3v 849.495n 3.3v 849.505n 3.3v 859.495n 3.3v 859.505n 3.3v 869.495n 3.3v 869.505n 3.3v 879.495n 3.3v 879.505n 0.0v 889.495n 0.0v 889.505n 0.0v 899.495n 0.0v 899.505n 0.0v 909.495n 0.0v 909.505n 0.0v 919.495n 0.0v 919.505n 3.3v 929.495n 3.3v 929.505n 0.0v 939.495n 0.0v 939.505n 0.0v 949.495n 0.0v 949.505n 0.0v 959.495n 0.0v 959.505n 0.0v 969.495n 0.0v 969.505n 0.0v 979.495n 0.0v 979.505n 0.0v 989.495n 0.0v 989.505n 0.0v 999.495n 0.0v 999.505n 0.0v 1009.495n 0.0v 1009.505n 0.0v 1019.495n 0.0v 1019.505n 0.0v 1029.495n 0.0v 1029.505n 0.0v 1039.495n 0.0v 1039.505n 3.3v 1049.495n 3.3v 1049.505n 3.3v 1059.495n 3.3v 1059.505n 3.3v 1069.495n 3.3v 1069.505n 3.3v 1079.495n 3.3v 1079.505n 3.3v 1089.495n 3.3v 1089.505n 3.3v 1099.495n 3.3v 1099.505n 3.3v 1109.495n 3.3v 1109.505n 0.0v 1119.495n 0.0v 1119.505n 0.0v 1129.495n 0.0v 1129.505n 0.0v 1139.495n 0.0v 1139.505n 0.0v 1149.495n 0.0v 1149.505n 0.0v 1159.495n 0.0v 1159.505n 0.0v 1169.495n 0.0v 1169.505n 0.0v 1179.495n 0.0v 1179.505n 3.3v 1189.495n 3.3v 1189.505n 3.3v 1199.495n 3.3v 1199.505n 3.3v 1209.495n 3.3v 1209.505n 3.3v 1219.495n 3.3v 1219.505n 3.3v 1229.495n 3.3v 1229.505n 3.3v 1239.495n 3.3v 1239.505n 3.3v 1249.495n 3.3v 1249.505n 3.3v 1259.495n 3.3v 1259.505n 0.0v 1269.495n 0.0v 1269.505n 0.0v 1279.495n 0.0v 1279.505n 0.0v 1289.495n 0.0v 1289.505n 0.0v 1299.495n 0.0v 1299.505n 0.0v 1309.495n 0.0v 1309.505n 0.0v 1319.495n 0.0v 1319.505n 0.0v 1329.495n 0.0v 1329.505n 0.0v 1339.495n 0.0v 1339.505n 0.0v 1349.495n 0.0v 1349.505n 0.0v 1359.495n 0.0v 1359.505n 0.0v 1369.495n 0.0v 1369.505n 0.0v 1379.495n 0.0v 1379.505n 0.0v 1389.495n 0.0v 1389.505n 0.0v 1399.495n 0.0v 1399.505n 0.0v 1409.495n 0.0v 1409.505n 0.0v 1419.495n 0.0v 1419.505n 0.0v 1429.495n 0.0v 1429.505n 0.0v 1439.495n 0.0v 1439.505n 0.0v 1449.495n 0.0v 1449.505n 0.0v 1459.495n 0.0v 1459.505n 3.3v 1469.495n 3.3v 1469.505n 3.3v 1479.495n 3.3v 1479.505n 3.3v 1489.495n 3.3v 1489.505n 3.3v 1499.495n 3.3v 1499.505n 0.0v 1509.495n 0.0v 1509.505n 3.3v 1519.495n 3.3v 1519.505n 3.3v 1529.495n 3.3v 1529.505n 3.3v 1539.495n 3.3v 1539.505n 3.3v 1549.495n 3.3v 1549.505n 3.3v 1559.495n 3.3v 1559.505n 3.3v 1569.495n 3.3v 1569.505n 3.3v 1579.495n 3.3v 1579.505n 3.3v 1589.495n 3.3v 1589.505n 0.0v 1599.495n 0.0v 1599.505n 0.0v 1609.495n 0.0v 1609.505n 0.0v 1619.495n 0.0v 1619.505n 3.3v 1629.495n 3.3v 1629.505n 3.3v 1639.495n 3.3v 1639.505n 3.3v 1649.495n 3.3v 1649.505n 3.3v 1659.495n 3.3v 1659.505n 0.0v 1669.495n 0.0v 1669.505n 0.0v 1679.495n 0.0v 1679.505n 0.0v 1689.495n 0.0v 1689.505n 0.0v 1699.495n 0.0v 1699.505n 3.3v 1709.495n 3.3v 1709.505n 3.3v 1719.495n 3.3v 1719.505n 3.3v 1729.495n 3.3v 1729.505n 3.3v 1739.495n 3.3v 1739.505n 3.3v 1749.495n 3.3v 1749.505n 3.3v 1759.495n 3.3v 1759.505n 3.3v 1769.495n 3.3v 1769.505n 0.0v 1779.495n 0.0v 1779.505n 0.0v 1789.495n 0.0v 1789.505n 0.0v 1799.495n 0.0v 1799.505n 0.0v 1809.495n 0.0v 1809.505n 0.0v 1819.495n 0.0v 1819.505n 0.0v 1829.495n 0.0v 1829.505n 0.0v 1839.495n 0.0v 1839.505n 0.0v 1849.495n 0.0v 1849.505n 3.3v 1859.495n 3.3v 1859.505n 3.3v 1869.495n 3.3v 1869.505n 3.3v 1879.495n 3.3v 1879.505n 0.0v 1889.495n 0.0v 1889.505n 0.0v 1899.495n 0.0v 1899.505n 0.0v 1909.495n 0.0v 1909.505n 0.0v 1919.495n 0.0v 1919.505n 0.0v 1929.495n 0.0v 1929.505n 3.3v 1939.495n 3.3v 1939.505n 3.3v 1949.495n 3.3v 1949.505n 3.3v 1959.495n 3.3v 1959.505n 3.3v 1969.495n 3.3v 1969.505n 3.3v 1979.495n 3.3v 1979.505n 3.3v 1989.495n 3.3v 1989.505n 3.3v 1999.495n 3.3v 1999.505n 3.3v 2009.495n 3.3v 2009.505n 0.0v 2019.495n 0.0v 2019.505n 0.0v 2029.495n 0.0v 2029.505n 0.0v 2039.495n 0.0v 2039.505n 0.0v 2049.495n 0.0v 2049.505n 0.0v )
* (time, data): [(0, 0), (10, 0), (20, 1), (30, 0), (40, 0), (50, 0), (60, 0), (70, 0), (80, 0), (90, 0), (100, 0), (110, 0), (120, 1), (130, 1), (140, 1), (150, 0), (160, 0), (170, 0), (180, 0), (190, 1), (200, 0), (210, 1), (220, 0), (230, 0), (240, 0), (250, 0), (260, 0), (270, 0), (280, 0), (290, 0), (300, 0), (310, 0), (320, 1), (330, 1), (340, 1), (350, 0), (360, 0), (370, 0), (380, 0), (390, 0), (400, 0), (410, 0), (420, 1), (430, 0), (440, 0), (450, 0), (460, 0), (470, 0), (480, 0), (490, 1), (500, 1), (510, 0), (520, 0), (530, 0), (540, 0), (550, 0), (560, 1), (570, 1), (580, 1), (590, 1), (600, 1), (610, 1), (620, 1), (630, 1), (640, 1), (650, 1), (660, 1), (670, 1), (680, 1), (690, 1), (700, 1), (710, 1), (720, 1), (730, 1), (740, 1), (750, 1), (760, 1), (770, 1), (780, 1), (790, 1), (800, 1), (810, 1), (820, 1), (830, 1), (840, 1), (850, 1), (860, 1), (870, 1), (880, 0), (890, 0), (900, 0), (910, 0), (920, 1), (930, 0), (940, 0), (950, 0), (960, 0), (970, 0), (980, 1), (990, 1), (1000, 1), (1010, 1), (1020, 1), (1030, 0), (1040, 1), (1050, 1), (1060, 1), (1070, 1), (1080, 1), (1090, 1), (1100, 1), (1110, 0), (1120, 0), (1130, 0), (1140, 0), (1150, 0), (1160, 0), (1170, 0), (1180, 0), (1190, 0), (1200, 0), (1210, 0), (1220, 1), (1230, 1), (1240, 1), (1250, 1), (1260, 0), (1270, 0), (1280, 0), (1290, 0), (1300, 0), (1310, 0), (1320, 0), (1330, 0), (1340, 0), (1350, 0), (1360, 1), (1370, 0), (1380, 0), (1390, 0), (1400, 0), (1410, 0), (1420, 0), (1430, 0), (1440, 1), (1450, 1), (1460, 1), (1470, 1), (1480, 1), (1490, 1), (1500, 1), (1510, 0), (1520, 0), (1530, 1), (1540, 1), (1550, 1), (1560, 1), (1570, 1), (1580, 1), (1590, 1), (1600, 1), (1610, 1), (1620, 0), (1630, 0), (1640, 0), (1650, 0), (1660, 1), (1670, 1), (1680, 1), (1690, 1), (1700, 0), (1710, 0), (1720, 0), (1730, 0), (1740, 0), (1750, 0), (1760, 0), (1770, 0), (1780, 0), (1790, 0), (1800, 0), (1810, 0), (1820, 0), (1830, 0), (1840, 0), (1850, 0), (1860, 0), (1870, 0), (1880, 0), (1890, 1), (1900, 1), (1910, 1), (1920, 1), (1930, 1), (1940, 1), (1950, 1), (1960, 1), (1970, 1), (1980, 0), (1990, 0), (2000, 0), (2010, 0), (2020, 0), (2030, 0), (2040, 0), (2050, 0)]
Vdin0_23  din0_23  0 PWL (0n 0.0v 9.495n 0.0v 9.505n 0.0v 19.495n 0.0v 19.505n 3.3v 29.495n 3.3v 29.505n 0.0v 39.495n 0.0v 39.505n 0.0v 49.495n 0.0v 49.505n 0.0v 59.495n 0.0v 59.505n 0.0v 69.495n 0.0v 69.505n 0.0v 79.495n 0.0v 79.505n 0.0v 89.495n 0.0v 89.505n 0.0v 99.495n 0.0v 99.505n 0.0v 109.495n 0.0v 109.505n 0.0v 119.495n 0.0v 119.505n 3.3v 129.495n 3.3v 129.505n 3.3v 139.495n 3.3v 139.505n 3.3v 149.495n 3.3v 149.505n 0.0v 159.495n 0.0v 159.505n 0.0v 169.495n 0.0v 169.505n 0.0v 179.495n 0.0v 179.505n 0.0v 189.495n 0.0v 189.505n 3.3v 199.495n 3.3v 199.505n 0.0v 209.495n 0.0v 209.505n 3.3v 219.495n 3.3v 219.505n 0.0v 229.495n 0.0v 229.505n 0.0v 239.495n 0.0v 239.505n 0.0v 249.495n 0.0v 249.505n 0.0v 259.495n 0.0v 259.505n 0.0v 269.495n 0.0v 269.505n 0.0v 279.495n 0.0v 279.505n 0.0v 289.495n 0.0v 289.505n 0.0v 299.495n 0.0v 299.505n 0.0v 309.495n 0.0v 309.505n 0.0v 319.495n 0.0v 319.505n 3.3v 329.495n 3.3v 329.505n 3.3v 339.495n 3.3v 339.505n 3.3v 349.495n 3.3v 349.505n 0.0v 359.495n 0.0v 359.505n 0.0v 369.495n 0.0v 369.505n 0.0v 379.495n 0.0v 379.505n 0.0v 389.495n 0.0v 389.505n 0.0v 399.495n 0.0v 399.505n 0.0v 409.495n 0.0v 409.505n 0.0v 419.495n 0.0v 419.505n 3.3v 429.495n 3.3v 429.505n 0.0v 439.495n 0.0v 439.505n 0.0v 449.495n 0.0v 449.505n 0.0v 459.495n 0.0v 459.505n 0.0v 469.495n 0.0v 469.505n 0.0v 479.495n 0.0v 479.505n 0.0v 489.495n 0.0v 489.505n 3.3v 499.495n 3.3v 499.505n 3.3v 509.495n 3.3v 509.505n 0.0v 519.495n 0.0v 519.505n 0.0v 529.495n 0.0v 529.505n 0.0v 539.495n 0.0v 539.505n 0.0v 549.495n 0.0v 549.505n 0.0v 559.495n 0.0v 559.505n 3.3v 569.495n 3.3v 569.505n 3.3v 579.495n 3.3v 579.505n 3.3v 589.495n 3.3v 589.505n 3.3v 599.495n 3.3v 599.505n 3.3v 609.495n 3.3v 609.505n 3.3v 619.495n 3.3v 619.505n 3.3v 629.495n 3.3v 629.505n 3.3v 639.495n 3.3v 639.505n 3.3v 649.495n 3.3v 649.505n 3.3v 659.495n 3.3v 659.505n 3.3v 669.495n 3.3v 669.505n 3.3v 679.495n 3.3v 679.505n 3.3v 689.495n 3.3v 689.505n 3.3v 699.495n 3.3v 699.505n 3.3v 709.495n 3.3v 709.505n 3.3v 719.495n 3.3v 719.505n 3.3v 729.495n 3.3v 729.505n 3.3v 739.495n 3.3v 739.505n 3.3v 749.495n 3.3v 749.505n 3.3v 759.495n 3.3v 759.505n 3.3v 769.495n 3.3v 769.505n 3.3v 779.495n 3.3v 779.505n 3.3v 789.495n 3.3v 789.505n 3.3v 799.495n 3.3v 799.505n 3.3v 809.495n 3.3v 809.505n 3.3v 819.495n 3.3v 819.505n 3.3v 829.495n 3.3v 829.505n 3.3v 839.495n 3.3v 839.505n 3.3v 849.495n 3.3v 849.505n 3.3v 859.495n 3.3v 859.505n 3.3v 869.495n 3.3v 869.505n 3.3v 879.495n 3.3v 879.505n 0.0v 889.495n 0.0v 889.505n 0.0v 899.495n 0.0v 899.505n 0.0v 909.495n 0.0v 909.505n 0.0v 919.495n 0.0v 919.505n 3.3v 929.495n 3.3v 929.505n 0.0v 939.495n 0.0v 939.505n 0.0v 949.495n 0.0v 949.505n 0.0v 959.495n 0.0v 959.505n 0.0v 969.495n 0.0v 969.505n 0.0v 979.495n 0.0v 979.505n 3.3v 989.495n 3.3v 989.505n 3.3v 999.495n 3.3v 999.505n 3.3v 1009.495n 3.3v 1009.505n 3.3v 1019.495n 3.3v 1019.505n 3.3v 1029.495n 3.3v 1029.505n 0.0v 1039.495n 0.0v 1039.505n 3.3v 1049.495n 3.3v 1049.505n 3.3v 1059.495n 3.3v 1059.505n 3.3v 1069.495n 3.3v 1069.505n 3.3v 1079.495n 3.3v 1079.505n 3.3v 1089.495n 3.3v 1089.505n 3.3v 1099.495n 3.3v 1099.505n 3.3v 1109.495n 3.3v 1109.505n 0.0v 1119.495n 0.0v 1119.505n 0.0v 1129.495n 0.0v 1129.505n 0.0v 1139.495n 0.0v 1139.505n 0.0v 1149.495n 0.0v 1149.505n 0.0v 1159.495n 0.0v 1159.505n 0.0v 1169.495n 0.0v 1169.505n 0.0v 1179.495n 0.0v 1179.505n 0.0v 1189.495n 0.0v 1189.505n 0.0v 1199.495n 0.0v 1199.505n 0.0v 1209.495n 0.0v 1209.505n 0.0v 1219.495n 0.0v 1219.505n 3.3v 1229.495n 3.3v 1229.505n 3.3v 1239.495n 3.3v 1239.505n 3.3v 1249.495n 3.3v 1249.505n 3.3v 1259.495n 3.3v 1259.505n 0.0v 1269.495n 0.0v 1269.505n 0.0v 1279.495n 0.0v 1279.505n 0.0v 1289.495n 0.0v 1289.505n 0.0v 1299.495n 0.0v 1299.505n 0.0v 1309.495n 0.0v 1309.505n 0.0v 1319.495n 0.0v 1319.505n 0.0v 1329.495n 0.0v 1329.505n 0.0v 1339.495n 0.0v 1339.505n 0.0v 1349.495n 0.0v 1349.505n 0.0v 1359.495n 0.0v 1359.505n 3.3v 1369.495n 3.3v 1369.505n 0.0v 1379.495n 0.0v 1379.505n 0.0v 1389.495n 0.0v 1389.505n 0.0v 1399.495n 0.0v 1399.505n 0.0v 1409.495n 0.0v 1409.505n 0.0v 1419.495n 0.0v 1419.505n 0.0v 1429.495n 0.0v 1429.505n 0.0v 1439.495n 0.0v 1439.505n 3.3v 1449.495n 3.3v 1449.505n 3.3v 1459.495n 3.3v 1459.505n 3.3v 1469.495n 3.3v 1469.505n 3.3v 1479.495n 3.3v 1479.505n 3.3v 1489.495n 3.3v 1489.505n 3.3v 1499.495n 3.3v 1499.505n 3.3v 1509.495n 3.3v 1509.505n 0.0v 1519.495n 0.0v 1519.505n 0.0v 1529.495n 0.0v 1529.505n 3.3v 1539.495n 3.3v 1539.505n 3.3v 1549.495n 3.3v 1549.505n 3.3v 1559.495n 3.3v 1559.505n 3.3v 1569.495n 3.3v 1569.505n 3.3v 1579.495n 3.3v 1579.505n 3.3v 1589.495n 3.3v 1589.505n 3.3v 1599.495n 3.3v 1599.505n 3.3v 1609.495n 3.3v 1609.505n 3.3v 1619.495n 3.3v 1619.505n 0.0v 1629.495n 0.0v 1629.505n 0.0v 1639.495n 0.0v 1639.505n 0.0v 1649.495n 0.0v 1649.505n 0.0v 1659.495n 0.0v 1659.505n 3.3v 1669.495n 3.3v 1669.505n 3.3v 1679.495n 3.3v 1679.505n 3.3v 1689.495n 3.3v 1689.505n 3.3v 1699.495n 3.3v 1699.505n 0.0v 1709.495n 0.0v 1709.505n 0.0v 1719.495n 0.0v 1719.505n 0.0v 1729.495n 0.0v 1729.505n 0.0v 1739.495n 0.0v 1739.505n 0.0v 1749.495n 0.0v 1749.505n 0.0v 1759.495n 0.0v 1759.505n 0.0v 1769.495n 0.0v 1769.505n 0.0v 1779.495n 0.0v 1779.505n 0.0v 1789.495n 0.0v 1789.505n 0.0v 1799.495n 0.0v 1799.505n 0.0v 1809.495n 0.0v 1809.505n 0.0v 1819.495n 0.0v 1819.505n 0.0v 1829.495n 0.0v 1829.505n 0.0v 1839.495n 0.0v 1839.505n 0.0v 1849.495n 0.0v 1849.505n 0.0v 1859.495n 0.0v 1859.505n 0.0v 1869.495n 0.0v 1869.505n 0.0v 1879.495n 0.0v 1879.505n 0.0v 1889.495n 0.0v 1889.505n 3.3v 1899.495n 3.3v 1899.505n 3.3v 1909.495n 3.3v 1909.505n 3.3v 1919.495n 3.3v 1919.505n 3.3v 1929.495n 3.3v 1929.505n 3.3v 1939.495n 3.3v 1939.505n 3.3v 1949.495n 3.3v 1949.505n 3.3v 1959.495n 3.3v 1959.505n 3.3v 1969.495n 3.3v 1969.505n 3.3v 1979.495n 3.3v 1979.505n 0.0v 1989.495n 0.0v 1989.505n 0.0v 1999.495n 0.0v 1999.505n 0.0v 2009.495n 0.0v 2009.505n 0.0v 2019.495n 0.0v 2019.505n 0.0v 2029.495n 0.0v 2029.505n 0.0v 2039.495n 0.0v 2039.505n 0.0v 2049.495n 0.0v 2049.505n 0.0v )
* (time, data): [(0, 0), (10, 1), (20, 0), (30, 0), (40, 0), (50, 0), (60, 0), (70, 0), (80, 0), (90, 0), (100, 0), (110, 0), (120, 1), (130, 1), (140, 1), (150, 1), (160, 1), (170, 1), (180, 1), (190, 0), (200, 1), (210, 1), (220, 1), (230, 1), (240, 0), (250, 1), (260, 1), (270, 0), (280, 0), (290, 0), (300, 0), (310, 0), (320, 1), (330, 1), (340, 1), (350, 1), (360, 1), (370, 1), (380, 1), (390, 1), (400, 1), (410, 1), (420, 1), (430, 1), (440, 1), (450, 0), (460, 0), (470, 0), (480, 0), (490, 1), (500, 1), (510, 1), (520, 1), (530, 1), (540, 1), (550, 0), (560, 0), (570, 1), (580, 1), (590, 1), (600, 1), (610, 1), (620, 1), (630, 1), (640, 1), (650, 1), (660, 1), (670, 0), (680, 0), (690, 0), (700, 0), (710, 0), (720, 0), (730, 0), (740, 0), (750, 0), (760, 0), (770, 0), (780, 0), (790, 0), (800, 0), (810, 0), (820, 0), (830, 0), (840, 0), (850, 0), (860, 0), (870, 0), (880, 0), (890, 0), (900, 0), (910, 0), (920, 1), (930, 1), (940, 1), (950, 1), (960, 1), (970, 1), (980, 1), (990, 1), (1000, 1), (1010, 1), (1020, 1), (1030, 0), (1040, 1), (1050, 1), (1060, 1), (1070, 1), (1080, 1), (1090, 1), (1100, 1), (1110, 1), (1120, 1), (1130, 1), (1140, 1), (1150, 1), (1160, 1), (1170, 1), (1180, 0), (1190, 0), (1200, 0), (1210, 0), (1220, 0), (1230, 0), (1240, 0), (1250, 0), (1260, 1), (1270, 1), (1280, 1), (1290, 1), (1300, 1), (1310, 1), (1320, 1), (1330, 1), (1340, 1), (1350, 1), (1360, 1), (1370, 0), (1380, 0), (1390, 0), (1400, 0), (1410, 0), (1420, 0), (1430, 0), (1440, 0), (1450, 0), (1460, 1), (1470, 1), (1480, 1), (1490, 1), (1500, 0), (1510, 1), (1520, 1), (1530, 1), (1540, 1), (1550, 1), (1560, 1), (1570, 1), (1580, 1), (1590, 1), (1600, 1), (1610, 1), (1620, 0), (1630, 0), (1640, 0), (1650, 0), (1660, 1), (1670, 1), (1680, 1), (1690, 1), (1700, 0), (1710, 1), (1720, 0), (1730, 0), (1740, 0), (1750, 0), (1760, 0), (1770, 0), (1780, 0), (1790, 0), (1800, 0), (1810, 0), (1820, 0), (1830, 0), (1840, 1), (1850, 1), (1860, 1), (1870, 1), (1880, 0), (1890, 1), (1900, 1), (1910, 1), (1920, 1), (1930, 0), (1940, 0), (1950, 0), (1960, 0), (1970, 0), (1980, 1), (1990, 1), (2000, 1), (2010, 0), (2020, 0), (2030, 0), (2040, 0), (2050, 0)]
Vdin0_24  din0_24  0 PWL (0n 0.0v 9.495n 0.0v 9.505n 3.3v 19.495n 3.3v 19.505n 0.0v 29.495n 0.0v 29.505n 0.0v 39.495n 0.0v 39.505n 0.0v 49.495n 0.0v 49.505n 0.0v 59.495n 0.0v 59.505n 0.0v 69.495n 0.0v 69.505n 0.0v 79.495n 0.0v 79.505n 0.0v 89.495n 0.0v 89.505n 0.0v 99.495n 0.0v 99.505n 0.0v 109.495n 0.0v 109.505n 0.0v 119.495n 0.0v 119.505n 3.3v 129.495n 3.3v 129.505n 3.3v 139.495n 3.3v 139.505n 3.3v 149.495n 3.3v 149.505n 3.3v 159.495n 3.3v 159.505n 3.3v 169.495n 3.3v 169.505n 3.3v 179.495n 3.3v 179.505n 3.3v 189.495n 3.3v 189.505n 0.0v 199.495n 0.0v 199.505n 3.3v 209.495n 3.3v 209.505n 3.3v 219.495n 3.3v 219.505n 3.3v 229.495n 3.3v 229.505n 3.3v 239.495n 3.3v 239.505n 0.0v 249.495n 0.0v 249.505n 3.3v 259.495n 3.3v 259.505n 3.3v 269.495n 3.3v 269.505n 0.0v 279.495n 0.0v 279.505n 0.0v 289.495n 0.0v 289.505n 0.0v 299.495n 0.0v 299.505n 0.0v 309.495n 0.0v 309.505n 0.0v 319.495n 0.0v 319.505n 3.3v 329.495n 3.3v 329.505n 3.3v 339.495n 3.3v 339.505n 3.3v 349.495n 3.3v 349.505n 3.3v 359.495n 3.3v 359.505n 3.3v 369.495n 3.3v 369.505n 3.3v 379.495n 3.3v 379.505n 3.3v 389.495n 3.3v 389.505n 3.3v 399.495n 3.3v 399.505n 3.3v 409.495n 3.3v 409.505n 3.3v 419.495n 3.3v 419.505n 3.3v 429.495n 3.3v 429.505n 3.3v 439.495n 3.3v 439.505n 3.3v 449.495n 3.3v 449.505n 0.0v 459.495n 0.0v 459.505n 0.0v 469.495n 0.0v 469.505n 0.0v 479.495n 0.0v 479.505n 0.0v 489.495n 0.0v 489.505n 3.3v 499.495n 3.3v 499.505n 3.3v 509.495n 3.3v 509.505n 3.3v 519.495n 3.3v 519.505n 3.3v 529.495n 3.3v 529.505n 3.3v 539.495n 3.3v 539.505n 3.3v 549.495n 3.3v 549.505n 0.0v 559.495n 0.0v 559.505n 0.0v 569.495n 0.0v 569.505n 3.3v 579.495n 3.3v 579.505n 3.3v 589.495n 3.3v 589.505n 3.3v 599.495n 3.3v 599.505n 3.3v 609.495n 3.3v 609.505n 3.3v 619.495n 3.3v 619.505n 3.3v 629.495n 3.3v 629.505n 3.3v 639.495n 3.3v 639.505n 3.3v 649.495n 3.3v 649.505n 3.3v 659.495n 3.3v 659.505n 3.3v 669.495n 3.3v 669.505n 0.0v 679.495n 0.0v 679.505n 0.0v 689.495n 0.0v 689.505n 0.0v 699.495n 0.0v 699.505n 0.0v 709.495n 0.0v 709.505n 0.0v 719.495n 0.0v 719.505n 0.0v 729.495n 0.0v 729.505n 0.0v 739.495n 0.0v 739.505n 0.0v 749.495n 0.0v 749.505n 0.0v 759.495n 0.0v 759.505n 0.0v 769.495n 0.0v 769.505n 0.0v 779.495n 0.0v 779.505n 0.0v 789.495n 0.0v 789.505n 0.0v 799.495n 0.0v 799.505n 0.0v 809.495n 0.0v 809.505n 0.0v 819.495n 0.0v 819.505n 0.0v 829.495n 0.0v 829.505n 0.0v 839.495n 0.0v 839.505n 0.0v 849.495n 0.0v 849.505n 0.0v 859.495n 0.0v 859.505n 0.0v 869.495n 0.0v 869.505n 0.0v 879.495n 0.0v 879.505n 0.0v 889.495n 0.0v 889.505n 0.0v 899.495n 0.0v 899.505n 0.0v 909.495n 0.0v 909.505n 0.0v 919.495n 0.0v 919.505n 3.3v 929.495n 3.3v 929.505n 3.3v 939.495n 3.3v 939.505n 3.3v 949.495n 3.3v 949.505n 3.3v 959.495n 3.3v 959.505n 3.3v 969.495n 3.3v 969.505n 3.3v 979.495n 3.3v 979.505n 3.3v 989.495n 3.3v 989.505n 3.3v 999.495n 3.3v 999.505n 3.3v 1009.495n 3.3v 1009.505n 3.3v 1019.495n 3.3v 1019.505n 3.3v 1029.495n 3.3v 1029.505n 0.0v 1039.495n 0.0v 1039.505n 3.3v 1049.495n 3.3v 1049.505n 3.3v 1059.495n 3.3v 1059.505n 3.3v 1069.495n 3.3v 1069.505n 3.3v 1079.495n 3.3v 1079.505n 3.3v 1089.495n 3.3v 1089.505n 3.3v 1099.495n 3.3v 1099.505n 3.3v 1109.495n 3.3v 1109.505n 3.3v 1119.495n 3.3v 1119.505n 3.3v 1129.495n 3.3v 1129.505n 3.3v 1139.495n 3.3v 1139.505n 3.3v 1149.495n 3.3v 1149.505n 3.3v 1159.495n 3.3v 1159.505n 3.3v 1169.495n 3.3v 1169.505n 3.3v 1179.495n 3.3v 1179.505n 0.0v 1189.495n 0.0v 1189.505n 0.0v 1199.495n 0.0v 1199.505n 0.0v 1209.495n 0.0v 1209.505n 0.0v 1219.495n 0.0v 1219.505n 0.0v 1229.495n 0.0v 1229.505n 0.0v 1239.495n 0.0v 1239.505n 0.0v 1249.495n 0.0v 1249.505n 0.0v 1259.495n 0.0v 1259.505n 3.3v 1269.495n 3.3v 1269.505n 3.3v 1279.495n 3.3v 1279.505n 3.3v 1289.495n 3.3v 1289.505n 3.3v 1299.495n 3.3v 1299.505n 3.3v 1309.495n 3.3v 1309.505n 3.3v 1319.495n 3.3v 1319.505n 3.3v 1329.495n 3.3v 1329.505n 3.3v 1339.495n 3.3v 1339.505n 3.3v 1349.495n 3.3v 1349.505n 3.3v 1359.495n 3.3v 1359.505n 3.3v 1369.495n 3.3v 1369.505n 0.0v 1379.495n 0.0v 1379.505n 0.0v 1389.495n 0.0v 1389.505n 0.0v 1399.495n 0.0v 1399.505n 0.0v 1409.495n 0.0v 1409.505n 0.0v 1419.495n 0.0v 1419.505n 0.0v 1429.495n 0.0v 1429.505n 0.0v 1439.495n 0.0v 1439.505n 0.0v 1449.495n 0.0v 1449.505n 0.0v 1459.495n 0.0v 1459.505n 3.3v 1469.495n 3.3v 1469.505n 3.3v 1479.495n 3.3v 1479.505n 3.3v 1489.495n 3.3v 1489.505n 3.3v 1499.495n 3.3v 1499.505n 0.0v 1509.495n 0.0v 1509.505n 3.3v 1519.495n 3.3v 1519.505n 3.3v 1529.495n 3.3v 1529.505n 3.3v 1539.495n 3.3v 1539.505n 3.3v 1549.495n 3.3v 1549.505n 3.3v 1559.495n 3.3v 1559.505n 3.3v 1569.495n 3.3v 1569.505n 3.3v 1579.495n 3.3v 1579.505n 3.3v 1589.495n 3.3v 1589.505n 3.3v 1599.495n 3.3v 1599.505n 3.3v 1609.495n 3.3v 1609.505n 3.3v 1619.495n 3.3v 1619.505n 0.0v 1629.495n 0.0v 1629.505n 0.0v 1639.495n 0.0v 1639.505n 0.0v 1649.495n 0.0v 1649.505n 0.0v 1659.495n 0.0v 1659.505n 3.3v 1669.495n 3.3v 1669.505n 3.3v 1679.495n 3.3v 1679.505n 3.3v 1689.495n 3.3v 1689.505n 3.3v 1699.495n 3.3v 1699.505n 0.0v 1709.495n 0.0v 1709.505n 3.3v 1719.495n 3.3v 1719.505n 0.0v 1729.495n 0.0v 1729.505n 0.0v 1739.495n 0.0v 1739.505n 0.0v 1749.495n 0.0v 1749.505n 0.0v 1759.495n 0.0v 1759.505n 0.0v 1769.495n 0.0v 1769.505n 0.0v 1779.495n 0.0v 1779.505n 0.0v 1789.495n 0.0v 1789.505n 0.0v 1799.495n 0.0v 1799.505n 0.0v 1809.495n 0.0v 1809.505n 0.0v 1819.495n 0.0v 1819.505n 0.0v 1829.495n 0.0v 1829.505n 0.0v 1839.495n 0.0v 1839.505n 3.3v 1849.495n 3.3v 1849.505n 3.3v 1859.495n 3.3v 1859.505n 3.3v 1869.495n 3.3v 1869.505n 3.3v 1879.495n 3.3v 1879.505n 0.0v 1889.495n 0.0v 1889.505n 3.3v 1899.495n 3.3v 1899.505n 3.3v 1909.495n 3.3v 1909.505n 3.3v 1919.495n 3.3v 1919.505n 3.3v 1929.495n 3.3v 1929.505n 0.0v 1939.495n 0.0v 1939.505n 0.0v 1949.495n 0.0v 1949.505n 0.0v 1959.495n 0.0v 1959.505n 0.0v 1969.495n 0.0v 1969.505n 0.0v 1979.495n 0.0v 1979.505n 3.3v 1989.495n 3.3v 1989.505n 3.3v 1999.495n 3.3v 1999.505n 3.3v 2009.495n 3.3v 2009.505n 0.0v 2019.495n 0.0v 2019.505n 0.0v 2029.495n 0.0v 2029.505n 0.0v 2039.495n 0.0v 2039.505n 0.0v 2049.495n 0.0v 2049.505n 0.0v )
* (time, data): [(0, 0), (10, 1), (20, 1), (30, 1), (40, 1), (50, 1), (60, 1), (70, 1), (80, 1), (90, 1), (100, 1), (110, 1), (120, 1), (130, 1), (140, 0), (150, 0), (160, 0), (170, 1), (180, 1), (190, 0), (200, 0), (210, 0), (220, 1), (230, 1), (240, 1), (250, 1), (260, 1), (270, 0), (280, 0), (290, 0), (300, 0), (310, 1), (320, 0), (330, 0), (340, 0), (350, 0), (360, 0), (370, 0), (380, 0), (390, 0), (400, 0), (410, 0), (420, 0), (430, 1), (440, 1), (450, 0), (460, 0), (470, 0), (480, 0), (490, 1), (500, 1), (510, 0), (520, 1), (530, 1), (540, 1), (550, 0), (560, 0), (570, 0), (580, 0), (590, 0), (600, 0), (610, 0), (620, 0), (630, 0), (640, 0), (650, 0), (660, 0), (670, 1), (680, 1), (690, 1), (700, 1), (710, 1), (720, 1), (730, 1), (740, 1), (750, 1), (760, 1), (770, 1), (780, 1), (790, 1), (800, 1), (810, 1), (820, 1), (830, 1), (840, 0), (850, 0), (860, 0), (870, 0), (880, 0), (890, 1), (900, 1), (910, 1), (920, 0), (930, 1), (940, 1), (950, 1), (960, 1), (970, 1), (980, 0), (990, 0), (1000, 0), (1010, 0), (1020, 0), (1030, 0), (1040, 1), (1050, 1), (1060, 1), (1070, 1), (1080, 1), (1090, 1), (1100, 1), (1110, 1), (1120, 1), (1130, 1), (1140, 1), (1150, 1), (1160, 1), (1170, 1), (1180, 0), (1190, 0), (1200, 0), (1210, 0), (1220, 1), (1230, 1), (1240, 1), (1250, 1), (1260, 1), (1270, 1), (1280, 1), (1290, 1), (1300, 1), (1310, 1), (1320, 1), (1330, 1), (1340, 1), (1350, 1), (1360, 1), (1370, 1), (1380, 1), (1390, 1), (1400, 1), (1410, 1), (1420, 1), (1430, 1), (1440, 1), (1450, 1), (1460, 0), (1470, 0), (1480, 0), (1490, 0), (1500, 0), (1510, 0), (1520, 0), (1530, 1), (1540, 1), (1550, 1), (1560, 1), (1570, 1), (1580, 1), (1590, 1), (1600, 1), (1610, 1), (1620, 0), (1630, 0), (1640, 0), (1650, 0), (1660, 1), (1670, 1), (1680, 1), (1690, 1), (1700, 0), (1710, 0), (1720, 1), (1730, 1), (1740, 1), (1750, 1), (1760, 1), (1770, 1), (1780, 1), (1790, 1), (1800, 1), (1810, 1), (1820, 1), (1830, 1), (1840, 1), (1850, 1), (1860, 1), (1870, 1), (1880, 0), (1890, 0), (1900, 0), (1910, 0), (1920, 0), (1930, 0), (1940, 0), (1950, 0), (1960, 0), (1970, 0), (1980, 1), (1990, 1), (2000, 1), (2010, 1), (2020, 1), (2030, 1), (2040, 1), (2050, 1)]
Vdin0_25  din0_25  0 PWL (0n 0.0v 9.495n 0.0v 9.505n 3.3v 19.495n 3.3v 19.505n 3.3v 29.495n 3.3v 29.505n 3.3v 39.495n 3.3v 39.505n 3.3v 49.495n 3.3v 49.505n 3.3v 59.495n 3.3v 59.505n 3.3v 69.495n 3.3v 69.505n 3.3v 79.495n 3.3v 79.505n 3.3v 89.495n 3.3v 89.505n 3.3v 99.495n 3.3v 99.505n 3.3v 109.495n 3.3v 109.505n 3.3v 119.495n 3.3v 119.505n 3.3v 129.495n 3.3v 129.505n 3.3v 139.495n 3.3v 139.505n 0.0v 149.495n 0.0v 149.505n 0.0v 159.495n 0.0v 159.505n 0.0v 169.495n 0.0v 169.505n 3.3v 179.495n 3.3v 179.505n 3.3v 189.495n 3.3v 189.505n 0.0v 199.495n 0.0v 199.505n 0.0v 209.495n 0.0v 209.505n 0.0v 219.495n 0.0v 219.505n 3.3v 229.495n 3.3v 229.505n 3.3v 239.495n 3.3v 239.505n 3.3v 249.495n 3.3v 249.505n 3.3v 259.495n 3.3v 259.505n 3.3v 269.495n 3.3v 269.505n 0.0v 279.495n 0.0v 279.505n 0.0v 289.495n 0.0v 289.505n 0.0v 299.495n 0.0v 299.505n 0.0v 309.495n 0.0v 309.505n 3.3v 319.495n 3.3v 319.505n 0.0v 329.495n 0.0v 329.505n 0.0v 339.495n 0.0v 339.505n 0.0v 349.495n 0.0v 349.505n 0.0v 359.495n 0.0v 359.505n 0.0v 369.495n 0.0v 369.505n 0.0v 379.495n 0.0v 379.505n 0.0v 389.495n 0.0v 389.505n 0.0v 399.495n 0.0v 399.505n 0.0v 409.495n 0.0v 409.505n 0.0v 419.495n 0.0v 419.505n 0.0v 429.495n 0.0v 429.505n 3.3v 439.495n 3.3v 439.505n 3.3v 449.495n 3.3v 449.505n 0.0v 459.495n 0.0v 459.505n 0.0v 469.495n 0.0v 469.505n 0.0v 479.495n 0.0v 479.505n 0.0v 489.495n 0.0v 489.505n 3.3v 499.495n 3.3v 499.505n 3.3v 509.495n 3.3v 509.505n 0.0v 519.495n 0.0v 519.505n 3.3v 529.495n 3.3v 529.505n 3.3v 539.495n 3.3v 539.505n 3.3v 549.495n 3.3v 549.505n 0.0v 559.495n 0.0v 559.505n 0.0v 569.495n 0.0v 569.505n 0.0v 579.495n 0.0v 579.505n 0.0v 589.495n 0.0v 589.505n 0.0v 599.495n 0.0v 599.505n 0.0v 609.495n 0.0v 609.505n 0.0v 619.495n 0.0v 619.505n 0.0v 629.495n 0.0v 629.505n 0.0v 639.495n 0.0v 639.505n 0.0v 649.495n 0.0v 649.505n 0.0v 659.495n 0.0v 659.505n 0.0v 669.495n 0.0v 669.505n 3.3v 679.495n 3.3v 679.505n 3.3v 689.495n 3.3v 689.505n 3.3v 699.495n 3.3v 699.505n 3.3v 709.495n 3.3v 709.505n 3.3v 719.495n 3.3v 719.505n 3.3v 729.495n 3.3v 729.505n 3.3v 739.495n 3.3v 739.505n 3.3v 749.495n 3.3v 749.505n 3.3v 759.495n 3.3v 759.505n 3.3v 769.495n 3.3v 769.505n 3.3v 779.495n 3.3v 779.505n 3.3v 789.495n 3.3v 789.505n 3.3v 799.495n 3.3v 799.505n 3.3v 809.495n 3.3v 809.505n 3.3v 819.495n 3.3v 819.505n 3.3v 829.495n 3.3v 829.505n 3.3v 839.495n 3.3v 839.505n 0.0v 849.495n 0.0v 849.505n 0.0v 859.495n 0.0v 859.505n 0.0v 869.495n 0.0v 869.505n 0.0v 879.495n 0.0v 879.505n 0.0v 889.495n 0.0v 889.505n 3.3v 899.495n 3.3v 899.505n 3.3v 909.495n 3.3v 909.505n 3.3v 919.495n 3.3v 919.505n 0.0v 929.495n 0.0v 929.505n 3.3v 939.495n 3.3v 939.505n 3.3v 949.495n 3.3v 949.505n 3.3v 959.495n 3.3v 959.505n 3.3v 969.495n 3.3v 969.505n 3.3v 979.495n 3.3v 979.505n 0.0v 989.495n 0.0v 989.505n 0.0v 999.495n 0.0v 999.505n 0.0v 1009.495n 0.0v 1009.505n 0.0v 1019.495n 0.0v 1019.505n 0.0v 1029.495n 0.0v 1029.505n 0.0v 1039.495n 0.0v 1039.505n 3.3v 1049.495n 3.3v 1049.505n 3.3v 1059.495n 3.3v 1059.505n 3.3v 1069.495n 3.3v 1069.505n 3.3v 1079.495n 3.3v 1079.505n 3.3v 1089.495n 3.3v 1089.505n 3.3v 1099.495n 3.3v 1099.505n 3.3v 1109.495n 3.3v 1109.505n 3.3v 1119.495n 3.3v 1119.505n 3.3v 1129.495n 3.3v 1129.505n 3.3v 1139.495n 3.3v 1139.505n 3.3v 1149.495n 3.3v 1149.505n 3.3v 1159.495n 3.3v 1159.505n 3.3v 1169.495n 3.3v 1169.505n 3.3v 1179.495n 3.3v 1179.505n 0.0v 1189.495n 0.0v 1189.505n 0.0v 1199.495n 0.0v 1199.505n 0.0v 1209.495n 0.0v 1209.505n 0.0v 1219.495n 0.0v 1219.505n 3.3v 1229.495n 3.3v 1229.505n 3.3v 1239.495n 3.3v 1239.505n 3.3v 1249.495n 3.3v 1249.505n 3.3v 1259.495n 3.3v 1259.505n 3.3v 1269.495n 3.3v 1269.505n 3.3v 1279.495n 3.3v 1279.505n 3.3v 1289.495n 3.3v 1289.505n 3.3v 1299.495n 3.3v 1299.505n 3.3v 1309.495n 3.3v 1309.505n 3.3v 1319.495n 3.3v 1319.505n 3.3v 1329.495n 3.3v 1329.505n 3.3v 1339.495n 3.3v 1339.505n 3.3v 1349.495n 3.3v 1349.505n 3.3v 1359.495n 3.3v 1359.505n 3.3v 1369.495n 3.3v 1369.505n 3.3v 1379.495n 3.3v 1379.505n 3.3v 1389.495n 3.3v 1389.505n 3.3v 1399.495n 3.3v 1399.505n 3.3v 1409.495n 3.3v 1409.505n 3.3v 1419.495n 3.3v 1419.505n 3.3v 1429.495n 3.3v 1429.505n 3.3v 1439.495n 3.3v 1439.505n 3.3v 1449.495n 3.3v 1449.505n 3.3v 1459.495n 3.3v 1459.505n 0.0v 1469.495n 0.0v 1469.505n 0.0v 1479.495n 0.0v 1479.505n 0.0v 1489.495n 0.0v 1489.505n 0.0v 1499.495n 0.0v 1499.505n 0.0v 1509.495n 0.0v 1509.505n 0.0v 1519.495n 0.0v 1519.505n 0.0v 1529.495n 0.0v 1529.505n 3.3v 1539.495n 3.3v 1539.505n 3.3v 1549.495n 3.3v 1549.505n 3.3v 1559.495n 3.3v 1559.505n 3.3v 1569.495n 3.3v 1569.505n 3.3v 1579.495n 3.3v 1579.505n 3.3v 1589.495n 3.3v 1589.505n 3.3v 1599.495n 3.3v 1599.505n 3.3v 1609.495n 3.3v 1609.505n 3.3v 1619.495n 3.3v 1619.505n 0.0v 1629.495n 0.0v 1629.505n 0.0v 1639.495n 0.0v 1639.505n 0.0v 1649.495n 0.0v 1649.505n 0.0v 1659.495n 0.0v 1659.505n 3.3v 1669.495n 3.3v 1669.505n 3.3v 1679.495n 3.3v 1679.505n 3.3v 1689.495n 3.3v 1689.505n 3.3v 1699.495n 3.3v 1699.505n 0.0v 1709.495n 0.0v 1709.505n 0.0v 1719.495n 0.0v 1719.505n 3.3v 1729.495n 3.3v 1729.505n 3.3v 1739.495n 3.3v 1739.505n 3.3v 1749.495n 3.3v 1749.505n 3.3v 1759.495n 3.3v 1759.505n 3.3v 1769.495n 3.3v 1769.505n 3.3v 1779.495n 3.3v 1779.505n 3.3v 1789.495n 3.3v 1789.505n 3.3v 1799.495n 3.3v 1799.505n 3.3v 1809.495n 3.3v 1809.505n 3.3v 1819.495n 3.3v 1819.505n 3.3v 1829.495n 3.3v 1829.505n 3.3v 1839.495n 3.3v 1839.505n 3.3v 1849.495n 3.3v 1849.505n 3.3v 1859.495n 3.3v 1859.505n 3.3v 1869.495n 3.3v 1869.505n 3.3v 1879.495n 3.3v 1879.505n 0.0v 1889.495n 0.0v 1889.505n 0.0v 1899.495n 0.0v 1899.505n 0.0v 1909.495n 0.0v 1909.505n 0.0v 1919.495n 0.0v 1919.505n 0.0v 1929.495n 0.0v 1929.505n 0.0v 1939.495n 0.0v 1939.505n 0.0v 1949.495n 0.0v 1949.505n 0.0v 1959.495n 0.0v 1959.505n 0.0v 1969.495n 0.0v 1969.505n 0.0v 1979.495n 0.0v 1979.505n 3.3v 1989.495n 3.3v 1989.505n 3.3v 1999.495n 3.3v 1999.505n 3.3v 2009.495n 3.3v 2009.505n 3.3v 2019.495n 3.3v 2019.505n 3.3v 2029.495n 3.3v 2029.505n 3.3v 2039.495n 3.3v 2039.505n 3.3v 2049.495n 3.3v 2049.505n 3.3v )
* (time, data): [(0, 0), (10, 0), (20, 0), (30, 0), (40, 0), (50, 0), (60, 0), (70, 0), (80, 0), (90, 0), (100, 0), (110, 0), (120, 0), (130, 0), (140, 0), (150, 0), (160, 0), (170, 0), (180, 0), (190, 1), (200, 0), (210, 1), (220, 0), (230, 0), (240, 1), (250, 1), (260, 1), (270, 1), (280, 1), (290, 1), (300, 1), (310, 0), (320, 0), (330, 0), (340, 0), (350, 0), (360, 0), (370, 0), (380, 0), (390, 0), (400, 0), (410, 0), (420, 0), (430, 1), (440, 1), (450, 0), (460, 0), (470, 0), (480, 0), (490, 1), (500, 1), (510, 1), (520, 0), (530, 0), (540, 0), (550, 1), (560, 1), (570, 1), (580, 1), (590, 1), (600, 1), (610, 1), (620, 1), (630, 1), (640, 1), (650, 0), (660, 0), (670, 0), (680, 0), (690, 0), (700, 0), (710, 0), (720, 0), (730, 0), (740, 0), (750, 0), (760, 0), (770, 0), (780, 0), (790, 0), (800, 0), (810, 0), (820, 0), (830, 0), (840, 1), (850, 1), (860, 1), (870, 1), (880, 0), (890, 0), (900, 0), (910, 0), (920, 1), (930, 1), (940, 1), (950, 1), (960, 1), (970, 1), (980, 0), (990, 0), (1000, 0), (1010, 0), (1020, 0), (1030, 0), (1040, 1), (1050, 1), (1060, 1), (1070, 1), (1080, 1), (1090, 1), (1100, 1), (1110, 0), (1120, 0), (1130, 0), (1140, 0), (1150, 0), (1160, 0), (1170, 0), (1180, 0), (1190, 0), (1200, 0), (1210, 0), (1220, 1), (1230, 1), (1240, 1), (1250, 1), (1260, 1), (1270, 1), (1280, 1), (1290, 1), (1300, 1), (1310, 1), (1320, 1), (1330, 1), (1340, 1), (1350, 1), (1360, 0), (1370, 1), (1380, 1), (1390, 1), (1400, 1), (1410, 1), (1420, 1), (1430, 1), (1440, 1), (1450, 1), (1460, 1), (1470, 1), (1480, 1), (1490, 1), (1500, 1), (1510, 1), (1520, 1), (1530, 0), (1540, 0), (1550, 0), (1560, 0), (1570, 0), (1580, 0), (1590, 1), (1600, 1), (1610, 1), (1620, 1), (1630, 1), (1640, 1), (1650, 1), (1660, 0), (1670, 0), (1680, 0), (1690, 0), (1700, 0), (1710, 1), (1720, 0), (1730, 0), (1740, 0), (1750, 0), (1760, 0), (1770, 1), (1780, 1), (1790, 1), (1800, 1), (1810, 1), (1820, 1), (1830, 1), (1840, 1), (1850, 0), (1860, 0), (1870, 0), (1880, 1), (1890, 0), (1900, 0), (1910, 0), (1920, 0), (1930, 1), (1940, 1), (1950, 1), (1960, 1), (1970, 1), (1980, 0), (1990, 0), (2000, 0), (2010, 0), (2020, 0), (2030, 0), (2040, 0), (2050, 0)]
Vdin0_26  din0_26  0 PWL (0n 0.0v 9.495n 0.0v 9.505n 0.0v 19.495n 0.0v 19.505n 0.0v 29.495n 0.0v 29.505n 0.0v 39.495n 0.0v 39.505n 0.0v 49.495n 0.0v 49.505n 0.0v 59.495n 0.0v 59.505n 0.0v 69.495n 0.0v 69.505n 0.0v 79.495n 0.0v 79.505n 0.0v 89.495n 0.0v 89.505n 0.0v 99.495n 0.0v 99.505n 0.0v 109.495n 0.0v 109.505n 0.0v 119.495n 0.0v 119.505n 0.0v 129.495n 0.0v 129.505n 0.0v 139.495n 0.0v 139.505n 0.0v 149.495n 0.0v 149.505n 0.0v 159.495n 0.0v 159.505n 0.0v 169.495n 0.0v 169.505n 0.0v 179.495n 0.0v 179.505n 0.0v 189.495n 0.0v 189.505n 3.3v 199.495n 3.3v 199.505n 0.0v 209.495n 0.0v 209.505n 3.3v 219.495n 3.3v 219.505n 0.0v 229.495n 0.0v 229.505n 0.0v 239.495n 0.0v 239.505n 3.3v 249.495n 3.3v 249.505n 3.3v 259.495n 3.3v 259.505n 3.3v 269.495n 3.3v 269.505n 3.3v 279.495n 3.3v 279.505n 3.3v 289.495n 3.3v 289.505n 3.3v 299.495n 3.3v 299.505n 3.3v 309.495n 3.3v 309.505n 0.0v 319.495n 0.0v 319.505n 0.0v 329.495n 0.0v 329.505n 0.0v 339.495n 0.0v 339.505n 0.0v 349.495n 0.0v 349.505n 0.0v 359.495n 0.0v 359.505n 0.0v 369.495n 0.0v 369.505n 0.0v 379.495n 0.0v 379.505n 0.0v 389.495n 0.0v 389.505n 0.0v 399.495n 0.0v 399.505n 0.0v 409.495n 0.0v 409.505n 0.0v 419.495n 0.0v 419.505n 0.0v 429.495n 0.0v 429.505n 3.3v 439.495n 3.3v 439.505n 3.3v 449.495n 3.3v 449.505n 0.0v 459.495n 0.0v 459.505n 0.0v 469.495n 0.0v 469.505n 0.0v 479.495n 0.0v 479.505n 0.0v 489.495n 0.0v 489.505n 3.3v 499.495n 3.3v 499.505n 3.3v 509.495n 3.3v 509.505n 3.3v 519.495n 3.3v 519.505n 0.0v 529.495n 0.0v 529.505n 0.0v 539.495n 0.0v 539.505n 0.0v 549.495n 0.0v 549.505n 3.3v 559.495n 3.3v 559.505n 3.3v 569.495n 3.3v 569.505n 3.3v 579.495n 3.3v 579.505n 3.3v 589.495n 3.3v 589.505n 3.3v 599.495n 3.3v 599.505n 3.3v 609.495n 3.3v 609.505n 3.3v 619.495n 3.3v 619.505n 3.3v 629.495n 3.3v 629.505n 3.3v 639.495n 3.3v 639.505n 3.3v 649.495n 3.3v 649.505n 0.0v 659.495n 0.0v 659.505n 0.0v 669.495n 0.0v 669.505n 0.0v 679.495n 0.0v 679.505n 0.0v 689.495n 0.0v 689.505n 0.0v 699.495n 0.0v 699.505n 0.0v 709.495n 0.0v 709.505n 0.0v 719.495n 0.0v 719.505n 0.0v 729.495n 0.0v 729.505n 0.0v 739.495n 0.0v 739.505n 0.0v 749.495n 0.0v 749.505n 0.0v 759.495n 0.0v 759.505n 0.0v 769.495n 0.0v 769.505n 0.0v 779.495n 0.0v 779.505n 0.0v 789.495n 0.0v 789.505n 0.0v 799.495n 0.0v 799.505n 0.0v 809.495n 0.0v 809.505n 0.0v 819.495n 0.0v 819.505n 0.0v 829.495n 0.0v 829.505n 0.0v 839.495n 0.0v 839.505n 3.3v 849.495n 3.3v 849.505n 3.3v 859.495n 3.3v 859.505n 3.3v 869.495n 3.3v 869.505n 3.3v 879.495n 3.3v 879.505n 0.0v 889.495n 0.0v 889.505n 0.0v 899.495n 0.0v 899.505n 0.0v 909.495n 0.0v 909.505n 0.0v 919.495n 0.0v 919.505n 3.3v 929.495n 3.3v 929.505n 3.3v 939.495n 3.3v 939.505n 3.3v 949.495n 3.3v 949.505n 3.3v 959.495n 3.3v 959.505n 3.3v 969.495n 3.3v 969.505n 3.3v 979.495n 3.3v 979.505n 0.0v 989.495n 0.0v 989.505n 0.0v 999.495n 0.0v 999.505n 0.0v 1009.495n 0.0v 1009.505n 0.0v 1019.495n 0.0v 1019.505n 0.0v 1029.495n 0.0v 1029.505n 0.0v 1039.495n 0.0v 1039.505n 3.3v 1049.495n 3.3v 1049.505n 3.3v 1059.495n 3.3v 1059.505n 3.3v 1069.495n 3.3v 1069.505n 3.3v 1079.495n 3.3v 1079.505n 3.3v 1089.495n 3.3v 1089.505n 3.3v 1099.495n 3.3v 1099.505n 3.3v 1109.495n 3.3v 1109.505n 0.0v 1119.495n 0.0v 1119.505n 0.0v 1129.495n 0.0v 1129.505n 0.0v 1139.495n 0.0v 1139.505n 0.0v 1149.495n 0.0v 1149.505n 0.0v 1159.495n 0.0v 1159.505n 0.0v 1169.495n 0.0v 1169.505n 0.0v 1179.495n 0.0v 1179.505n 0.0v 1189.495n 0.0v 1189.505n 0.0v 1199.495n 0.0v 1199.505n 0.0v 1209.495n 0.0v 1209.505n 0.0v 1219.495n 0.0v 1219.505n 3.3v 1229.495n 3.3v 1229.505n 3.3v 1239.495n 3.3v 1239.505n 3.3v 1249.495n 3.3v 1249.505n 3.3v 1259.495n 3.3v 1259.505n 3.3v 1269.495n 3.3v 1269.505n 3.3v 1279.495n 3.3v 1279.505n 3.3v 1289.495n 3.3v 1289.505n 3.3v 1299.495n 3.3v 1299.505n 3.3v 1309.495n 3.3v 1309.505n 3.3v 1319.495n 3.3v 1319.505n 3.3v 1329.495n 3.3v 1329.505n 3.3v 1339.495n 3.3v 1339.505n 3.3v 1349.495n 3.3v 1349.505n 3.3v 1359.495n 3.3v 1359.505n 0.0v 1369.495n 0.0v 1369.505n 3.3v 1379.495n 3.3v 1379.505n 3.3v 1389.495n 3.3v 1389.505n 3.3v 1399.495n 3.3v 1399.505n 3.3v 1409.495n 3.3v 1409.505n 3.3v 1419.495n 3.3v 1419.505n 3.3v 1429.495n 3.3v 1429.505n 3.3v 1439.495n 3.3v 1439.505n 3.3v 1449.495n 3.3v 1449.505n 3.3v 1459.495n 3.3v 1459.505n 3.3v 1469.495n 3.3v 1469.505n 3.3v 1479.495n 3.3v 1479.505n 3.3v 1489.495n 3.3v 1489.505n 3.3v 1499.495n 3.3v 1499.505n 3.3v 1509.495n 3.3v 1509.505n 3.3v 1519.495n 3.3v 1519.505n 3.3v 1529.495n 3.3v 1529.505n 0.0v 1539.495n 0.0v 1539.505n 0.0v 1549.495n 0.0v 1549.505n 0.0v 1559.495n 0.0v 1559.505n 0.0v 1569.495n 0.0v 1569.505n 0.0v 1579.495n 0.0v 1579.505n 0.0v 1589.495n 0.0v 1589.505n 3.3v 1599.495n 3.3v 1599.505n 3.3v 1609.495n 3.3v 1609.505n 3.3v 1619.495n 3.3v 1619.505n 3.3v 1629.495n 3.3v 1629.505n 3.3v 1639.495n 3.3v 1639.505n 3.3v 1649.495n 3.3v 1649.505n 3.3v 1659.495n 3.3v 1659.505n 0.0v 1669.495n 0.0v 1669.505n 0.0v 1679.495n 0.0v 1679.505n 0.0v 1689.495n 0.0v 1689.505n 0.0v 1699.495n 0.0v 1699.505n 0.0v 1709.495n 0.0v 1709.505n 3.3v 1719.495n 3.3v 1719.505n 0.0v 1729.495n 0.0v 1729.505n 0.0v 1739.495n 0.0v 1739.505n 0.0v 1749.495n 0.0v 1749.505n 0.0v 1759.495n 0.0v 1759.505n 0.0v 1769.495n 0.0v 1769.505n 3.3v 1779.495n 3.3v 1779.505n 3.3v 1789.495n 3.3v 1789.505n 3.3v 1799.495n 3.3v 1799.505n 3.3v 1809.495n 3.3v 1809.505n 3.3v 1819.495n 3.3v 1819.505n 3.3v 1829.495n 3.3v 1829.505n 3.3v 1839.495n 3.3v 1839.505n 3.3v 1849.495n 3.3v 1849.505n 0.0v 1859.495n 0.0v 1859.505n 0.0v 1869.495n 0.0v 1869.505n 0.0v 1879.495n 0.0v 1879.505n 3.3v 1889.495n 3.3v 1889.505n 0.0v 1899.495n 0.0v 1899.505n 0.0v 1909.495n 0.0v 1909.505n 0.0v 1919.495n 0.0v 1919.505n 0.0v 1929.495n 0.0v 1929.505n 3.3v 1939.495n 3.3v 1939.505n 3.3v 1949.495n 3.3v 1949.505n 3.3v 1959.495n 3.3v 1959.505n 3.3v 1969.495n 3.3v 1969.505n 3.3v 1979.495n 3.3v 1979.505n 0.0v 1989.495n 0.0v 1989.505n 0.0v 1999.495n 0.0v 1999.505n 0.0v 2009.495n 0.0v 2009.505n 0.0v 2019.495n 0.0v 2019.505n 0.0v 2029.495n 0.0v 2029.505n 0.0v 2039.495n 0.0v 2039.505n 0.0v 2049.495n 0.0v 2049.505n 0.0v )
* (time, data): [(0, 0), (10, 1), (20, 0), (30, 1), (40, 1), (50, 1), (60, 1), (70, 1), (80, 1), (90, 1), (100, 1), (110, 1), (120, 1), (130, 1), (140, 0), (150, 1), (160, 1), (170, 0), (180, 1), (190, 1), (200, 0), (210, 1), (220, 0), (230, 0), (240, 1), (250, 1), (260, 1), (270, 1), (280, 1), (290, 1), (300, 1), (310, 1), (320, 0), (330, 0), (340, 0), (350, 0), (360, 0), (370, 0), (380, 0), (390, 0), (400, 0), (410, 0), (420, 0), (430, 0), (440, 0), (450, 1), (460, 1), (470, 1), (480, 1), (490, 0), (500, 1), (510, 1), (520, 1), (530, 1), (540, 1), (550, 1), (560, 1), (570, 1), (580, 1), (590, 1), (600, 1), (610, 1), (620, 1), (630, 1), (640, 1), (650, 1), (660, 1), (670, 0), (680, 0), (690, 0), (700, 0), (710, 0), (720, 0), (730, 0), (740, 0), (750, 0), (760, 0), (770, 0), (780, 0), (790, 0), (800, 0), (810, 0), (820, 0), (830, 0), (840, 1), (850, 1), (860, 1), (870, 1), (880, 0), (890, 1), (900, 1), (910, 1), (920, 0), (930, 0), (940, 0), (950, 1), (960, 1), (970, 1), (980, 1), (990, 1), (1000, 1), (1010, 1), (1020, 1), (1030, 0), (1040, 1), (1050, 1), (1060, 1), (1070, 1), (1080, 1), (1090, 1), (1100, 1), (1110, 0), (1120, 0), (1130, 0), (1140, 0), (1150, 0), (1160, 0), (1170, 0), (1180, 0), (1190, 0), (1200, 0), (1210, 0), (1220, 1), (1230, 1), (1240, 1), (1250, 1), (1260, 1), (1270, 1), (1280, 1), (1290, 1), (1300, 1), (1310, 1), (1320, 1), (1330, 1), (1340, 1), (1350, 1), (1360, 1), (1370, 0), (1380, 0), (1390, 0), (1400, 0), (1410, 0), (1420, 0), (1430, 0), (1440, 1), (1450, 1), (1460, 0), (1470, 0), (1480, 0), (1490, 0), (1500, 0), (1510, 1), (1520, 1), (1530, 0), (1540, 0), (1550, 0), (1560, 0), (1570, 0), (1580, 0), (1590, 0), (1600, 0), (1610, 0), (1620, 0), (1630, 0), (1640, 0), (1650, 0), (1660, 0), (1670, 0), (1680, 0), (1690, 0), (1700, 0), (1710, 1), (1720, 0), (1730, 0), (1740, 0), (1750, 0), (1760, 0), (1770, 1), (1780, 0), (1790, 0), (1800, 0), (1810, 0), (1820, 0), (1830, 0), (1840, 1), (1850, 1), (1860, 1), (1870, 1), (1880, 1), (1890, 1), (1900, 1), (1910, 1), (1920, 1), (1930, 1), (1940, 1), (1950, 1), (1960, 1), (1970, 1), (1980, 1), (1990, 1), (2000, 1), (2010, 1), (2020, 1), (2030, 1), (2040, 1), (2050, 1)]
Vdin0_27  din0_27  0 PWL (0n 0.0v 9.495n 0.0v 9.505n 3.3v 19.495n 3.3v 19.505n 0.0v 29.495n 0.0v 29.505n 3.3v 39.495n 3.3v 39.505n 3.3v 49.495n 3.3v 49.505n 3.3v 59.495n 3.3v 59.505n 3.3v 69.495n 3.3v 69.505n 3.3v 79.495n 3.3v 79.505n 3.3v 89.495n 3.3v 89.505n 3.3v 99.495n 3.3v 99.505n 3.3v 109.495n 3.3v 109.505n 3.3v 119.495n 3.3v 119.505n 3.3v 129.495n 3.3v 129.505n 3.3v 139.495n 3.3v 139.505n 0.0v 149.495n 0.0v 149.505n 3.3v 159.495n 3.3v 159.505n 3.3v 169.495n 3.3v 169.505n 0.0v 179.495n 0.0v 179.505n 3.3v 189.495n 3.3v 189.505n 3.3v 199.495n 3.3v 199.505n 0.0v 209.495n 0.0v 209.505n 3.3v 219.495n 3.3v 219.505n 0.0v 229.495n 0.0v 229.505n 0.0v 239.495n 0.0v 239.505n 3.3v 249.495n 3.3v 249.505n 3.3v 259.495n 3.3v 259.505n 3.3v 269.495n 3.3v 269.505n 3.3v 279.495n 3.3v 279.505n 3.3v 289.495n 3.3v 289.505n 3.3v 299.495n 3.3v 299.505n 3.3v 309.495n 3.3v 309.505n 3.3v 319.495n 3.3v 319.505n 0.0v 329.495n 0.0v 329.505n 0.0v 339.495n 0.0v 339.505n 0.0v 349.495n 0.0v 349.505n 0.0v 359.495n 0.0v 359.505n 0.0v 369.495n 0.0v 369.505n 0.0v 379.495n 0.0v 379.505n 0.0v 389.495n 0.0v 389.505n 0.0v 399.495n 0.0v 399.505n 0.0v 409.495n 0.0v 409.505n 0.0v 419.495n 0.0v 419.505n 0.0v 429.495n 0.0v 429.505n 0.0v 439.495n 0.0v 439.505n 0.0v 449.495n 0.0v 449.505n 3.3v 459.495n 3.3v 459.505n 3.3v 469.495n 3.3v 469.505n 3.3v 479.495n 3.3v 479.505n 3.3v 489.495n 3.3v 489.505n 0.0v 499.495n 0.0v 499.505n 3.3v 509.495n 3.3v 509.505n 3.3v 519.495n 3.3v 519.505n 3.3v 529.495n 3.3v 529.505n 3.3v 539.495n 3.3v 539.505n 3.3v 549.495n 3.3v 549.505n 3.3v 559.495n 3.3v 559.505n 3.3v 569.495n 3.3v 569.505n 3.3v 579.495n 3.3v 579.505n 3.3v 589.495n 3.3v 589.505n 3.3v 599.495n 3.3v 599.505n 3.3v 609.495n 3.3v 609.505n 3.3v 619.495n 3.3v 619.505n 3.3v 629.495n 3.3v 629.505n 3.3v 639.495n 3.3v 639.505n 3.3v 649.495n 3.3v 649.505n 3.3v 659.495n 3.3v 659.505n 3.3v 669.495n 3.3v 669.505n 0.0v 679.495n 0.0v 679.505n 0.0v 689.495n 0.0v 689.505n 0.0v 699.495n 0.0v 699.505n 0.0v 709.495n 0.0v 709.505n 0.0v 719.495n 0.0v 719.505n 0.0v 729.495n 0.0v 729.505n 0.0v 739.495n 0.0v 739.505n 0.0v 749.495n 0.0v 749.505n 0.0v 759.495n 0.0v 759.505n 0.0v 769.495n 0.0v 769.505n 0.0v 779.495n 0.0v 779.505n 0.0v 789.495n 0.0v 789.505n 0.0v 799.495n 0.0v 799.505n 0.0v 809.495n 0.0v 809.505n 0.0v 819.495n 0.0v 819.505n 0.0v 829.495n 0.0v 829.505n 0.0v 839.495n 0.0v 839.505n 3.3v 849.495n 3.3v 849.505n 3.3v 859.495n 3.3v 859.505n 3.3v 869.495n 3.3v 869.505n 3.3v 879.495n 3.3v 879.505n 0.0v 889.495n 0.0v 889.505n 3.3v 899.495n 3.3v 899.505n 3.3v 909.495n 3.3v 909.505n 3.3v 919.495n 3.3v 919.505n 0.0v 929.495n 0.0v 929.505n 0.0v 939.495n 0.0v 939.505n 0.0v 949.495n 0.0v 949.505n 3.3v 959.495n 3.3v 959.505n 3.3v 969.495n 3.3v 969.505n 3.3v 979.495n 3.3v 979.505n 3.3v 989.495n 3.3v 989.505n 3.3v 999.495n 3.3v 999.505n 3.3v 1009.495n 3.3v 1009.505n 3.3v 1019.495n 3.3v 1019.505n 3.3v 1029.495n 3.3v 1029.505n 0.0v 1039.495n 0.0v 1039.505n 3.3v 1049.495n 3.3v 1049.505n 3.3v 1059.495n 3.3v 1059.505n 3.3v 1069.495n 3.3v 1069.505n 3.3v 1079.495n 3.3v 1079.505n 3.3v 1089.495n 3.3v 1089.505n 3.3v 1099.495n 3.3v 1099.505n 3.3v 1109.495n 3.3v 1109.505n 0.0v 1119.495n 0.0v 1119.505n 0.0v 1129.495n 0.0v 1129.505n 0.0v 1139.495n 0.0v 1139.505n 0.0v 1149.495n 0.0v 1149.505n 0.0v 1159.495n 0.0v 1159.505n 0.0v 1169.495n 0.0v 1169.505n 0.0v 1179.495n 0.0v 1179.505n 0.0v 1189.495n 0.0v 1189.505n 0.0v 1199.495n 0.0v 1199.505n 0.0v 1209.495n 0.0v 1209.505n 0.0v 1219.495n 0.0v 1219.505n 3.3v 1229.495n 3.3v 1229.505n 3.3v 1239.495n 3.3v 1239.505n 3.3v 1249.495n 3.3v 1249.505n 3.3v 1259.495n 3.3v 1259.505n 3.3v 1269.495n 3.3v 1269.505n 3.3v 1279.495n 3.3v 1279.505n 3.3v 1289.495n 3.3v 1289.505n 3.3v 1299.495n 3.3v 1299.505n 3.3v 1309.495n 3.3v 1309.505n 3.3v 1319.495n 3.3v 1319.505n 3.3v 1329.495n 3.3v 1329.505n 3.3v 1339.495n 3.3v 1339.505n 3.3v 1349.495n 3.3v 1349.505n 3.3v 1359.495n 3.3v 1359.505n 3.3v 1369.495n 3.3v 1369.505n 0.0v 1379.495n 0.0v 1379.505n 0.0v 1389.495n 0.0v 1389.505n 0.0v 1399.495n 0.0v 1399.505n 0.0v 1409.495n 0.0v 1409.505n 0.0v 1419.495n 0.0v 1419.505n 0.0v 1429.495n 0.0v 1429.505n 0.0v 1439.495n 0.0v 1439.505n 3.3v 1449.495n 3.3v 1449.505n 3.3v 1459.495n 3.3v 1459.505n 0.0v 1469.495n 0.0v 1469.505n 0.0v 1479.495n 0.0v 1479.505n 0.0v 1489.495n 0.0v 1489.505n 0.0v 1499.495n 0.0v 1499.505n 0.0v 1509.495n 0.0v 1509.505n 3.3v 1519.495n 3.3v 1519.505n 3.3v 1529.495n 3.3v 1529.505n 0.0v 1539.495n 0.0v 1539.505n 0.0v 1549.495n 0.0v 1549.505n 0.0v 1559.495n 0.0v 1559.505n 0.0v 1569.495n 0.0v 1569.505n 0.0v 1579.495n 0.0v 1579.505n 0.0v 1589.495n 0.0v 1589.505n 0.0v 1599.495n 0.0v 1599.505n 0.0v 1609.495n 0.0v 1609.505n 0.0v 1619.495n 0.0v 1619.505n 0.0v 1629.495n 0.0v 1629.505n 0.0v 1639.495n 0.0v 1639.505n 0.0v 1649.495n 0.0v 1649.505n 0.0v 1659.495n 0.0v 1659.505n 0.0v 1669.495n 0.0v 1669.505n 0.0v 1679.495n 0.0v 1679.505n 0.0v 1689.495n 0.0v 1689.505n 0.0v 1699.495n 0.0v 1699.505n 0.0v 1709.495n 0.0v 1709.505n 3.3v 1719.495n 3.3v 1719.505n 0.0v 1729.495n 0.0v 1729.505n 0.0v 1739.495n 0.0v 1739.505n 0.0v 1749.495n 0.0v 1749.505n 0.0v 1759.495n 0.0v 1759.505n 0.0v 1769.495n 0.0v 1769.505n 3.3v 1779.495n 3.3v 1779.505n 0.0v 1789.495n 0.0v 1789.505n 0.0v 1799.495n 0.0v 1799.505n 0.0v 1809.495n 0.0v 1809.505n 0.0v 1819.495n 0.0v 1819.505n 0.0v 1829.495n 0.0v 1829.505n 0.0v 1839.495n 0.0v 1839.505n 3.3v 1849.495n 3.3v 1849.505n 3.3v 1859.495n 3.3v 1859.505n 3.3v 1869.495n 3.3v 1869.505n 3.3v 1879.495n 3.3v 1879.505n 3.3v 1889.495n 3.3v 1889.505n 3.3v 1899.495n 3.3v 1899.505n 3.3v 1909.495n 3.3v 1909.505n 3.3v 1919.495n 3.3v 1919.505n 3.3v 1929.495n 3.3v 1929.505n 3.3v 1939.495n 3.3v 1939.505n 3.3v 1949.495n 3.3v 1949.505n 3.3v 1959.495n 3.3v 1959.505n 3.3v 1969.495n 3.3v 1969.505n 3.3v 1979.495n 3.3v 1979.505n 3.3v 1989.495n 3.3v 1989.505n 3.3v 1999.495n 3.3v 1999.505n 3.3v 2009.495n 3.3v 2009.505n 3.3v 2019.495n 3.3v 2019.505n 3.3v 2029.495n 3.3v 2029.505n 3.3v 2039.495n 3.3v 2039.505n 3.3v 2049.495n 3.3v 2049.505n 3.3v )
* (time, data): [(0, 0), (10, 0), (20, 0), (30, 1), (40, 1), (50, 1), (60, 1), (70, 1), (80, 1), (90, 1), (100, 1), (110, 1), (120, 0), (130, 0), (140, 0), (150, 1), (160, 1), (170, 0), (180, 1), (190, 0), (200, 0), (210, 0), (220, 0), (230, 0), (240, 0), (250, 1), (260, 1), (270, 0), (280, 0), (290, 0), (300, 0), (310, 0), (320, 1), (330, 1), (340, 1), (350, 0), (360, 0), (370, 0), (380, 0), (390, 0), (400, 0), (410, 0), (420, 0), (430, 1), (440, 1), (450, 1), (460, 1), (470, 1), (480, 1), (490, 1), (500, 1), (510, 1), (520, 1), (530, 1), (540, 1), (550, 0), (560, 0), (570, 1), (580, 1), (590, 1), (600, 1), (610, 1), (620, 1), (630, 1), (640, 1), (650, 0), (660, 0), (670, 1), (680, 1), (690, 1), (700, 1), (710, 1), (720, 1), (730, 1), (740, 0), (750, 0), (760, 0), (770, 0), (780, 0), (790, 0), (800, 0), (810, 0), (820, 0), (830, 0), (840, 1), (850, 1), (860, 1), (870, 1), (880, 1), (890, 1), (900, 1), (910, 1), (920, 0), (930, 0), (940, 0), (950, 0), (960, 0), (970, 0), (980, 0), (990, 0), (1000, 0), (1010, 0), (1020, 0), (1030, 0), (1040, 1), (1050, 1), (1060, 1), (1070, 1), (1080, 1), (1090, 1), (1100, 1), (1110, 1), (1120, 1), (1130, 1), (1140, 1), (1150, 1), (1160, 1), (1170, 1), (1180, 0), (1190, 0), (1200, 0), (1210, 0), (1220, 1), (1230, 1), (1240, 1), (1250, 1), (1260, 0), (1270, 0), (1280, 0), (1290, 0), (1300, 0), (1310, 0), (1320, 0), (1330, 0), (1340, 0), (1350, 0), (1360, 0), (1370, 1), (1380, 1), (1390, 1), (1400, 1), (1410, 1), (1420, 1), (1430, 1), (1440, 0), (1450, 0), (1460, 1), (1470, 1), (1480, 1), (1490, 1), (1500, 1), (1510, 1), (1520, 1), (1530, 0), (1540, 0), (1550, 0), (1560, 0), (1570, 0), (1580, 0), (1590, 0), (1600, 0), (1610, 0), (1620, 0), (1630, 0), (1640, 0), (1650, 0), (1660, 1), (1670, 1), (1680, 1), (1690, 1), (1700, 1), (1710, 1), (1720, 1), (1730, 1), (1740, 1), (1750, 1), (1760, 1), (1770, 0), (1780, 1), (1790, 1), (1800, 1), (1810, 1), (1820, 1), (1830, 1), (1840, 1), (1850, 0), (1860, 0), (1870, 0), (1880, 0), (1890, 0), (1900, 0), (1910, 0), (1920, 0), (1930, 1), (1940, 1), (1950, 1), (1960, 1), (1970, 1), (1980, 1), (1990, 1), (2000, 1), (2010, 0), (2020, 0), (2030, 0), (2040, 0), (2050, 0)]
Vdin0_28  din0_28  0 PWL (0n 0.0v 9.495n 0.0v 9.505n 0.0v 19.495n 0.0v 19.505n 0.0v 29.495n 0.0v 29.505n 3.3v 39.495n 3.3v 39.505n 3.3v 49.495n 3.3v 49.505n 3.3v 59.495n 3.3v 59.505n 3.3v 69.495n 3.3v 69.505n 3.3v 79.495n 3.3v 79.505n 3.3v 89.495n 3.3v 89.505n 3.3v 99.495n 3.3v 99.505n 3.3v 109.495n 3.3v 109.505n 3.3v 119.495n 3.3v 119.505n 0.0v 129.495n 0.0v 129.505n 0.0v 139.495n 0.0v 139.505n 0.0v 149.495n 0.0v 149.505n 3.3v 159.495n 3.3v 159.505n 3.3v 169.495n 3.3v 169.505n 0.0v 179.495n 0.0v 179.505n 3.3v 189.495n 3.3v 189.505n 0.0v 199.495n 0.0v 199.505n 0.0v 209.495n 0.0v 209.505n 0.0v 219.495n 0.0v 219.505n 0.0v 229.495n 0.0v 229.505n 0.0v 239.495n 0.0v 239.505n 0.0v 249.495n 0.0v 249.505n 3.3v 259.495n 3.3v 259.505n 3.3v 269.495n 3.3v 269.505n 0.0v 279.495n 0.0v 279.505n 0.0v 289.495n 0.0v 289.505n 0.0v 299.495n 0.0v 299.505n 0.0v 309.495n 0.0v 309.505n 0.0v 319.495n 0.0v 319.505n 3.3v 329.495n 3.3v 329.505n 3.3v 339.495n 3.3v 339.505n 3.3v 349.495n 3.3v 349.505n 0.0v 359.495n 0.0v 359.505n 0.0v 369.495n 0.0v 369.505n 0.0v 379.495n 0.0v 379.505n 0.0v 389.495n 0.0v 389.505n 0.0v 399.495n 0.0v 399.505n 0.0v 409.495n 0.0v 409.505n 0.0v 419.495n 0.0v 419.505n 0.0v 429.495n 0.0v 429.505n 3.3v 439.495n 3.3v 439.505n 3.3v 449.495n 3.3v 449.505n 3.3v 459.495n 3.3v 459.505n 3.3v 469.495n 3.3v 469.505n 3.3v 479.495n 3.3v 479.505n 3.3v 489.495n 3.3v 489.505n 3.3v 499.495n 3.3v 499.505n 3.3v 509.495n 3.3v 509.505n 3.3v 519.495n 3.3v 519.505n 3.3v 529.495n 3.3v 529.505n 3.3v 539.495n 3.3v 539.505n 3.3v 549.495n 3.3v 549.505n 0.0v 559.495n 0.0v 559.505n 0.0v 569.495n 0.0v 569.505n 3.3v 579.495n 3.3v 579.505n 3.3v 589.495n 3.3v 589.505n 3.3v 599.495n 3.3v 599.505n 3.3v 609.495n 3.3v 609.505n 3.3v 619.495n 3.3v 619.505n 3.3v 629.495n 3.3v 629.505n 3.3v 639.495n 3.3v 639.505n 3.3v 649.495n 3.3v 649.505n 0.0v 659.495n 0.0v 659.505n 0.0v 669.495n 0.0v 669.505n 3.3v 679.495n 3.3v 679.505n 3.3v 689.495n 3.3v 689.505n 3.3v 699.495n 3.3v 699.505n 3.3v 709.495n 3.3v 709.505n 3.3v 719.495n 3.3v 719.505n 3.3v 729.495n 3.3v 729.505n 3.3v 739.495n 3.3v 739.505n 0.0v 749.495n 0.0v 749.505n 0.0v 759.495n 0.0v 759.505n 0.0v 769.495n 0.0v 769.505n 0.0v 779.495n 0.0v 779.505n 0.0v 789.495n 0.0v 789.505n 0.0v 799.495n 0.0v 799.505n 0.0v 809.495n 0.0v 809.505n 0.0v 819.495n 0.0v 819.505n 0.0v 829.495n 0.0v 829.505n 0.0v 839.495n 0.0v 839.505n 3.3v 849.495n 3.3v 849.505n 3.3v 859.495n 3.3v 859.505n 3.3v 869.495n 3.3v 869.505n 3.3v 879.495n 3.3v 879.505n 3.3v 889.495n 3.3v 889.505n 3.3v 899.495n 3.3v 899.505n 3.3v 909.495n 3.3v 909.505n 3.3v 919.495n 3.3v 919.505n 0.0v 929.495n 0.0v 929.505n 0.0v 939.495n 0.0v 939.505n 0.0v 949.495n 0.0v 949.505n 0.0v 959.495n 0.0v 959.505n 0.0v 969.495n 0.0v 969.505n 0.0v 979.495n 0.0v 979.505n 0.0v 989.495n 0.0v 989.505n 0.0v 999.495n 0.0v 999.505n 0.0v 1009.495n 0.0v 1009.505n 0.0v 1019.495n 0.0v 1019.505n 0.0v 1029.495n 0.0v 1029.505n 0.0v 1039.495n 0.0v 1039.505n 3.3v 1049.495n 3.3v 1049.505n 3.3v 1059.495n 3.3v 1059.505n 3.3v 1069.495n 3.3v 1069.505n 3.3v 1079.495n 3.3v 1079.505n 3.3v 1089.495n 3.3v 1089.505n 3.3v 1099.495n 3.3v 1099.505n 3.3v 1109.495n 3.3v 1109.505n 3.3v 1119.495n 3.3v 1119.505n 3.3v 1129.495n 3.3v 1129.505n 3.3v 1139.495n 3.3v 1139.505n 3.3v 1149.495n 3.3v 1149.505n 3.3v 1159.495n 3.3v 1159.505n 3.3v 1169.495n 3.3v 1169.505n 3.3v 1179.495n 3.3v 1179.505n 0.0v 1189.495n 0.0v 1189.505n 0.0v 1199.495n 0.0v 1199.505n 0.0v 1209.495n 0.0v 1209.505n 0.0v 1219.495n 0.0v 1219.505n 3.3v 1229.495n 3.3v 1229.505n 3.3v 1239.495n 3.3v 1239.505n 3.3v 1249.495n 3.3v 1249.505n 3.3v 1259.495n 3.3v 1259.505n 0.0v 1269.495n 0.0v 1269.505n 0.0v 1279.495n 0.0v 1279.505n 0.0v 1289.495n 0.0v 1289.505n 0.0v 1299.495n 0.0v 1299.505n 0.0v 1309.495n 0.0v 1309.505n 0.0v 1319.495n 0.0v 1319.505n 0.0v 1329.495n 0.0v 1329.505n 0.0v 1339.495n 0.0v 1339.505n 0.0v 1349.495n 0.0v 1349.505n 0.0v 1359.495n 0.0v 1359.505n 0.0v 1369.495n 0.0v 1369.505n 3.3v 1379.495n 3.3v 1379.505n 3.3v 1389.495n 3.3v 1389.505n 3.3v 1399.495n 3.3v 1399.505n 3.3v 1409.495n 3.3v 1409.505n 3.3v 1419.495n 3.3v 1419.505n 3.3v 1429.495n 3.3v 1429.505n 3.3v 1439.495n 3.3v 1439.505n 0.0v 1449.495n 0.0v 1449.505n 0.0v 1459.495n 0.0v 1459.505n 3.3v 1469.495n 3.3v 1469.505n 3.3v 1479.495n 3.3v 1479.505n 3.3v 1489.495n 3.3v 1489.505n 3.3v 1499.495n 3.3v 1499.505n 3.3v 1509.495n 3.3v 1509.505n 3.3v 1519.495n 3.3v 1519.505n 3.3v 1529.495n 3.3v 1529.505n 0.0v 1539.495n 0.0v 1539.505n 0.0v 1549.495n 0.0v 1549.505n 0.0v 1559.495n 0.0v 1559.505n 0.0v 1569.495n 0.0v 1569.505n 0.0v 1579.495n 0.0v 1579.505n 0.0v 1589.495n 0.0v 1589.505n 0.0v 1599.495n 0.0v 1599.505n 0.0v 1609.495n 0.0v 1609.505n 0.0v 1619.495n 0.0v 1619.505n 0.0v 1629.495n 0.0v 1629.505n 0.0v 1639.495n 0.0v 1639.505n 0.0v 1649.495n 0.0v 1649.505n 0.0v 1659.495n 0.0v 1659.505n 3.3v 1669.495n 3.3v 1669.505n 3.3v 1679.495n 3.3v 1679.505n 3.3v 1689.495n 3.3v 1689.505n 3.3v 1699.495n 3.3v 1699.505n 3.3v 1709.495n 3.3v 1709.505n 3.3v 1719.495n 3.3v 1719.505n 3.3v 1729.495n 3.3v 1729.505n 3.3v 1739.495n 3.3v 1739.505n 3.3v 1749.495n 3.3v 1749.505n 3.3v 1759.495n 3.3v 1759.505n 3.3v 1769.495n 3.3v 1769.505n 0.0v 1779.495n 0.0v 1779.505n 3.3v 1789.495n 3.3v 1789.505n 3.3v 1799.495n 3.3v 1799.505n 3.3v 1809.495n 3.3v 1809.505n 3.3v 1819.495n 3.3v 1819.505n 3.3v 1829.495n 3.3v 1829.505n 3.3v 1839.495n 3.3v 1839.505n 3.3v 1849.495n 3.3v 1849.505n 0.0v 1859.495n 0.0v 1859.505n 0.0v 1869.495n 0.0v 1869.505n 0.0v 1879.495n 0.0v 1879.505n 0.0v 1889.495n 0.0v 1889.505n 0.0v 1899.495n 0.0v 1899.505n 0.0v 1909.495n 0.0v 1909.505n 0.0v 1919.495n 0.0v 1919.505n 0.0v 1929.495n 0.0v 1929.505n 3.3v 1939.495n 3.3v 1939.505n 3.3v 1949.495n 3.3v 1949.505n 3.3v 1959.495n 3.3v 1959.505n 3.3v 1969.495n 3.3v 1969.505n 3.3v 1979.495n 3.3v 1979.505n 3.3v 1989.495n 3.3v 1989.505n 3.3v 1999.495n 3.3v 1999.505n 3.3v 2009.495n 3.3v 2009.505n 0.0v 2019.495n 0.0v 2019.505n 0.0v 2029.495n 0.0v 2029.505n 0.0v 2039.495n 0.0v 2039.505n 0.0v 2049.495n 0.0v 2049.505n 0.0v )
* (time, data): [(0, 0), (10, 1), (20, 0), (30, 0), (40, 0), (50, 0), (60, 0), (70, 0), (80, 0), (90, 0), (100, 0), (110, 0), (120, 1), (130, 1), (140, 1), (150, 0), (160, 0), (170, 0), (180, 1), (190, 1), (200, 1), (210, 1), (220, 1), (230, 1), (240, 0), (250, 1), (260, 1), (270, 0), (280, 0), (290, 0), (300, 0), (310, 1), (320, 1), (330, 1), (340, 1), (350, 1), (360, 1), (370, 1), (380, 1), (390, 1), (400, 1), (410, 1), (420, 1), (430, 1), (440, 1), (450, 0), (460, 0), (470, 0), (480, 0), (490, 1), (500, 0), (510, 0), (520, 0), (530, 0), (540, 0), (550, 1), (560, 0), (570, 0), (580, 0), (590, 0), (600, 0), (610, 0), (620, 0), (630, 0), (640, 0), (650, 0), (660, 0), (670, 1), (680, 1), (690, 1), (700, 1), (710, 1), (720, 1), (730, 1), (740, 1), (750, 1), (760, 1), (770, 1), (780, 1), (790, 1), (800, 1), (810, 1), (820, 1), (830, 1), (840, 0), (850, 0), (860, 0), (870, 0), (880, 0), (890, 1), (900, 1), (910, 1), (920, 0), (930, 0), (940, 0), (950, 0), (960, 0), (970, 0), (980, 0), (990, 0), (1000, 0), (1010, 0), (1020, 0), (1030, 0), (1040, 1), (1050, 1), (1060, 1), (1070, 1), (1080, 1), (1090, 1), (1100, 1), (1110, 0), (1120, 0), (1130, 0), (1140, 0), (1150, 0), (1160, 0), (1170, 0), (1180, 0), (1190, 0), (1200, 0), (1210, 0), (1220, 0), (1230, 0), (1240, 0), (1250, 0), (1260, 0), (1270, 0), (1280, 0), (1290, 0), (1300, 0), (1310, 0), (1320, 0), (1330, 0), (1340, 0), (1350, 0), (1360, 0), (1370, 0), (1380, 0), (1390, 0), (1400, 0), (1410, 0), (1420, 0), (1430, 0), (1440, 1), (1450, 1), (1460, 0), (1470, 0), (1480, 0), (1490, 0), (1500, 1), (1510, 0), (1520, 0), (1530, 0), (1540, 0), (1550, 0), (1560, 0), (1570, 0), (1580, 0), (1590, 1), (1600, 1), (1610, 1), (1620, 0), (1630, 0), (1640, 0), (1650, 0), (1660, 1), (1670, 1), (1680, 1), (1690, 1), (1700, 1), (1710, 1), (1720, 0), (1730, 0), (1740, 0), (1750, 0), (1760, 0), (1770, 1), (1780, 0), (1790, 0), (1800, 0), (1810, 0), (1820, 0), (1830, 0), (1840, 1), (1850, 1), (1860, 1), (1870, 1), (1880, 0), (1890, 1), (1900, 1), (1910, 1), (1920, 1), (1930, 1), (1940, 1), (1950, 1), (1960, 1), (1970, 1), (1980, 1), (1990, 1), (2000, 1), (2010, 0), (2020, 0), (2030, 0), (2040, 0), (2050, 0)]
Vdin0_29  din0_29  0 PWL (0n 0.0v 9.495n 0.0v 9.505n 3.3v 19.495n 3.3v 19.505n 0.0v 29.495n 0.0v 29.505n 0.0v 39.495n 0.0v 39.505n 0.0v 49.495n 0.0v 49.505n 0.0v 59.495n 0.0v 59.505n 0.0v 69.495n 0.0v 69.505n 0.0v 79.495n 0.0v 79.505n 0.0v 89.495n 0.0v 89.505n 0.0v 99.495n 0.0v 99.505n 0.0v 109.495n 0.0v 109.505n 0.0v 119.495n 0.0v 119.505n 3.3v 129.495n 3.3v 129.505n 3.3v 139.495n 3.3v 139.505n 3.3v 149.495n 3.3v 149.505n 0.0v 159.495n 0.0v 159.505n 0.0v 169.495n 0.0v 169.505n 0.0v 179.495n 0.0v 179.505n 3.3v 189.495n 3.3v 189.505n 3.3v 199.495n 3.3v 199.505n 3.3v 209.495n 3.3v 209.505n 3.3v 219.495n 3.3v 219.505n 3.3v 229.495n 3.3v 229.505n 3.3v 239.495n 3.3v 239.505n 0.0v 249.495n 0.0v 249.505n 3.3v 259.495n 3.3v 259.505n 3.3v 269.495n 3.3v 269.505n 0.0v 279.495n 0.0v 279.505n 0.0v 289.495n 0.0v 289.505n 0.0v 299.495n 0.0v 299.505n 0.0v 309.495n 0.0v 309.505n 3.3v 319.495n 3.3v 319.505n 3.3v 329.495n 3.3v 329.505n 3.3v 339.495n 3.3v 339.505n 3.3v 349.495n 3.3v 349.505n 3.3v 359.495n 3.3v 359.505n 3.3v 369.495n 3.3v 369.505n 3.3v 379.495n 3.3v 379.505n 3.3v 389.495n 3.3v 389.505n 3.3v 399.495n 3.3v 399.505n 3.3v 409.495n 3.3v 409.505n 3.3v 419.495n 3.3v 419.505n 3.3v 429.495n 3.3v 429.505n 3.3v 439.495n 3.3v 439.505n 3.3v 449.495n 3.3v 449.505n 0.0v 459.495n 0.0v 459.505n 0.0v 469.495n 0.0v 469.505n 0.0v 479.495n 0.0v 479.505n 0.0v 489.495n 0.0v 489.505n 3.3v 499.495n 3.3v 499.505n 0.0v 509.495n 0.0v 509.505n 0.0v 519.495n 0.0v 519.505n 0.0v 529.495n 0.0v 529.505n 0.0v 539.495n 0.0v 539.505n 0.0v 549.495n 0.0v 549.505n 3.3v 559.495n 3.3v 559.505n 0.0v 569.495n 0.0v 569.505n 0.0v 579.495n 0.0v 579.505n 0.0v 589.495n 0.0v 589.505n 0.0v 599.495n 0.0v 599.505n 0.0v 609.495n 0.0v 609.505n 0.0v 619.495n 0.0v 619.505n 0.0v 629.495n 0.0v 629.505n 0.0v 639.495n 0.0v 639.505n 0.0v 649.495n 0.0v 649.505n 0.0v 659.495n 0.0v 659.505n 0.0v 669.495n 0.0v 669.505n 3.3v 679.495n 3.3v 679.505n 3.3v 689.495n 3.3v 689.505n 3.3v 699.495n 3.3v 699.505n 3.3v 709.495n 3.3v 709.505n 3.3v 719.495n 3.3v 719.505n 3.3v 729.495n 3.3v 729.505n 3.3v 739.495n 3.3v 739.505n 3.3v 749.495n 3.3v 749.505n 3.3v 759.495n 3.3v 759.505n 3.3v 769.495n 3.3v 769.505n 3.3v 779.495n 3.3v 779.505n 3.3v 789.495n 3.3v 789.505n 3.3v 799.495n 3.3v 799.505n 3.3v 809.495n 3.3v 809.505n 3.3v 819.495n 3.3v 819.505n 3.3v 829.495n 3.3v 829.505n 3.3v 839.495n 3.3v 839.505n 0.0v 849.495n 0.0v 849.505n 0.0v 859.495n 0.0v 859.505n 0.0v 869.495n 0.0v 869.505n 0.0v 879.495n 0.0v 879.505n 0.0v 889.495n 0.0v 889.505n 3.3v 899.495n 3.3v 899.505n 3.3v 909.495n 3.3v 909.505n 3.3v 919.495n 3.3v 919.505n 0.0v 929.495n 0.0v 929.505n 0.0v 939.495n 0.0v 939.505n 0.0v 949.495n 0.0v 949.505n 0.0v 959.495n 0.0v 959.505n 0.0v 969.495n 0.0v 969.505n 0.0v 979.495n 0.0v 979.505n 0.0v 989.495n 0.0v 989.505n 0.0v 999.495n 0.0v 999.505n 0.0v 1009.495n 0.0v 1009.505n 0.0v 1019.495n 0.0v 1019.505n 0.0v 1029.495n 0.0v 1029.505n 0.0v 1039.495n 0.0v 1039.505n 3.3v 1049.495n 3.3v 1049.505n 3.3v 1059.495n 3.3v 1059.505n 3.3v 1069.495n 3.3v 1069.505n 3.3v 1079.495n 3.3v 1079.505n 3.3v 1089.495n 3.3v 1089.505n 3.3v 1099.495n 3.3v 1099.505n 3.3v 1109.495n 3.3v 1109.505n 0.0v 1119.495n 0.0v 1119.505n 0.0v 1129.495n 0.0v 1129.505n 0.0v 1139.495n 0.0v 1139.505n 0.0v 1149.495n 0.0v 1149.505n 0.0v 1159.495n 0.0v 1159.505n 0.0v 1169.495n 0.0v 1169.505n 0.0v 1179.495n 0.0v 1179.505n 0.0v 1189.495n 0.0v 1189.505n 0.0v 1199.495n 0.0v 1199.505n 0.0v 1209.495n 0.0v 1209.505n 0.0v 1219.495n 0.0v 1219.505n 0.0v 1229.495n 0.0v 1229.505n 0.0v 1239.495n 0.0v 1239.505n 0.0v 1249.495n 0.0v 1249.505n 0.0v 1259.495n 0.0v 1259.505n 0.0v 1269.495n 0.0v 1269.505n 0.0v 1279.495n 0.0v 1279.505n 0.0v 1289.495n 0.0v 1289.505n 0.0v 1299.495n 0.0v 1299.505n 0.0v 1309.495n 0.0v 1309.505n 0.0v 1319.495n 0.0v 1319.505n 0.0v 1329.495n 0.0v 1329.505n 0.0v 1339.495n 0.0v 1339.505n 0.0v 1349.495n 0.0v 1349.505n 0.0v 1359.495n 0.0v 1359.505n 0.0v 1369.495n 0.0v 1369.505n 0.0v 1379.495n 0.0v 1379.505n 0.0v 1389.495n 0.0v 1389.505n 0.0v 1399.495n 0.0v 1399.505n 0.0v 1409.495n 0.0v 1409.505n 0.0v 1419.495n 0.0v 1419.505n 0.0v 1429.495n 0.0v 1429.505n 0.0v 1439.495n 0.0v 1439.505n 3.3v 1449.495n 3.3v 1449.505n 3.3v 1459.495n 3.3v 1459.505n 0.0v 1469.495n 0.0v 1469.505n 0.0v 1479.495n 0.0v 1479.505n 0.0v 1489.495n 0.0v 1489.505n 0.0v 1499.495n 0.0v 1499.505n 3.3v 1509.495n 3.3v 1509.505n 0.0v 1519.495n 0.0v 1519.505n 0.0v 1529.495n 0.0v 1529.505n 0.0v 1539.495n 0.0v 1539.505n 0.0v 1549.495n 0.0v 1549.505n 0.0v 1559.495n 0.0v 1559.505n 0.0v 1569.495n 0.0v 1569.505n 0.0v 1579.495n 0.0v 1579.505n 0.0v 1589.495n 0.0v 1589.505n 3.3v 1599.495n 3.3v 1599.505n 3.3v 1609.495n 3.3v 1609.505n 3.3v 1619.495n 3.3v 1619.505n 0.0v 1629.495n 0.0v 1629.505n 0.0v 1639.495n 0.0v 1639.505n 0.0v 1649.495n 0.0v 1649.505n 0.0v 1659.495n 0.0v 1659.505n 3.3v 1669.495n 3.3v 1669.505n 3.3v 1679.495n 3.3v 1679.505n 3.3v 1689.495n 3.3v 1689.505n 3.3v 1699.495n 3.3v 1699.505n 3.3v 1709.495n 3.3v 1709.505n 3.3v 1719.495n 3.3v 1719.505n 0.0v 1729.495n 0.0v 1729.505n 0.0v 1739.495n 0.0v 1739.505n 0.0v 1749.495n 0.0v 1749.505n 0.0v 1759.495n 0.0v 1759.505n 0.0v 1769.495n 0.0v 1769.505n 3.3v 1779.495n 3.3v 1779.505n 0.0v 1789.495n 0.0v 1789.505n 0.0v 1799.495n 0.0v 1799.505n 0.0v 1809.495n 0.0v 1809.505n 0.0v 1819.495n 0.0v 1819.505n 0.0v 1829.495n 0.0v 1829.505n 0.0v 1839.495n 0.0v 1839.505n 3.3v 1849.495n 3.3v 1849.505n 3.3v 1859.495n 3.3v 1859.505n 3.3v 1869.495n 3.3v 1869.505n 3.3v 1879.495n 3.3v 1879.505n 0.0v 1889.495n 0.0v 1889.505n 3.3v 1899.495n 3.3v 1899.505n 3.3v 1909.495n 3.3v 1909.505n 3.3v 1919.495n 3.3v 1919.505n 3.3v 1929.495n 3.3v 1929.505n 3.3v 1939.495n 3.3v 1939.505n 3.3v 1949.495n 3.3v 1949.505n 3.3v 1959.495n 3.3v 1959.505n 3.3v 1969.495n 3.3v 1969.505n 3.3v 1979.495n 3.3v 1979.505n 3.3v 1989.495n 3.3v 1989.505n 3.3v 1999.495n 3.3v 1999.505n 3.3v 2009.495n 3.3v 2009.505n 0.0v 2019.495n 0.0v 2019.505n 0.0v 2029.495n 0.0v 2029.505n 0.0v 2039.495n 0.0v 2039.505n 0.0v 2049.495n 0.0v 2049.505n 0.0v )
* (time, data): [(0, 0), (10, 1), (20, 0), (30, 1), (40, 1), (50, 1), (60, 1), (70, 1), (80, 1), (90, 1), (100, 1), (110, 1), (120, 0), (130, 0), (140, 0), (150, 1), (160, 1), (170, 0), (180, 0), (190, 0), (200, 0), (210, 1), (220, 0), (230, 0), (240, 1), (250, 0), (260, 0), (270, 1), (280, 1), (290, 1), (300, 1), (310, 0), (320, 0), (330, 0), (340, 0), (350, 1), (360, 1), (370, 1), (380, 1), (390, 1), (400, 1), (410, 1), (420, 0), (430, 0), (440, 0), (450, 0), (460, 0), (470, 0), (480, 0), (490, 1), (500, 1), (510, 1), (520, 0), (530, 0), (540, 0), (550, 1), (560, 0), (570, 1), (580, 1), (590, 1), (600, 1), (610, 1), (620, 1), (630, 1), (640, 1), (650, 0), (660, 0), (670, 0), (680, 0), (690, 0), (700, 0), (710, 0), (720, 0), (730, 0), (740, 1), (750, 1), (760, 1), (770, 1), (780, 1), (790, 1), (800, 1), (810, 1), (820, 1), (830, 1), (840, 0), (850, 0), (860, 0), (870, 0), (880, 1), (890, 0), (900, 0), (910, 0), (920, 0), (930, 1), (940, 1), (950, 1), (960, 1), (970, 1), (980, 0), (990, 0), (1000, 0), (1010, 0), (1020, 0), (1030, 1), (1040, 1), (1050, 1), (1060, 1), (1070, 1), (1080, 1), (1090, 1), (1100, 1), (1110, 0), (1120, 0), (1130, 0), (1140, 0), (1150, 0), (1160, 0), (1170, 0), (1180, 0), (1190, 0), (1200, 0), (1210, 0), (1220, 1), (1230, 1), (1240, 1), (1250, 1), (1260, 0), (1270, 0), (1280, 0), (1290, 0), (1300, 0), (1310, 0), (1320, 0), (1330, 0), (1340, 0), (1350, 0), (1360, 0), (1370, 1), (1380, 1), (1390, 1), (1400, 1), (1410, 1), (1420, 1), (1430, 1), (1440, 0), (1450, 0), (1460, 0), (1470, 0), (1480, 0), (1490, 0), (1500, 0), (1510, 1), (1520, 1), (1530, 0), (1540, 0), (1550, 0), (1560, 0), (1570, 0), (1580, 0), (1590, 0), (1600, 0), (1610, 0), (1620, 0), (1630, 0), (1640, 0), (1650, 0), (1660, 0), (1670, 0), (1680, 0), (1690, 0), (1700, 1), (1710, 1), (1720, 0), (1730, 0), (1740, 0), (1750, 0), (1760, 0), (1770, 0), (1780, 1), (1790, 1), (1800, 1), (1810, 1), (1820, 1), (1830, 1), (1840, 1), (1850, 1), (1860, 1), (1870, 1), (1880, 1), (1890, 0), (1900, 0), (1910, 0), (1920, 0), (1930, 1), (1940, 1), (1950, 1), (1960, 1), (1970, 1), (1980, 0), (1990, 0), (2000, 0), (2010, 1), (2020, 1), (2030, 1), (2040, 1), (2050, 1)]
Vdin0_30  din0_30  0 PWL (0n 0.0v 9.495n 0.0v 9.505n 3.3v 19.495n 3.3v 19.505n 0.0v 29.495n 0.0v 29.505n 3.3v 39.495n 3.3v 39.505n 3.3v 49.495n 3.3v 49.505n 3.3v 59.495n 3.3v 59.505n 3.3v 69.495n 3.3v 69.505n 3.3v 79.495n 3.3v 79.505n 3.3v 89.495n 3.3v 89.505n 3.3v 99.495n 3.3v 99.505n 3.3v 109.495n 3.3v 109.505n 3.3v 119.495n 3.3v 119.505n 0.0v 129.495n 0.0v 129.505n 0.0v 139.495n 0.0v 139.505n 0.0v 149.495n 0.0v 149.505n 3.3v 159.495n 3.3v 159.505n 3.3v 169.495n 3.3v 169.505n 0.0v 179.495n 0.0v 179.505n 0.0v 189.495n 0.0v 189.505n 0.0v 199.495n 0.0v 199.505n 0.0v 209.495n 0.0v 209.505n 3.3v 219.495n 3.3v 219.505n 0.0v 229.495n 0.0v 229.505n 0.0v 239.495n 0.0v 239.505n 3.3v 249.495n 3.3v 249.505n 0.0v 259.495n 0.0v 259.505n 0.0v 269.495n 0.0v 269.505n 3.3v 279.495n 3.3v 279.505n 3.3v 289.495n 3.3v 289.505n 3.3v 299.495n 3.3v 299.505n 3.3v 309.495n 3.3v 309.505n 0.0v 319.495n 0.0v 319.505n 0.0v 329.495n 0.0v 329.505n 0.0v 339.495n 0.0v 339.505n 0.0v 349.495n 0.0v 349.505n 3.3v 359.495n 3.3v 359.505n 3.3v 369.495n 3.3v 369.505n 3.3v 379.495n 3.3v 379.505n 3.3v 389.495n 3.3v 389.505n 3.3v 399.495n 3.3v 399.505n 3.3v 409.495n 3.3v 409.505n 3.3v 419.495n 3.3v 419.505n 0.0v 429.495n 0.0v 429.505n 0.0v 439.495n 0.0v 439.505n 0.0v 449.495n 0.0v 449.505n 0.0v 459.495n 0.0v 459.505n 0.0v 469.495n 0.0v 469.505n 0.0v 479.495n 0.0v 479.505n 0.0v 489.495n 0.0v 489.505n 3.3v 499.495n 3.3v 499.505n 3.3v 509.495n 3.3v 509.505n 3.3v 519.495n 3.3v 519.505n 0.0v 529.495n 0.0v 529.505n 0.0v 539.495n 0.0v 539.505n 0.0v 549.495n 0.0v 549.505n 3.3v 559.495n 3.3v 559.505n 0.0v 569.495n 0.0v 569.505n 3.3v 579.495n 3.3v 579.505n 3.3v 589.495n 3.3v 589.505n 3.3v 599.495n 3.3v 599.505n 3.3v 609.495n 3.3v 609.505n 3.3v 619.495n 3.3v 619.505n 3.3v 629.495n 3.3v 629.505n 3.3v 639.495n 3.3v 639.505n 3.3v 649.495n 3.3v 649.505n 0.0v 659.495n 0.0v 659.505n 0.0v 669.495n 0.0v 669.505n 0.0v 679.495n 0.0v 679.505n 0.0v 689.495n 0.0v 689.505n 0.0v 699.495n 0.0v 699.505n 0.0v 709.495n 0.0v 709.505n 0.0v 719.495n 0.0v 719.505n 0.0v 729.495n 0.0v 729.505n 0.0v 739.495n 0.0v 739.505n 3.3v 749.495n 3.3v 749.505n 3.3v 759.495n 3.3v 759.505n 3.3v 769.495n 3.3v 769.505n 3.3v 779.495n 3.3v 779.505n 3.3v 789.495n 3.3v 789.505n 3.3v 799.495n 3.3v 799.505n 3.3v 809.495n 3.3v 809.505n 3.3v 819.495n 3.3v 819.505n 3.3v 829.495n 3.3v 829.505n 3.3v 839.495n 3.3v 839.505n 0.0v 849.495n 0.0v 849.505n 0.0v 859.495n 0.0v 859.505n 0.0v 869.495n 0.0v 869.505n 0.0v 879.495n 0.0v 879.505n 3.3v 889.495n 3.3v 889.505n 0.0v 899.495n 0.0v 899.505n 0.0v 909.495n 0.0v 909.505n 0.0v 919.495n 0.0v 919.505n 0.0v 929.495n 0.0v 929.505n 3.3v 939.495n 3.3v 939.505n 3.3v 949.495n 3.3v 949.505n 3.3v 959.495n 3.3v 959.505n 3.3v 969.495n 3.3v 969.505n 3.3v 979.495n 3.3v 979.505n 0.0v 989.495n 0.0v 989.505n 0.0v 999.495n 0.0v 999.505n 0.0v 1009.495n 0.0v 1009.505n 0.0v 1019.495n 0.0v 1019.505n 0.0v 1029.495n 0.0v 1029.505n 3.3v 1039.495n 3.3v 1039.505n 3.3v 1049.495n 3.3v 1049.505n 3.3v 1059.495n 3.3v 1059.505n 3.3v 1069.495n 3.3v 1069.505n 3.3v 1079.495n 3.3v 1079.505n 3.3v 1089.495n 3.3v 1089.505n 3.3v 1099.495n 3.3v 1099.505n 3.3v 1109.495n 3.3v 1109.505n 0.0v 1119.495n 0.0v 1119.505n 0.0v 1129.495n 0.0v 1129.505n 0.0v 1139.495n 0.0v 1139.505n 0.0v 1149.495n 0.0v 1149.505n 0.0v 1159.495n 0.0v 1159.505n 0.0v 1169.495n 0.0v 1169.505n 0.0v 1179.495n 0.0v 1179.505n 0.0v 1189.495n 0.0v 1189.505n 0.0v 1199.495n 0.0v 1199.505n 0.0v 1209.495n 0.0v 1209.505n 0.0v 1219.495n 0.0v 1219.505n 3.3v 1229.495n 3.3v 1229.505n 3.3v 1239.495n 3.3v 1239.505n 3.3v 1249.495n 3.3v 1249.505n 3.3v 1259.495n 3.3v 1259.505n 0.0v 1269.495n 0.0v 1269.505n 0.0v 1279.495n 0.0v 1279.505n 0.0v 1289.495n 0.0v 1289.505n 0.0v 1299.495n 0.0v 1299.505n 0.0v 1309.495n 0.0v 1309.505n 0.0v 1319.495n 0.0v 1319.505n 0.0v 1329.495n 0.0v 1329.505n 0.0v 1339.495n 0.0v 1339.505n 0.0v 1349.495n 0.0v 1349.505n 0.0v 1359.495n 0.0v 1359.505n 0.0v 1369.495n 0.0v 1369.505n 3.3v 1379.495n 3.3v 1379.505n 3.3v 1389.495n 3.3v 1389.505n 3.3v 1399.495n 3.3v 1399.505n 3.3v 1409.495n 3.3v 1409.505n 3.3v 1419.495n 3.3v 1419.505n 3.3v 1429.495n 3.3v 1429.505n 3.3v 1439.495n 3.3v 1439.505n 0.0v 1449.495n 0.0v 1449.505n 0.0v 1459.495n 0.0v 1459.505n 0.0v 1469.495n 0.0v 1469.505n 0.0v 1479.495n 0.0v 1479.505n 0.0v 1489.495n 0.0v 1489.505n 0.0v 1499.495n 0.0v 1499.505n 0.0v 1509.495n 0.0v 1509.505n 3.3v 1519.495n 3.3v 1519.505n 3.3v 1529.495n 3.3v 1529.505n 0.0v 1539.495n 0.0v 1539.505n 0.0v 1549.495n 0.0v 1549.505n 0.0v 1559.495n 0.0v 1559.505n 0.0v 1569.495n 0.0v 1569.505n 0.0v 1579.495n 0.0v 1579.505n 0.0v 1589.495n 0.0v 1589.505n 0.0v 1599.495n 0.0v 1599.505n 0.0v 1609.495n 0.0v 1609.505n 0.0v 1619.495n 0.0v 1619.505n 0.0v 1629.495n 0.0v 1629.505n 0.0v 1639.495n 0.0v 1639.505n 0.0v 1649.495n 0.0v 1649.505n 0.0v 1659.495n 0.0v 1659.505n 0.0v 1669.495n 0.0v 1669.505n 0.0v 1679.495n 0.0v 1679.505n 0.0v 1689.495n 0.0v 1689.505n 0.0v 1699.495n 0.0v 1699.505n 3.3v 1709.495n 3.3v 1709.505n 3.3v 1719.495n 3.3v 1719.505n 0.0v 1729.495n 0.0v 1729.505n 0.0v 1739.495n 0.0v 1739.505n 0.0v 1749.495n 0.0v 1749.505n 0.0v 1759.495n 0.0v 1759.505n 0.0v 1769.495n 0.0v 1769.505n 0.0v 1779.495n 0.0v 1779.505n 3.3v 1789.495n 3.3v 1789.505n 3.3v 1799.495n 3.3v 1799.505n 3.3v 1809.495n 3.3v 1809.505n 3.3v 1819.495n 3.3v 1819.505n 3.3v 1829.495n 3.3v 1829.505n 3.3v 1839.495n 3.3v 1839.505n 3.3v 1849.495n 3.3v 1849.505n 3.3v 1859.495n 3.3v 1859.505n 3.3v 1869.495n 3.3v 1869.505n 3.3v 1879.495n 3.3v 1879.505n 3.3v 1889.495n 3.3v 1889.505n 0.0v 1899.495n 0.0v 1899.505n 0.0v 1909.495n 0.0v 1909.505n 0.0v 1919.495n 0.0v 1919.505n 0.0v 1929.495n 0.0v 1929.505n 3.3v 1939.495n 3.3v 1939.505n 3.3v 1949.495n 3.3v 1949.505n 3.3v 1959.495n 3.3v 1959.505n 3.3v 1969.495n 3.3v 1969.505n 3.3v 1979.495n 3.3v 1979.505n 0.0v 1989.495n 0.0v 1989.505n 0.0v 1999.495n 0.0v 1999.505n 0.0v 2009.495n 0.0v 2009.505n 3.3v 2019.495n 3.3v 2019.505n 3.3v 2029.495n 3.3v 2029.505n 3.3v 2039.495n 3.3v 2039.505n 3.3v 2049.495n 3.3v 2049.505n 3.3v )
* (time, data): [(0, 0), (10, 0), (20, 1), (30, 1), (40, 1), (50, 1), (60, 1), (70, 1), (80, 1), (90, 1), (100, 1), (110, 1), (120, 0), (130, 0), (140, 1), (150, 0), (160, 0), (170, 1), (180, 1), (190, 0), (200, 0), (210, 1), (220, 0), (230, 0), (240, 0), (250, 0), (260, 0), (270, 1), (280, 1), (290, 1), (300, 1), (310, 0), (320, 0), (330, 0), (340, 0), (350, 0), (360, 0), (370, 0), (380, 0), (390, 0), (400, 0), (410, 0), (420, 1), (430, 0), (440, 0), (450, 0), (460, 0), (470, 0), (480, 0), (490, 0), (500, 1), (510, 1), (520, 1), (530, 1), (540, 1), (550, 1), (560, 1), (570, 1), (580, 1), (590, 1), (600, 1), (610, 1), (620, 1), (630, 1), (640, 1), (650, 1), (660, 1), (670, 1), (680, 1), (690, 1), (700, 1), (710, 1), (720, 1), (730, 1), (740, 1), (750, 1), (760, 1), (770, 1), (780, 1), (790, 1), (800, 1), (810, 1), (820, 1), (830, 1), (840, 1), (850, 1), (860, 1), (870, 1), (880, 1), (890, 0), (900, 0), (910, 0), (920, 0), (930, 1), (940, 1), (950, 1), (960, 1), (970, 1), (980, 1), (990, 1), (1000, 1), (1010, 1), (1020, 1), (1030, 0), (1040, 0), (1050, 0), (1060, 0), (1070, 0), (1080, 0), (1090, 0), (1100, 0), (1110, 0), (1120, 0), (1130, 0), (1140, 0), (1150, 0), (1160, 0), (1170, 0), (1180, 0), (1190, 0), (1200, 0), (1210, 0), (1220, 0), (1230, 0), (1240, 0), (1250, 0), (1260, 1), (1270, 1), (1280, 1), (1290, 1), (1300, 1), (1310, 1), (1320, 1), (1330, 1), (1340, 1), (1350, 1), (1360, 1), (1370, 1), (1380, 1), (1390, 1), (1400, 1), (1410, 1), (1420, 1), (1430, 1), (1440, 0), (1450, 0), (1460, 1), (1470, 1), (1480, 1), (1490, 1), (1500, 1), (1510, 0), (1520, 0), (1530, 1), (1540, 1), (1550, 1), (1560, 1), (1570, 1), (1580, 1), (1590, 1), (1600, 1), (1610, 1), (1620, 0), (1630, 0), (1640, 0), (1650, 0), (1660, 1), (1670, 1), (1680, 1), (1690, 1), (1700, 0), (1710, 1), (1720, 0), (1730, 0), (1740, 0), (1750, 0), (1760, 0), (1770, 1), (1780, 1), (1790, 1), (1800, 1), (1810, 1), (1820, 1), (1830, 1), (1840, 1), (1850, 0), (1860, 0), (1870, 0), (1880, 1), (1890, 1), (1900, 1), (1910, 1), (1920, 1), (1930, 1), (1940, 1), (1950, 1), (1960, 1), (1970, 1), (1980, 0), (1990, 0), (2000, 0), (2010, 0), (2020, 0), (2030, 0), (2040, 0), (2050, 0)]
Vdin0_31  din0_31  0 PWL (0n 0.0v 9.495n 0.0v 9.505n 0.0v 19.495n 0.0v 19.505n 3.3v 29.495n 3.3v 29.505n 3.3v 39.495n 3.3v 39.505n 3.3v 49.495n 3.3v 49.505n 3.3v 59.495n 3.3v 59.505n 3.3v 69.495n 3.3v 69.505n 3.3v 79.495n 3.3v 79.505n 3.3v 89.495n 3.3v 89.505n 3.3v 99.495n 3.3v 99.505n 3.3v 109.495n 3.3v 109.505n 3.3v 119.495n 3.3v 119.505n 0.0v 129.495n 0.0v 129.505n 0.0v 139.495n 0.0v 139.505n 3.3v 149.495n 3.3v 149.505n 0.0v 159.495n 0.0v 159.505n 0.0v 169.495n 0.0v 169.505n 3.3v 179.495n 3.3v 179.505n 3.3v 189.495n 3.3v 189.505n 0.0v 199.495n 0.0v 199.505n 0.0v 209.495n 0.0v 209.505n 3.3v 219.495n 3.3v 219.505n 0.0v 229.495n 0.0v 229.505n 0.0v 239.495n 0.0v 239.505n 0.0v 249.495n 0.0v 249.505n 0.0v 259.495n 0.0v 259.505n 0.0v 269.495n 0.0v 269.505n 3.3v 279.495n 3.3v 279.505n 3.3v 289.495n 3.3v 289.505n 3.3v 299.495n 3.3v 299.505n 3.3v 309.495n 3.3v 309.505n 0.0v 319.495n 0.0v 319.505n 0.0v 329.495n 0.0v 329.505n 0.0v 339.495n 0.0v 339.505n 0.0v 349.495n 0.0v 349.505n 0.0v 359.495n 0.0v 359.505n 0.0v 369.495n 0.0v 369.505n 0.0v 379.495n 0.0v 379.505n 0.0v 389.495n 0.0v 389.505n 0.0v 399.495n 0.0v 399.505n 0.0v 409.495n 0.0v 409.505n 0.0v 419.495n 0.0v 419.505n 3.3v 429.495n 3.3v 429.505n 0.0v 439.495n 0.0v 439.505n 0.0v 449.495n 0.0v 449.505n 0.0v 459.495n 0.0v 459.505n 0.0v 469.495n 0.0v 469.505n 0.0v 479.495n 0.0v 479.505n 0.0v 489.495n 0.0v 489.505n 0.0v 499.495n 0.0v 499.505n 3.3v 509.495n 3.3v 509.505n 3.3v 519.495n 3.3v 519.505n 3.3v 529.495n 3.3v 529.505n 3.3v 539.495n 3.3v 539.505n 3.3v 549.495n 3.3v 549.505n 3.3v 559.495n 3.3v 559.505n 3.3v 569.495n 3.3v 569.505n 3.3v 579.495n 3.3v 579.505n 3.3v 589.495n 3.3v 589.505n 3.3v 599.495n 3.3v 599.505n 3.3v 609.495n 3.3v 609.505n 3.3v 619.495n 3.3v 619.505n 3.3v 629.495n 3.3v 629.505n 3.3v 639.495n 3.3v 639.505n 3.3v 649.495n 3.3v 649.505n 3.3v 659.495n 3.3v 659.505n 3.3v 669.495n 3.3v 669.505n 3.3v 679.495n 3.3v 679.505n 3.3v 689.495n 3.3v 689.505n 3.3v 699.495n 3.3v 699.505n 3.3v 709.495n 3.3v 709.505n 3.3v 719.495n 3.3v 719.505n 3.3v 729.495n 3.3v 729.505n 3.3v 739.495n 3.3v 739.505n 3.3v 749.495n 3.3v 749.505n 3.3v 759.495n 3.3v 759.505n 3.3v 769.495n 3.3v 769.505n 3.3v 779.495n 3.3v 779.505n 3.3v 789.495n 3.3v 789.505n 3.3v 799.495n 3.3v 799.505n 3.3v 809.495n 3.3v 809.505n 3.3v 819.495n 3.3v 819.505n 3.3v 829.495n 3.3v 829.505n 3.3v 839.495n 3.3v 839.505n 3.3v 849.495n 3.3v 849.505n 3.3v 859.495n 3.3v 859.505n 3.3v 869.495n 3.3v 869.505n 3.3v 879.495n 3.3v 879.505n 3.3v 889.495n 3.3v 889.505n 0.0v 899.495n 0.0v 899.505n 0.0v 909.495n 0.0v 909.505n 0.0v 919.495n 0.0v 919.505n 0.0v 929.495n 0.0v 929.505n 3.3v 939.495n 3.3v 939.505n 3.3v 949.495n 3.3v 949.505n 3.3v 959.495n 3.3v 959.505n 3.3v 969.495n 3.3v 969.505n 3.3v 979.495n 3.3v 979.505n 3.3v 989.495n 3.3v 989.505n 3.3v 999.495n 3.3v 999.505n 3.3v 1009.495n 3.3v 1009.505n 3.3v 1019.495n 3.3v 1019.505n 3.3v 1029.495n 3.3v 1029.505n 0.0v 1039.495n 0.0v 1039.505n 0.0v 1049.495n 0.0v 1049.505n 0.0v 1059.495n 0.0v 1059.505n 0.0v 1069.495n 0.0v 1069.505n 0.0v 1079.495n 0.0v 1079.505n 0.0v 1089.495n 0.0v 1089.505n 0.0v 1099.495n 0.0v 1099.505n 0.0v 1109.495n 0.0v 1109.505n 0.0v 1119.495n 0.0v 1119.505n 0.0v 1129.495n 0.0v 1129.505n 0.0v 1139.495n 0.0v 1139.505n 0.0v 1149.495n 0.0v 1149.505n 0.0v 1159.495n 0.0v 1159.505n 0.0v 1169.495n 0.0v 1169.505n 0.0v 1179.495n 0.0v 1179.505n 0.0v 1189.495n 0.0v 1189.505n 0.0v 1199.495n 0.0v 1199.505n 0.0v 1209.495n 0.0v 1209.505n 0.0v 1219.495n 0.0v 1219.505n 0.0v 1229.495n 0.0v 1229.505n 0.0v 1239.495n 0.0v 1239.505n 0.0v 1249.495n 0.0v 1249.505n 0.0v 1259.495n 0.0v 1259.505n 3.3v 1269.495n 3.3v 1269.505n 3.3v 1279.495n 3.3v 1279.505n 3.3v 1289.495n 3.3v 1289.505n 3.3v 1299.495n 3.3v 1299.505n 3.3v 1309.495n 3.3v 1309.505n 3.3v 1319.495n 3.3v 1319.505n 3.3v 1329.495n 3.3v 1329.505n 3.3v 1339.495n 3.3v 1339.505n 3.3v 1349.495n 3.3v 1349.505n 3.3v 1359.495n 3.3v 1359.505n 3.3v 1369.495n 3.3v 1369.505n 3.3v 1379.495n 3.3v 1379.505n 3.3v 1389.495n 3.3v 1389.505n 3.3v 1399.495n 3.3v 1399.505n 3.3v 1409.495n 3.3v 1409.505n 3.3v 1419.495n 3.3v 1419.505n 3.3v 1429.495n 3.3v 1429.505n 3.3v 1439.495n 3.3v 1439.505n 0.0v 1449.495n 0.0v 1449.505n 0.0v 1459.495n 0.0v 1459.505n 3.3v 1469.495n 3.3v 1469.505n 3.3v 1479.495n 3.3v 1479.505n 3.3v 1489.495n 3.3v 1489.505n 3.3v 1499.495n 3.3v 1499.505n 3.3v 1509.495n 3.3v 1509.505n 0.0v 1519.495n 0.0v 1519.505n 0.0v 1529.495n 0.0v 1529.505n 3.3v 1539.495n 3.3v 1539.505n 3.3v 1549.495n 3.3v 1549.505n 3.3v 1559.495n 3.3v 1559.505n 3.3v 1569.495n 3.3v 1569.505n 3.3v 1579.495n 3.3v 1579.505n 3.3v 1589.495n 3.3v 1589.505n 3.3v 1599.495n 3.3v 1599.505n 3.3v 1609.495n 3.3v 1609.505n 3.3v 1619.495n 3.3v 1619.505n 0.0v 1629.495n 0.0v 1629.505n 0.0v 1639.495n 0.0v 1639.505n 0.0v 1649.495n 0.0v 1649.505n 0.0v 1659.495n 0.0v 1659.505n 3.3v 1669.495n 3.3v 1669.505n 3.3v 1679.495n 3.3v 1679.505n 3.3v 1689.495n 3.3v 1689.505n 3.3v 1699.495n 3.3v 1699.505n 0.0v 1709.495n 0.0v 1709.505n 3.3v 1719.495n 3.3v 1719.505n 0.0v 1729.495n 0.0v 1729.505n 0.0v 1739.495n 0.0v 1739.505n 0.0v 1749.495n 0.0v 1749.505n 0.0v 1759.495n 0.0v 1759.505n 0.0v 1769.495n 0.0v 1769.505n 3.3v 1779.495n 3.3v 1779.505n 3.3v 1789.495n 3.3v 1789.505n 3.3v 1799.495n 3.3v 1799.505n 3.3v 1809.495n 3.3v 1809.505n 3.3v 1819.495n 3.3v 1819.505n 3.3v 1829.495n 3.3v 1829.505n 3.3v 1839.495n 3.3v 1839.505n 3.3v 1849.495n 3.3v 1849.505n 0.0v 1859.495n 0.0v 1859.505n 0.0v 1869.495n 0.0v 1869.505n 0.0v 1879.495n 0.0v 1879.505n 3.3v 1889.495n 3.3v 1889.505n 3.3v 1899.495n 3.3v 1899.505n 3.3v 1909.495n 3.3v 1909.505n 3.3v 1919.495n 3.3v 1919.505n 3.3v 1929.495n 3.3v 1929.505n 3.3v 1939.495n 3.3v 1939.505n 3.3v 1949.495n 3.3v 1949.505n 3.3v 1959.495n 3.3v 1959.505n 3.3v 1969.495n 3.3v 1969.505n 3.3v 1979.495n 3.3v 1979.505n 0.0v 1989.495n 0.0v 1989.505n 0.0v 1999.495n 0.0v 1999.505n 0.0v 2009.495n 0.0v 2009.505n 0.0v 2019.495n 0.0v 2019.505n 0.0v 2029.495n 0.0v 2029.505n 0.0v 2039.495n 0.0v 2039.505n 0.0v 2049.495n 0.0v 2049.505n 0.0v )
* (time, data): [(0, 0), (10, 1), (20, 0), (30, 1), (40, 1), (50, 1), (60, 1), (70, 0), (80, 0), (90, 0), (100, 0), (110, 0), (120, 0), (130, 0), (140, 0), (150, 1), (160, 0), (170, 0), (180, 1), (190, 1), (200, 1), (210, 1), (220, 1), (230, 0), (240, 0), (250, 0), (260, 0), (270, 0), (280, 0), (290, 0), (300, 0), (310, 0), (320, 0), (330, 0), (340, 0), (350, 0), (360, 1), (370, 1), (380, 1), (390, 1), (400, 1), (410, 1), (420, 1), (430, 1), (440, 1), (450, 1), (460, 1), (470, 1), (480, 1), (490, 1), (500, 1), (510, 1), (520, 1), (530, 1), (540, 1), (550, 1), (560, 1), (570, 1), (580, 1), (590, 1), (600, 1), (610, 0), (620, 0), (630, 1), (640, 1), (650, 1), (660, 1), (670, 1), (680, 1), (690, 0), (700, 0), (710, 0), (720, 0), (730, 0), (740, 1), (750, 0), (760, 0), (770, 1), (780, 1), (790, 1), (800, 0), (810, 0), (820, 1), (830, 1), (840, 1), (850, 1), (860, 1), (870, 1), (880, 1), (890, 1), (900, 1), (910, 1), (920, 1), (930, 1), (940, 1), (950, 1), (960, 0), (970, 0), (980, 0), (990, 0), (1000, 1), (1010, 1), (1020, 1), (1030, 1), (1040, 1), (1050, 1), (1060, 1), (1070, 1), (1080, 1), (1090, 1), (1100, 1), (1110, 1), (1120, 1), (1130, 1), (1140, 1), (1150, 1), (1160, 1), (1170, 1), (1180, 1), (1190, 1), (1200, 1), (1210, 1), (1220, 1), (1230, 1), (1240, 0), (1250, 0), (1260, 0), (1270, 0), (1280, 1), (1290, 1), (1300, 1), (1310, 1), (1320, 1), (1330, 1), (1340, 0), (1350, 0), (1360, 0), (1370, 0), (1380, 0), (1390, 1), (1400, 1), (1410, 1), (1420, 1), (1430, 0), (1440, 0), (1450, 0), (1460, 0), (1470, 1), (1480, 1), (1490, 1), (1500, 1), (1510, 1), (1520, 1), (1530, 1), (1540, 1), (1550, 1), (1560, 1), (1570, 0), (1580, 0), (1590, 0), (1600, 0), (1610, 1), (1620, 1), (1630, 0), (1640, 0), (1650, 0), (1660, 1), (1670, 1), (1680, 0), (1690, 0), (1700, 0), (1710, 0), (1720, 0), (1730, 0), (1740, 0), (1750, 0), (1760, 0), (1770, 1), (1780, 1), (1790, 0), (1800, 0), (1810, 0), (1820, 0), (1830, 0), (1840, 0), (1850, 0), (1860, 0), (1870, 0), (1880, 0), (1890, 0), (1900, 0), (1910, 0), (1920, 0), (1930, 0), (1940, 0), (1950, 0), (1960, 0), (1970, 0), (1980, 1), (1990, 1), (2000, 1), (2010, 1), (2020, 1), (2030, 1), (2040, 1), (2050, 1)]
Vdin1_0  din1_0  0 PWL (0n 0.0v 9.495n 0.0v 9.505n 3.3v 19.495n 3.3v 19.505n 0.0v 29.495n 0.0v 29.505n 3.3v 39.495n 3.3v 39.505n 3.3v 49.495n 3.3v 49.505n 3.3v 59.495n 3.3v 59.505n 3.3v 69.495n 3.3v 69.505n 0.0v 79.495n 0.0v 79.505n 0.0v 89.495n 0.0v 89.505n 0.0v 99.495n 0.0v 99.505n 0.0v 109.495n 0.0v 109.505n 0.0v 119.495n 0.0v 119.505n 0.0v 129.495n 0.0v 129.505n 0.0v 139.495n 0.0v 139.505n 0.0v 149.495n 0.0v 149.505n 3.3v 159.495n 3.3v 159.505n 0.0v 169.495n 0.0v 169.505n 0.0v 179.495n 0.0v 179.505n 3.3v 189.495n 3.3v 189.505n 3.3v 199.495n 3.3v 199.505n 3.3v 209.495n 3.3v 209.505n 3.3v 219.495n 3.3v 219.505n 3.3v 229.495n 3.3v 229.505n 0.0v 239.495n 0.0v 239.505n 0.0v 249.495n 0.0v 249.505n 0.0v 259.495n 0.0v 259.505n 0.0v 269.495n 0.0v 269.505n 0.0v 279.495n 0.0v 279.505n 0.0v 289.495n 0.0v 289.505n 0.0v 299.495n 0.0v 299.505n 0.0v 309.495n 0.0v 309.505n 0.0v 319.495n 0.0v 319.505n 0.0v 329.495n 0.0v 329.505n 0.0v 339.495n 0.0v 339.505n 0.0v 349.495n 0.0v 349.505n 0.0v 359.495n 0.0v 359.505n 3.3v 369.495n 3.3v 369.505n 3.3v 379.495n 3.3v 379.505n 3.3v 389.495n 3.3v 389.505n 3.3v 399.495n 3.3v 399.505n 3.3v 409.495n 3.3v 409.505n 3.3v 419.495n 3.3v 419.505n 3.3v 429.495n 3.3v 429.505n 3.3v 439.495n 3.3v 439.505n 3.3v 449.495n 3.3v 449.505n 3.3v 459.495n 3.3v 459.505n 3.3v 469.495n 3.3v 469.505n 3.3v 479.495n 3.3v 479.505n 3.3v 489.495n 3.3v 489.505n 3.3v 499.495n 3.3v 499.505n 3.3v 509.495n 3.3v 509.505n 3.3v 519.495n 3.3v 519.505n 3.3v 529.495n 3.3v 529.505n 3.3v 539.495n 3.3v 539.505n 3.3v 549.495n 3.3v 549.505n 3.3v 559.495n 3.3v 559.505n 3.3v 569.495n 3.3v 569.505n 3.3v 579.495n 3.3v 579.505n 3.3v 589.495n 3.3v 589.505n 3.3v 599.495n 3.3v 599.505n 3.3v 609.495n 3.3v 609.505n 0.0v 619.495n 0.0v 619.505n 0.0v 629.495n 0.0v 629.505n 3.3v 639.495n 3.3v 639.505n 3.3v 649.495n 3.3v 649.505n 3.3v 659.495n 3.3v 659.505n 3.3v 669.495n 3.3v 669.505n 3.3v 679.495n 3.3v 679.505n 3.3v 689.495n 3.3v 689.505n 0.0v 699.495n 0.0v 699.505n 0.0v 709.495n 0.0v 709.505n 0.0v 719.495n 0.0v 719.505n 0.0v 729.495n 0.0v 729.505n 0.0v 739.495n 0.0v 739.505n 3.3v 749.495n 3.3v 749.505n 0.0v 759.495n 0.0v 759.505n 0.0v 769.495n 0.0v 769.505n 3.3v 779.495n 3.3v 779.505n 3.3v 789.495n 3.3v 789.505n 3.3v 799.495n 3.3v 799.505n 0.0v 809.495n 0.0v 809.505n 0.0v 819.495n 0.0v 819.505n 3.3v 829.495n 3.3v 829.505n 3.3v 839.495n 3.3v 839.505n 3.3v 849.495n 3.3v 849.505n 3.3v 859.495n 3.3v 859.505n 3.3v 869.495n 3.3v 869.505n 3.3v 879.495n 3.3v 879.505n 3.3v 889.495n 3.3v 889.505n 3.3v 899.495n 3.3v 899.505n 3.3v 909.495n 3.3v 909.505n 3.3v 919.495n 3.3v 919.505n 3.3v 929.495n 3.3v 929.505n 3.3v 939.495n 3.3v 939.505n 3.3v 949.495n 3.3v 949.505n 3.3v 959.495n 3.3v 959.505n 0.0v 969.495n 0.0v 969.505n 0.0v 979.495n 0.0v 979.505n 0.0v 989.495n 0.0v 989.505n 0.0v 999.495n 0.0v 999.505n 3.3v 1009.495n 3.3v 1009.505n 3.3v 1019.495n 3.3v 1019.505n 3.3v 1029.495n 3.3v 1029.505n 3.3v 1039.495n 3.3v 1039.505n 3.3v 1049.495n 3.3v 1049.505n 3.3v 1059.495n 3.3v 1059.505n 3.3v 1069.495n 3.3v 1069.505n 3.3v 1079.495n 3.3v 1079.505n 3.3v 1089.495n 3.3v 1089.505n 3.3v 1099.495n 3.3v 1099.505n 3.3v 1109.495n 3.3v 1109.505n 3.3v 1119.495n 3.3v 1119.505n 3.3v 1129.495n 3.3v 1129.505n 3.3v 1139.495n 3.3v 1139.505n 3.3v 1149.495n 3.3v 1149.505n 3.3v 1159.495n 3.3v 1159.505n 3.3v 1169.495n 3.3v 1169.505n 3.3v 1179.495n 3.3v 1179.505n 3.3v 1189.495n 3.3v 1189.505n 3.3v 1199.495n 3.3v 1199.505n 3.3v 1209.495n 3.3v 1209.505n 3.3v 1219.495n 3.3v 1219.505n 3.3v 1229.495n 3.3v 1229.505n 3.3v 1239.495n 3.3v 1239.505n 0.0v 1249.495n 0.0v 1249.505n 0.0v 1259.495n 0.0v 1259.505n 0.0v 1269.495n 0.0v 1269.505n 0.0v 1279.495n 0.0v 1279.505n 3.3v 1289.495n 3.3v 1289.505n 3.3v 1299.495n 3.3v 1299.505n 3.3v 1309.495n 3.3v 1309.505n 3.3v 1319.495n 3.3v 1319.505n 3.3v 1329.495n 3.3v 1329.505n 3.3v 1339.495n 3.3v 1339.505n 0.0v 1349.495n 0.0v 1349.505n 0.0v 1359.495n 0.0v 1359.505n 0.0v 1369.495n 0.0v 1369.505n 0.0v 1379.495n 0.0v 1379.505n 0.0v 1389.495n 0.0v 1389.505n 3.3v 1399.495n 3.3v 1399.505n 3.3v 1409.495n 3.3v 1409.505n 3.3v 1419.495n 3.3v 1419.505n 3.3v 1429.495n 3.3v 1429.505n 0.0v 1439.495n 0.0v 1439.505n 0.0v 1449.495n 0.0v 1449.505n 0.0v 1459.495n 0.0v 1459.505n 0.0v 1469.495n 0.0v 1469.505n 3.3v 1479.495n 3.3v 1479.505n 3.3v 1489.495n 3.3v 1489.505n 3.3v 1499.495n 3.3v 1499.505n 3.3v 1509.495n 3.3v 1509.505n 3.3v 1519.495n 3.3v 1519.505n 3.3v 1529.495n 3.3v 1529.505n 3.3v 1539.495n 3.3v 1539.505n 3.3v 1549.495n 3.3v 1549.505n 3.3v 1559.495n 3.3v 1559.505n 3.3v 1569.495n 3.3v 1569.505n 0.0v 1579.495n 0.0v 1579.505n 0.0v 1589.495n 0.0v 1589.505n 0.0v 1599.495n 0.0v 1599.505n 0.0v 1609.495n 0.0v 1609.505n 3.3v 1619.495n 3.3v 1619.505n 3.3v 1629.495n 3.3v 1629.505n 0.0v 1639.495n 0.0v 1639.505n 0.0v 1649.495n 0.0v 1649.505n 0.0v 1659.495n 0.0v 1659.505n 3.3v 1669.495n 3.3v 1669.505n 3.3v 1679.495n 3.3v 1679.505n 0.0v 1689.495n 0.0v 1689.505n 0.0v 1699.495n 0.0v 1699.505n 0.0v 1709.495n 0.0v 1709.505n 0.0v 1719.495n 0.0v 1719.505n 0.0v 1729.495n 0.0v 1729.505n 0.0v 1739.495n 0.0v 1739.505n 0.0v 1749.495n 0.0v 1749.505n 0.0v 1759.495n 0.0v 1759.505n 0.0v 1769.495n 0.0v 1769.505n 3.3v 1779.495n 3.3v 1779.505n 3.3v 1789.495n 3.3v 1789.505n 0.0v 1799.495n 0.0v 1799.505n 0.0v 1809.495n 0.0v 1809.505n 0.0v 1819.495n 0.0v 1819.505n 0.0v 1829.495n 0.0v 1829.505n 0.0v 1839.495n 0.0v 1839.505n 0.0v 1849.495n 0.0v 1849.505n 0.0v 1859.495n 0.0v 1859.505n 0.0v 1869.495n 0.0v 1869.505n 0.0v 1879.495n 0.0v 1879.505n 0.0v 1889.495n 0.0v 1889.505n 0.0v 1899.495n 0.0v 1899.505n 0.0v 1909.495n 0.0v 1909.505n 0.0v 1919.495n 0.0v 1919.505n 0.0v 1929.495n 0.0v 1929.505n 0.0v 1939.495n 0.0v 1939.505n 0.0v 1949.495n 0.0v 1949.505n 0.0v 1959.495n 0.0v 1959.505n 0.0v 1969.495n 0.0v 1969.505n 0.0v 1979.495n 0.0v 1979.505n 3.3v 1989.495n 3.3v 1989.505n 3.3v 1999.495n 3.3v 1999.505n 3.3v 2009.495n 3.3v 2009.505n 3.3v 2019.495n 3.3v 2019.505n 3.3v 2029.495n 3.3v 2029.505n 3.3v 2039.495n 3.3v 2039.505n 3.3v 2049.495n 3.3v 2049.505n 3.3v )
* (time, data): [(0, 0), (10, 0), (20, 1), (30, 1), (40, 1), (50, 1), (60, 1), (70, 1), (80, 1), (90, 1), (100, 0), (110, 0), (120, 0), (130, 0), (140, 0), (150, 0), (160, 0), (170, 0), (180, 0), (190, 0), (200, 0), (210, 0), (220, 0), (230, 1), (240, 1), (250, 1), (260, 1), (270, 1), (280, 1), (290, 1), (300, 1), (310, 1), (320, 1), (330, 0), (340, 0), (350, 0), (360, 0), (370, 0), (380, 0), (390, 0), (400, 0), (410, 0), (420, 0), (430, 0), (440, 1), (450, 1), (460, 1), (470, 1), (480, 1), (490, 1), (500, 1), (510, 1), (520, 1), (530, 1), (540, 1), (550, 1), (560, 1), (570, 1), (580, 1), (590, 1), (600, 1), (610, 1), (620, 1), (630, 0), (640, 0), (650, 0), (660, 0), (670, 0), (680, 0), (690, 0), (700, 0), (710, 0), (720, 0), (730, 0), (740, 0), (750, 0), (760, 0), (770, 1), (780, 1), (790, 1), (800, 1), (810, 1), (820, 1), (830, 1), (840, 1), (850, 1), (860, 1), (870, 1), (880, 1), (890, 1), (900, 1), (910, 0), (920, 0), (930, 0), (940, 1), (950, 1), (960, 0), (970, 0), (980, 0), (990, 0), (1000, 1), (1010, 1), (1020, 1), (1030, 1), (1040, 1), (1050, 1), (1060, 1), (1070, 1), (1080, 1), (1090, 0), (1100, 0), (1110, 0), (1120, 0), (1130, 0), (1140, 0), (1150, 0), (1160, 0), (1170, 0), (1180, 0), (1190, 0), (1200, 0), (1210, 0), (1220, 0), (1230, 0), (1240, 0), (1250, 0), (1260, 0), (1270, 0), (1280, 0), (1290, 0), (1300, 0), (1310, 0), (1320, 1), (1330, 1), (1340, 0), (1350, 0), (1360, 0), (1370, 0), (1380, 0), (1390, 0), (1400, 0), (1410, 0), (1420, 0), (1430, 0), (1440, 1), (1450, 1), (1460, 1), (1470, 0), (1480, 0), (1490, 0), (1500, 0), (1510, 0), (1520, 0), (1530, 0), (1540, 0), (1550, 0), (1560, 0), (1570, 1), (1580, 1), (1590, 1), (1600, 1), (1610, 0), (1620, 0), (1630, 0), (1640, 0), (1650, 0), (1660, 1), (1670, 1), (1680, 0), (1690, 0), (1700, 0), (1710, 0), (1720, 0), (1730, 0), (1740, 0), (1750, 0), (1760, 0), (1770, 1), (1780, 1), (1790, 1), (1800, 1), (1810, 1), (1820, 1), (1830, 1), (1840, 1), (1850, 1), (1860, 1), (1870, 1), (1880, 1), (1890, 1), (1900, 1), (1910, 1), (1920, 1), (1930, 1), (1940, 1), (1950, 0), (1960, 0), (1970, 0), (1980, 0), (1990, 0), (2000, 0), (2010, 0), (2020, 0), (2030, 1), (2040, 1), (2050, 1)]
Vdin1_1  din1_1  0 PWL (0n 0.0v 9.495n 0.0v 9.505n 0.0v 19.495n 0.0v 19.505n 3.3v 29.495n 3.3v 29.505n 3.3v 39.495n 3.3v 39.505n 3.3v 49.495n 3.3v 49.505n 3.3v 59.495n 3.3v 59.505n 3.3v 69.495n 3.3v 69.505n 3.3v 79.495n 3.3v 79.505n 3.3v 89.495n 3.3v 89.505n 3.3v 99.495n 3.3v 99.505n 0.0v 109.495n 0.0v 109.505n 0.0v 119.495n 0.0v 119.505n 0.0v 129.495n 0.0v 129.505n 0.0v 139.495n 0.0v 139.505n 0.0v 149.495n 0.0v 149.505n 0.0v 159.495n 0.0v 159.505n 0.0v 169.495n 0.0v 169.505n 0.0v 179.495n 0.0v 179.505n 0.0v 189.495n 0.0v 189.505n 0.0v 199.495n 0.0v 199.505n 0.0v 209.495n 0.0v 209.505n 0.0v 219.495n 0.0v 219.505n 0.0v 229.495n 0.0v 229.505n 3.3v 239.495n 3.3v 239.505n 3.3v 249.495n 3.3v 249.505n 3.3v 259.495n 3.3v 259.505n 3.3v 269.495n 3.3v 269.505n 3.3v 279.495n 3.3v 279.505n 3.3v 289.495n 3.3v 289.505n 3.3v 299.495n 3.3v 299.505n 3.3v 309.495n 3.3v 309.505n 3.3v 319.495n 3.3v 319.505n 3.3v 329.495n 3.3v 329.505n 0.0v 339.495n 0.0v 339.505n 0.0v 349.495n 0.0v 349.505n 0.0v 359.495n 0.0v 359.505n 0.0v 369.495n 0.0v 369.505n 0.0v 379.495n 0.0v 379.505n 0.0v 389.495n 0.0v 389.505n 0.0v 399.495n 0.0v 399.505n 0.0v 409.495n 0.0v 409.505n 0.0v 419.495n 0.0v 419.505n 0.0v 429.495n 0.0v 429.505n 0.0v 439.495n 0.0v 439.505n 3.3v 449.495n 3.3v 449.505n 3.3v 459.495n 3.3v 459.505n 3.3v 469.495n 3.3v 469.505n 3.3v 479.495n 3.3v 479.505n 3.3v 489.495n 3.3v 489.505n 3.3v 499.495n 3.3v 499.505n 3.3v 509.495n 3.3v 509.505n 3.3v 519.495n 3.3v 519.505n 3.3v 529.495n 3.3v 529.505n 3.3v 539.495n 3.3v 539.505n 3.3v 549.495n 3.3v 549.505n 3.3v 559.495n 3.3v 559.505n 3.3v 569.495n 3.3v 569.505n 3.3v 579.495n 3.3v 579.505n 3.3v 589.495n 3.3v 589.505n 3.3v 599.495n 3.3v 599.505n 3.3v 609.495n 3.3v 609.505n 3.3v 619.495n 3.3v 619.505n 3.3v 629.495n 3.3v 629.505n 0.0v 639.495n 0.0v 639.505n 0.0v 649.495n 0.0v 649.505n 0.0v 659.495n 0.0v 659.505n 0.0v 669.495n 0.0v 669.505n 0.0v 679.495n 0.0v 679.505n 0.0v 689.495n 0.0v 689.505n 0.0v 699.495n 0.0v 699.505n 0.0v 709.495n 0.0v 709.505n 0.0v 719.495n 0.0v 719.505n 0.0v 729.495n 0.0v 729.505n 0.0v 739.495n 0.0v 739.505n 0.0v 749.495n 0.0v 749.505n 0.0v 759.495n 0.0v 759.505n 0.0v 769.495n 0.0v 769.505n 3.3v 779.495n 3.3v 779.505n 3.3v 789.495n 3.3v 789.505n 3.3v 799.495n 3.3v 799.505n 3.3v 809.495n 3.3v 809.505n 3.3v 819.495n 3.3v 819.505n 3.3v 829.495n 3.3v 829.505n 3.3v 839.495n 3.3v 839.505n 3.3v 849.495n 3.3v 849.505n 3.3v 859.495n 3.3v 859.505n 3.3v 869.495n 3.3v 869.505n 3.3v 879.495n 3.3v 879.505n 3.3v 889.495n 3.3v 889.505n 3.3v 899.495n 3.3v 899.505n 3.3v 909.495n 3.3v 909.505n 0.0v 919.495n 0.0v 919.505n 0.0v 929.495n 0.0v 929.505n 0.0v 939.495n 0.0v 939.505n 3.3v 949.495n 3.3v 949.505n 3.3v 959.495n 3.3v 959.505n 0.0v 969.495n 0.0v 969.505n 0.0v 979.495n 0.0v 979.505n 0.0v 989.495n 0.0v 989.505n 0.0v 999.495n 0.0v 999.505n 3.3v 1009.495n 3.3v 1009.505n 3.3v 1019.495n 3.3v 1019.505n 3.3v 1029.495n 3.3v 1029.505n 3.3v 1039.495n 3.3v 1039.505n 3.3v 1049.495n 3.3v 1049.505n 3.3v 1059.495n 3.3v 1059.505n 3.3v 1069.495n 3.3v 1069.505n 3.3v 1079.495n 3.3v 1079.505n 3.3v 1089.495n 3.3v 1089.505n 0.0v 1099.495n 0.0v 1099.505n 0.0v 1109.495n 0.0v 1109.505n 0.0v 1119.495n 0.0v 1119.505n 0.0v 1129.495n 0.0v 1129.505n 0.0v 1139.495n 0.0v 1139.505n 0.0v 1149.495n 0.0v 1149.505n 0.0v 1159.495n 0.0v 1159.505n 0.0v 1169.495n 0.0v 1169.505n 0.0v 1179.495n 0.0v 1179.505n 0.0v 1189.495n 0.0v 1189.505n 0.0v 1199.495n 0.0v 1199.505n 0.0v 1209.495n 0.0v 1209.505n 0.0v 1219.495n 0.0v 1219.505n 0.0v 1229.495n 0.0v 1229.505n 0.0v 1239.495n 0.0v 1239.505n 0.0v 1249.495n 0.0v 1249.505n 0.0v 1259.495n 0.0v 1259.505n 0.0v 1269.495n 0.0v 1269.505n 0.0v 1279.495n 0.0v 1279.505n 0.0v 1289.495n 0.0v 1289.505n 0.0v 1299.495n 0.0v 1299.505n 0.0v 1309.495n 0.0v 1309.505n 0.0v 1319.495n 0.0v 1319.505n 3.3v 1329.495n 3.3v 1329.505n 3.3v 1339.495n 3.3v 1339.505n 0.0v 1349.495n 0.0v 1349.505n 0.0v 1359.495n 0.0v 1359.505n 0.0v 1369.495n 0.0v 1369.505n 0.0v 1379.495n 0.0v 1379.505n 0.0v 1389.495n 0.0v 1389.505n 0.0v 1399.495n 0.0v 1399.505n 0.0v 1409.495n 0.0v 1409.505n 0.0v 1419.495n 0.0v 1419.505n 0.0v 1429.495n 0.0v 1429.505n 0.0v 1439.495n 0.0v 1439.505n 3.3v 1449.495n 3.3v 1449.505n 3.3v 1459.495n 3.3v 1459.505n 3.3v 1469.495n 3.3v 1469.505n 0.0v 1479.495n 0.0v 1479.505n 0.0v 1489.495n 0.0v 1489.505n 0.0v 1499.495n 0.0v 1499.505n 0.0v 1509.495n 0.0v 1509.505n 0.0v 1519.495n 0.0v 1519.505n 0.0v 1529.495n 0.0v 1529.505n 0.0v 1539.495n 0.0v 1539.505n 0.0v 1549.495n 0.0v 1549.505n 0.0v 1559.495n 0.0v 1559.505n 0.0v 1569.495n 0.0v 1569.505n 3.3v 1579.495n 3.3v 1579.505n 3.3v 1589.495n 3.3v 1589.505n 3.3v 1599.495n 3.3v 1599.505n 3.3v 1609.495n 3.3v 1609.505n 0.0v 1619.495n 0.0v 1619.505n 0.0v 1629.495n 0.0v 1629.505n 0.0v 1639.495n 0.0v 1639.505n 0.0v 1649.495n 0.0v 1649.505n 0.0v 1659.495n 0.0v 1659.505n 3.3v 1669.495n 3.3v 1669.505n 3.3v 1679.495n 3.3v 1679.505n 0.0v 1689.495n 0.0v 1689.505n 0.0v 1699.495n 0.0v 1699.505n 0.0v 1709.495n 0.0v 1709.505n 0.0v 1719.495n 0.0v 1719.505n 0.0v 1729.495n 0.0v 1729.505n 0.0v 1739.495n 0.0v 1739.505n 0.0v 1749.495n 0.0v 1749.505n 0.0v 1759.495n 0.0v 1759.505n 0.0v 1769.495n 0.0v 1769.505n 3.3v 1779.495n 3.3v 1779.505n 3.3v 1789.495n 3.3v 1789.505n 3.3v 1799.495n 3.3v 1799.505n 3.3v 1809.495n 3.3v 1809.505n 3.3v 1819.495n 3.3v 1819.505n 3.3v 1829.495n 3.3v 1829.505n 3.3v 1839.495n 3.3v 1839.505n 3.3v 1849.495n 3.3v 1849.505n 3.3v 1859.495n 3.3v 1859.505n 3.3v 1869.495n 3.3v 1869.505n 3.3v 1879.495n 3.3v 1879.505n 3.3v 1889.495n 3.3v 1889.505n 3.3v 1899.495n 3.3v 1899.505n 3.3v 1909.495n 3.3v 1909.505n 3.3v 1919.495n 3.3v 1919.505n 3.3v 1929.495n 3.3v 1929.505n 3.3v 1939.495n 3.3v 1939.505n 3.3v 1949.495n 3.3v 1949.505n 0.0v 1959.495n 0.0v 1959.505n 0.0v 1969.495n 0.0v 1969.505n 0.0v 1979.495n 0.0v 1979.505n 0.0v 1989.495n 0.0v 1989.505n 0.0v 1999.495n 0.0v 1999.505n 0.0v 2009.495n 0.0v 2009.505n 0.0v 2019.495n 0.0v 2019.505n 0.0v 2029.495n 0.0v 2029.505n 3.3v 2039.495n 3.3v 2039.505n 3.3v 2049.495n 3.3v 2049.505n 3.3v )
* (time, data): [(0, 0), (10, 1), (20, 0), (30, 0), (40, 0), (50, 0), (60, 0), (70, 0), (80, 0), (90, 0), (100, 0), (110, 0), (120, 0), (130, 0), (140, 0), (150, 1), (160, 0), (170, 0), (180, 1), (190, 1), (200, 1), (210, 1), (220, 1), (230, 1), (240, 1), (250, 1), (260, 1), (270, 1), (280, 1), (290, 1), (300, 1), (310, 1), (320, 1), (330, 1), (340, 1), (350, 1), (360, 0), (370, 0), (380, 0), (390, 0), (400, 0), (410, 0), (420, 0), (430, 0), (440, 0), (450, 0), (460, 0), (470, 0), (480, 0), (490, 0), (500, 0), (510, 0), (520, 0), (530, 0), (540, 0), (550, 0), (560, 0), (570, 0), (580, 0), (590, 0), (600, 0), (610, 0), (620, 0), (630, 0), (640, 0), (650, 0), (660, 0), (670, 0), (680, 0), (690, 1), (700, 1), (710, 1), (720, 1), (730, 1), (740, 0), (750, 1), (760, 1), (770, 0), (780, 0), (790, 0), (800, 0), (810, 0), (820, 1), (830, 1), (840, 1), (850, 1), (860, 1), (870, 1), (880, 1), (890, 1), (900, 1), (910, 0), (920, 0), (930, 0), (940, 0), (950, 0), (960, 1), (970, 1), (980, 1), (990, 1), (1000, 1), (1010, 1), (1020, 1), (1030, 1), (1040, 1), (1050, 1), (1060, 1), (1070, 1), (1080, 1), (1090, 0), (1100, 0), (1110, 0), (1120, 0), (1130, 0), (1140, 0), (1150, 0), (1160, 0), (1170, 0), (1180, 0), (1190, 0), (1200, 0), (1210, 0), (1220, 0), (1230, 0), (1240, 1), (1250, 0), (1260, 0), (1270, 0), (1280, 0), (1290, 0), (1300, 0), (1310, 0), (1320, 1), (1330, 1), (1340, 1), (1350, 1), (1360, 0), (1370, 0), (1380, 0), (1390, 1), (1400, 1), (1410, 1), (1420, 1), (1430, 1), (1440, 1), (1450, 1), (1460, 1), (1470, 0), (1480, 0), (1490, 0), (1500, 0), (1510, 0), (1520, 0), (1530, 0), (1540, 0), (1550, 1), (1560, 1), (1570, 0), (1580, 0), (1590, 0), (1600, 0), (1610, 0), (1620, 0), (1630, 1), (1640, 1), (1650, 1), (1660, 1), (1670, 1), (1680, 0), (1690, 0), (1700, 0), (1710, 0), (1720, 0), (1730, 0), (1740, 0), (1750, 0), (1760, 0), (1770, 1), (1780, 1), (1790, 0), (1800, 0), (1810, 0), (1820, 0), (1830, 0), (1840, 0), (1850, 0), (1860, 0), (1870, 0), (1880, 0), (1890, 0), (1900, 0), (1910, 0), (1920, 0), (1930, 0), (1940, 0), (1950, 1), (1960, 1), (1970, 1), (1980, 0), (1990, 0), (2000, 0), (2010, 0), (2020, 1), (2030, 1), (2040, 1), (2050, 1)]
Vdin1_2  din1_2  0 PWL (0n 0.0v 9.495n 0.0v 9.505n 3.3v 19.495n 3.3v 19.505n 0.0v 29.495n 0.0v 29.505n 0.0v 39.495n 0.0v 39.505n 0.0v 49.495n 0.0v 49.505n 0.0v 59.495n 0.0v 59.505n 0.0v 69.495n 0.0v 69.505n 0.0v 79.495n 0.0v 79.505n 0.0v 89.495n 0.0v 89.505n 0.0v 99.495n 0.0v 99.505n 0.0v 109.495n 0.0v 109.505n 0.0v 119.495n 0.0v 119.505n 0.0v 129.495n 0.0v 129.505n 0.0v 139.495n 0.0v 139.505n 0.0v 149.495n 0.0v 149.505n 3.3v 159.495n 3.3v 159.505n 0.0v 169.495n 0.0v 169.505n 0.0v 179.495n 0.0v 179.505n 3.3v 189.495n 3.3v 189.505n 3.3v 199.495n 3.3v 199.505n 3.3v 209.495n 3.3v 209.505n 3.3v 219.495n 3.3v 219.505n 3.3v 229.495n 3.3v 229.505n 3.3v 239.495n 3.3v 239.505n 3.3v 249.495n 3.3v 249.505n 3.3v 259.495n 3.3v 259.505n 3.3v 269.495n 3.3v 269.505n 3.3v 279.495n 3.3v 279.505n 3.3v 289.495n 3.3v 289.505n 3.3v 299.495n 3.3v 299.505n 3.3v 309.495n 3.3v 309.505n 3.3v 319.495n 3.3v 319.505n 3.3v 329.495n 3.3v 329.505n 3.3v 339.495n 3.3v 339.505n 3.3v 349.495n 3.3v 349.505n 3.3v 359.495n 3.3v 359.505n 0.0v 369.495n 0.0v 369.505n 0.0v 379.495n 0.0v 379.505n 0.0v 389.495n 0.0v 389.505n 0.0v 399.495n 0.0v 399.505n 0.0v 409.495n 0.0v 409.505n 0.0v 419.495n 0.0v 419.505n 0.0v 429.495n 0.0v 429.505n 0.0v 439.495n 0.0v 439.505n 0.0v 449.495n 0.0v 449.505n 0.0v 459.495n 0.0v 459.505n 0.0v 469.495n 0.0v 469.505n 0.0v 479.495n 0.0v 479.505n 0.0v 489.495n 0.0v 489.505n 0.0v 499.495n 0.0v 499.505n 0.0v 509.495n 0.0v 509.505n 0.0v 519.495n 0.0v 519.505n 0.0v 529.495n 0.0v 529.505n 0.0v 539.495n 0.0v 539.505n 0.0v 549.495n 0.0v 549.505n 0.0v 559.495n 0.0v 559.505n 0.0v 569.495n 0.0v 569.505n 0.0v 579.495n 0.0v 579.505n 0.0v 589.495n 0.0v 589.505n 0.0v 599.495n 0.0v 599.505n 0.0v 609.495n 0.0v 609.505n 0.0v 619.495n 0.0v 619.505n 0.0v 629.495n 0.0v 629.505n 0.0v 639.495n 0.0v 639.505n 0.0v 649.495n 0.0v 649.505n 0.0v 659.495n 0.0v 659.505n 0.0v 669.495n 0.0v 669.505n 0.0v 679.495n 0.0v 679.505n 0.0v 689.495n 0.0v 689.505n 3.3v 699.495n 3.3v 699.505n 3.3v 709.495n 3.3v 709.505n 3.3v 719.495n 3.3v 719.505n 3.3v 729.495n 3.3v 729.505n 3.3v 739.495n 3.3v 739.505n 0.0v 749.495n 0.0v 749.505n 3.3v 759.495n 3.3v 759.505n 3.3v 769.495n 3.3v 769.505n 0.0v 779.495n 0.0v 779.505n 0.0v 789.495n 0.0v 789.505n 0.0v 799.495n 0.0v 799.505n 0.0v 809.495n 0.0v 809.505n 0.0v 819.495n 0.0v 819.505n 3.3v 829.495n 3.3v 829.505n 3.3v 839.495n 3.3v 839.505n 3.3v 849.495n 3.3v 849.505n 3.3v 859.495n 3.3v 859.505n 3.3v 869.495n 3.3v 869.505n 3.3v 879.495n 3.3v 879.505n 3.3v 889.495n 3.3v 889.505n 3.3v 899.495n 3.3v 899.505n 3.3v 909.495n 3.3v 909.505n 0.0v 919.495n 0.0v 919.505n 0.0v 929.495n 0.0v 929.505n 0.0v 939.495n 0.0v 939.505n 0.0v 949.495n 0.0v 949.505n 0.0v 959.495n 0.0v 959.505n 3.3v 969.495n 3.3v 969.505n 3.3v 979.495n 3.3v 979.505n 3.3v 989.495n 3.3v 989.505n 3.3v 999.495n 3.3v 999.505n 3.3v 1009.495n 3.3v 1009.505n 3.3v 1019.495n 3.3v 1019.505n 3.3v 1029.495n 3.3v 1029.505n 3.3v 1039.495n 3.3v 1039.505n 3.3v 1049.495n 3.3v 1049.505n 3.3v 1059.495n 3.3v 1059.505n 3.3v 1069.495n 3.3v 1069.505n 3.3v 1079.495n 3.3v 1079.505n 3.3v 1089.495n 3.3v 1089.505n 0.0v 1099.495n 0.0v 1099.505n 0.0v 1109.495n 0.0v 1109.505n 0.0v 1119.495n 0.0v 1119.505n 0.0v 1129.495n 0.0v 1129.505n 0.0v 1139.495n 0.0v 1139.505n 0.0v 1149.495n 0.0v 1149.505n 0.0v 1159.495n 0.0v 1159.505n 0.0v 1169.495n 0.0v 1169.505n 0.0v 1179.495n 0.0v 1179.505n 0.0v 1189.495n 0.0v 1189.505n 0.0v 1199.495n 0.0v 1199.505n 0.0v 1209.495n 0.0v 1209.505n 0.0v 1219.495n 0.0v 1219.505n 0.0v 1229.495n 0.0v 1229.505n 0.0v 1239.495n 0.0v 1239.505n 3.3v 1249.495n 3.3v 1249.505n 0.0v 1259.495n 0.0v 1259.505n 0.0v 1269.495n 0.0v 1269.505n 0.0v 1279.495n 0.0v 1279.505n 0.0v 1289.495n 0.0v 1289.505n 0.0v 1299.495n 0.0v 1299.505n 0.0v 1309.495n 0.0v 1309.505n 0.0v 1319.495n 0.0v 1319.505n 3.3v 1329.495n 3.3v 1329.505n 3.3v 1339.495n 3.3v 1339.505n 3.3v 1349.495n 3.3v 1349.505n 3.3v 1359.495n 3.3v 1359.505n 0.0v 1369.495n 0.0v 1369.505n 0.0v 1379.495n 0.0v 1379.505n 0.0v 1389.495n 0.0v 1389.505n 3.3v 1399.495n 3.3v 1399.505n 3.3v 1409.495n 3.3v 1409.505n 3.3v 1419.495n 3.3v 1419.505n 3.3v 1429.495n 3.3v 1429.505n 3.3v 1439.495n 3.3v 1439.505n 3.3v 1449.495n 3.3v 1449.505n 3.3v 1459.495n 3.3v 1459.505n 3.3v 1469.495n 3.3v 1469.505n 0.0v 1479.495n 0.0v 1479.505n 0.0v 1489.495n 0.0v 1489.505n 0.0v 1499.495n 0.0v 1499.505n 0.0v 1509.495n 0.0v 1509.505n 0.0v 1519.495n 0.0v 1519.505n 0.0v 1529.495n 0.0v 1529.505n 0.0v 1539.495n 0.0v 1539.505n 0.0v 1549.495n 0.0v 1549.505n 3.3v 1559.495n 3.3v 1559.505n 3.3v 1569.495n 3.3v 1569.505n 0.0v 1579.495n 0.0v 1579.505n 0.0v 1589.495n 0.0v 1589.505n 0.0v 1599.495n 0.0v 1599.505n 0.0v 1609.495n 0.0v 1609.505n 0.0v 1619.495n 0.0v 1619.505n 0.0v 1629.495n 0.0v 1629.505n 3.3v 1639.495n 3.3v 1639.505n 3.3v 1649.495n 3.3v 1649.505n 3.3v 1659.495n 3.3v 1659.505n 3.3v 1669.495n 3.3v 1669.505n 3.3v 1679.495n 3.3v 1679.505n 0.0v 1689.495n 0.0v 1689.505n 0.0v 1699.495n 0.0v 1699.505n 0.0v 1709.495n 0.0v 1709.505n 0.0v 1719.495n 0.0v 1719.505n 0.0v 1729.495n 0.0v 1729.505n 0.0v 1739.495n 0.0v 1739.505n 0.0v 1749.495n 0.0v 1749.505n 0.0v 1759.495n 0.0v 1759.505n 0.0v 1769.495n 0.0v 1769.505n 3.3v 1779.495n 3.3v 1779.505n 3.3v 1789.495n 3.3v 1789.505n 0.0v 1799.495n 0.0v 1799.505n 0.0v 1809.495n 0.0v 1809.505n 0.0v 1819.495n 0.0v 1819.505n 0.0v 1829.495n 0.0v 1829.505n 0.0v 1839.495n 0.0v 1839.505n 0.0v 1849.495n 0.0v 1849.505n 0.0v 1859.495n 0.0v 1859.505n 0.0v 1869.495n 0.0v 1869.505n 0.0v 1879.495n 0.0v 1879.505n 0.0v 1889.495n 0.0v 1889.505n 0.0v 1899.495n 0.0v 1899.505n 0.0v 1909.495n 0.0v 1909.505n 0.0v 1919.495n 0.0v 1919.505n 0.0v 1929.495n 0.0v 1929.505n 0.0v 1939.495n 0.0v 1939.505n 0.0v 1949.495n 0.0v 1949.505n 3.3v 1959.495n 3.3v 1959.505n 3.3v 1969.495n 3.3v 1969.505n 3.3v 1979.495n 3.3v 1979.505n 0.0v 1989.495n 0.0v 1989.505n 0.0v 1999.495n 0.0v 1999.505n 0.0v 2009.495n 0.0v 2009.505n 0.0v 2019.495n 0.0v 2019.505n 3.3v 2029.495n 3.3v 2029.505n 3.3v 2039.495n 3.3v 2039.505n 3.3v 2049.495n 3.3v 2049.505n 3.3v )
* (time, data): [(0, 0), (10, 0), (20, 1), (30, 0), (40, 0), (50, 0), (60, 1), (70, 1), (80, 1), (90, 1), (100, 0), (110, 0), (120, 0), (130, 0), (140, 0), (150, 1), (160, 1), (170, 1), (180, 1), (190, 1), (200, 1), (210, 1), (220, 1), (230, 0), (240, 0), (250, 0), (260, 0), (270, 0), (280, 0), (290, 0), (300, 0), (310, 0), (320, 0), (330, 1), (340, 1), (350, 1), (360, 0), (370, 0), (380, 0), (390, 0), (400, 0), (410, 0), (420, 0), (430, 0), (440, 1), (450, 1), (460, 1), (470, 1), (480, 1), (490, 1), (500, 1), (510, 1), (520, 1), (530, 1), (540, 1), (550, 1), (560, 1), (570, 1), (580, 1), (590, 1), (600, 1), (610, 0), (620, 0), (630, 0), (640, 0), (650, 0), (660, 0), (670, 0), (680, 0), (690, 0), (700, 0), (710, 0), (720, 0), (730, 0), (740, 1), (750, 0), (760, 0), (770, 1), (780, 1), (790, 1), (800, 0), (810, 0), (820, 0), (830, 0), (840, 1), (850, 1), (860, 1), (870, 1), (880, 1), (890, 1), (900, 1), (910, 1), (920, 1), (930, 1), (940, 0), (950, 0), (960, 1), (970, 1), (980, 1), (990, 1), (1000, 0), (1010, 0), (1020, 0), (1030, 0), (1040, 0), (1050, 0), (1060, 0), (1070, 0), (1080, 1), (1090, 1), (1100, 1), (1110, 1), (1120, 1), (1130, 1), (1140, 1), (1150, 1), (1160, 1), (1170, 1), (1180, 1), (1190, 1), (1200, 1), (1210, 1), (1220, 1), (1230, 1), (1240, 0), (1250, 0), (1260, 0), (1270, 0), (1280, 0), (1290, 0), (1300, 0), (1310, 0), (1320, 0), (1330, 0), (1340, 1), (1350, 1), (1360, 0), (1370, 0), (1380, 0), (1390, 1), (1400, 1), (1410, 1), (1420, 1), (1430, 0), (1440, 1), (1450, 1), (1460, 1), (1470, 0), (1480, 0), (1490, 0), (1500, 0), (1510, 0), (1520, 0), (1530, 0), (1540, 0), (1550, 1), (1560, 1), (1570, 0), (1580, 0), (1590, 0), (1600, 0), (1610, 1), (1620, 1), (1630, 0), (1640, 0), (1650, 0), (1660, 0), (1670, 0), (1680, 0), (1690, 0), (1700, 0), (1710, 0), (1720, 0), (1730, 0), (1740, 0), (1750, 0), (1760, 0), (1770, 0), (1780, 0), (1790, 0), (1800, 0), (1810, 0), (1820, 0), (1830, 0), (1840, 0), (1850, 0), (1860, 0), (1870, 0), (1880, 0), (1890, 0), (1900, 0), (1910, 0), (1920, 0), (1930, 0), (1940, 0), (1950, 1), (1960, 1), (1970, 1), (1980, 0), (1990, 0), (2000, 0), (2010, 0), (2020, 1), (2030, 1), (2040, 1), (2050, 1)]
Vdin1_3  din1_3  0 PWL (0n 0.0v 9.495n 0.0v 9.505n 0.0v 19.495n 0.0v 19.505n 3.3v 29.495n 3.3v 29.505n 0.0v 39.495n 0.0v 39.505n 0.0v 49.495n 0.0v 49.505n 0.0v 59.495n 0.0v 59.505n 3.3v 69.495n 3.3v 69.505n 3.3v 79.495n 3.3v 79.505n 3.3v 89.495n 3.3v 89.505n 3.3v 99.495n 3.3v 99.505n 0.0v 109.495n 0.0v 109.505n 0.0v 119.495n 0.0v 119.505n 0.0v 129.495n 0.0v 129.505n 0.0v 139.495n 0.0v 139.505n 0.0v 149.495n 0.0v 149.505n 3.3v 159.495n 3.3v 159.505n 3.3v 169.495n 3.3v 169.505n 3.3v 179.495n 3.3v 179.505n 3.3v 189.495n 3.3v 189.505n 3.3v 199.495n 3.3v 199.505n 3.3v 209.495n 3.3v 209.505n 3.3v 219.495n 3.3v 219.505n 3.3v 229.495n 3.3v 229.505n 0.0v 239.495n 0.0v 239.505n 0.0v 249.495n 0.0v 249.505n 0.0v 259.495n 0.0v 259.505n 0.0v 269.495n 0.0v 269.505n 0.0v 279.495n 0.0v 279.505n 0.0v 289.495n 0.0v 289.505n 0.0v 299.495n 0.0v 299.505n 0.0v 309.495n 0.0v 309.505n 0.0v 319.495n 0.0v 319.505n 0.0v 329.495n 0.0v 329.505n 3.3v 339.495n 3.3v 339.505n 3.3v 349.495n 3.3v 349.505n 3.3v 359.495n 3.3v 359.505n 0.0v 369.495n 0.0v 369.505n 0.0v 379.495n 0.0v 379.505n 0.0v 389.495n 0.0v 389.505n 0.0v 399.495n 0.0v 399.505n 0.0v 409.495n 0.0v 409.505n 0.0v 419.495n 0.0v 419.505n 0.0v 429.495n 0.0v 429.505n 0.0v 439.495n 0.0v 439.505n 3.3v 449.495n 3.3v 449.505n 3.3v 459.495n 3.3v 459.505n 3.3v 469.495n 3.3v 469.505n 3.3v 479.495n 3.3v 479.505n 3.3v 489.495n 3.3v 489.505n 3.3v 499.495n 3.3v 499.505n 3.3v 509.495n 3.3v 509.505n 3.3v 519.495n 3.3v 519.505n 3.3v 529.495n 3.3v 529.505n 3.3v 539.495n 3.3v 539.505n 3.3v 549.495n 3.3v 549.505n 3.3v 559.495n 3.3v 559.505n 3.3v 569.495n 3.3v 569.505n 3.3v 579.495n 3.3v 579.505n 3.3v 589.495n 3.3v 589.505n 3.3v 599.495n 3.3v 599.505n 3.3v 609.495n 3.3v 609.505n 0.0v 619.495n 0.0v 619.505n 0.0v 629.495n 0.0v 629.505n 0.0v 639.495n 0.0v 639.505n 0.0v 649.495n 0.0v 649.505n 0.0v 659.495n 0.0v 659.505n 0.0v 669.495n 0.0v 669.505n 0.0v 679.495n 0.0v 679.505n 0.0v 689.495n 0.0v 689.505n 0.0v 699.495n 0.0v 699.505n 0.0v 709.495n 0.0v 709.505n 0.0v 719.495n 0.0v 719.505n 0.0v 729.495n 0.0v 729.505n 0.0v 739.495n 0.0v 739.505n 3.3v 749.495n 3.3v 749.505n 0.0v 759.495n 0.0v 759.505n 0.0v 769.495n 0.0v 769.505n 3.3v 779.495n 3.3v 779.505n 3.3v 789.495n 3.3v 789.505n 3.3v 799.495n 3.3v 799.505n 0.0v 809.495n 0.0v 809.505n 0.0v 819.495n 0.0v 819.505n 0.0v 829.495n 0.0v 829.505n 0.0v 839.495n 0.0v 839.505n 3.3v 849.495n 3.3v 849.505n 3.3v 859.495n 3.3v 859.505n 3.3v 869.495n 3.3v 869.505n 3.3v 879.495n 3.3v 879.505n 3.3v 889.495n 3.3v 889.505n 3.3v 899.495n 3.3v 899.505n 3.3v 909.495n 3.3v 909.505n 3.3v 919.495n 3.3v 919.505n 3.3v 929.495n 3.3v 929.505n 3.3v 939.495n 3.3v 939.505n 0.0v 949.495n 0.0v 949.505n 0.0v 959.495n 0.0v 959.505n 3.3v 969.495n 3.3v 969.505n 3.3v 979.495n 3.3v 979.505n 3.3v 989.495n 3.3v 989.505n 3.3v 999.495n 3.3v 999.505n 0.0v 1009.495n 0.0v 1009.505n 0.0v 1019.495n 0.0v 1019.505n 0.0v 1029.495n 0.0v 1029.505n 0.0v 1039.495n 0.0v 1039.505n 0.0v 1049.495n 0.0v 1049.505n 0.0v 1059.495n 0.0v 1059.505n 0.0v 1069.495n 0.0v 1069.505n 0.0v 1079.495n 0.0v 1079.505n 3.3v 1089.495n 3.3v 1089.505n 3.3v 1099.495n 3.3v 1099.505n 3.3v 1109.495n 3.3v 1109.505n 3.3v 1119.495n 3.3v 1119.505n 3.3v 1129.495n 3.3v 1129.505n 3.3v 1139.495n 3.3v 1139.505n 3.3v 1149.495n 3.3v 1149.505n 3.3v 1159.495n 3.3v 1159.505n 3.3v 1169.495n 3.3v 1169.505n 3.3v 1179.495n 3.3v 1179.505n 3.3v 1189.495n 3.3v 1189.505n 3.3v 1199.495n 3.3v 1199.505n 3.3v 1209.495n 3.3v 1209.505n 3.3v 1219.495n 3.3v 1219.505n 3.3v 1229.495n 3.3v 1229.505n 3.3v 1239.495n 3.3v 1239.505n 0.0v 1249.495n 0.0v 1249.505n 0.0v 1259.495n 0.0v 1259.505n 0.0v 1269.495n 0.0v 1269.505n 0.0v 1279.495n 0.0v 1279.505n 0.0v 1289.495n 0.0v 1289.505n 0.0v 1299.495n 0.0v 1299.505n 0.0v 1309.495n 0.0v 1309.505n 0.0v 1319.495n 0.0v 1319.505n 0.0v 1329.495n 0.0v 1329.505n 0.0v 1339.495n 0.0v 1339.505n 3.3v 1349.495n 3.3v 1349.505n 3.3v 1359.495n 3.3v 1359.505n 0.0v 1369.495n 0.0v 1369.505n 0.0v 1379.495n 0.0v 1379.505n 0.0v 1389.495n 0.0v 1389.505n 3.3v 1399.495n 3.3v 1399.505n 3.3v 1409.495n 3.3v 1409.505n 3.3v 1419.495n 3.3v 1419.505n 3.3v 1429.495n 3.3v 1429.505n 0.0v 1439.495n 0.0v 1439.505n 3.3v 1449.495n 3.3v 1449.505n 3.3v 1459.495n 3.3v 1459.505n 3.3v 1469.495n 3.3v 1469.505n 0.0v 1479.495n 0.0v 1479.505n 0.0v 1489.495n 0.0v 1489.505n 0.0v 1499.495n 0.0v 1499.505n 0.0v 1509.495n 0.0v 1509.505n 0.0v 1519.495n 0.0v 1519.505n 0.0v 1529.495n 0.0v 1529.505n 0.0v 1539.495n 0.0v 1539.505n 0.0v 1549.495n 0.0v 1549.505n 3.3v 1559.495n 3.3v 1559.505n 3.3v 1569.495n 3.3v 1569.505n 0.0v 1579.495n 0.0v 1579.505n 0.0v 1589.495n 0.0v 1589.505n 0.0v 1599.495n 0.0v 1599.505n 0.0v 1609.495n 0.0v 1609.505n 3.3v 1619.495n 3.3v 1619.505n 3.3v 1629.495n 3.3v 1629.505n 0.0v 1639.495n 0.0v 1639.505n 0.0v 1649.495n 0.0v 1649.505n 0.0v 1659.495n 0.0v 1659.505n 0.0v 1669.495n 0.0v 1669.505n 0.0v 1679.495n 0.0v 1679.505n 0.0v 1689.495n 0.0v 1689.505n 0.0v 1699.495n 0.0v 1699.505n 0.0v 1709.495n 0.0v 1709.505n 0.0v 1719.495n 0.0v 1719.505n 0.0v 1729.495n 0.0v 1729.505n 0.0v 1739.495n 0.0v 1739.505n 0.0v 1749.495n 0.0v 1749.505n 0.0v 1759.495n 0.0v 1759.505n 0.0v 1769.495n 0.0v 1769.505n 0.0v 1779.495n 0.0v 1779.505n 0.0v 1789.495n 0.0v 1789.505n 0.0v 1799.495n 0.0v 1799.505n 0.0v 1809.495n 0.0v 1809.505n 0.0v 1819.495n 0.0v 1819.505n 0.0v 1829.495n 0.0v 1829.505n 0.0v 1839.495n 0.0v 1839.505n 0.0v 1849.495n 0.0v 1849.505n 0.0v 1859.495n 0.0v 1859.505n 0.0v 1869.495n 0.0v 1869.505n 0.0v 1879.495n 0.0v 1879.505n 0.0v 1889.495n 0.0v 1889.505n 0.0v 1899.495n 0.0v 1899.505n 0.0v 1909.495n 0.0v 1909.505n 0.0v 1919.495n 0.0v 1919.505n 0.0v 1929.495n 0.0v 1929.505n 0.0v 1939.495n 0.0v 1939.505n 0.0v 1949.495n 0.0v 1949.505n 3.3v 1959.495n 3.3v 1959.505n 3.3v 1969.495n 3.3v 1969.505n 3.3v 1979.495n 3.3v 1979.505n 0.0v 1989.495n 0.0v 1989.505n 0.0v 1999.495n 0.0v 1999.505n 0.0v 2009.495n 0.0v 2009.505n 0.0v 2019.495n 0.0v 2019.505n 3.3v 2029.495n 3.3v 2029.505n 3.3v 2039.495n 3.3v 2039.505n 3.3v 2049.495n 3.3v 2049.505n 3.3v )
* (time, data): [(0, 0), (10, 0), (20, 1), (30, 1), (40, 1), (50, 0), (60, 0), (70, 1), (80, 1), (90, 1), (100, 1), (110, 1), (120, 1), (130, 1), (140, 1), (150, 0), (160, 0), (170, 0), (180, 1), (190, 1), (200, 1), (210, 1), (220, 1), (230, 0), (240, 0), (250, 0), (260, 0), (270, 0), (280, 0), (290, 0), (300, 0), (310, 0), (320, 0), (330, 0), (340, 0), (350, 0), (360, 1), (370, 1), (380, 1), (390, 1), (400, 1), (410, 1), (420, 1), (430, 1), (440, 1), (450, 1), (460, 1), (470, 1), (480, 1), (490, 1), (500, 1), (510, 1), (520, 1), (530, 1), (540, 0), (550, 0), (560, 0), (570, 0), (580, 0), (590, 0), (600, 0), (610, 0), (620, 0), (630, 0), (640, 0), (650, 0), (660, 0), (670, 0), (680, 0), (690, 1), (700, 1), (710, 1), (720, 1), (730, 1), (740, 0), (750, 0), (760, 0), (770, 0), (780, 0), (790, 0), (800, 0), (810, 0), (820, 0), (830, 0), (840, 0), (850, 0), (860, 0), (870, 0), (880, 0), (890, 0), (900, 0), (910, 1), (920, 1), (930, 1), (940, 0), (950, 0), (960, 0), (970, 0), (980, 0), (990, 0), (1000, 0), (1010, 0), (1020, 0), (1030, 0), (1040, 0), (1050, 0), (1060, 0), (1070, 0), (1080, 0), (1090, 0), (1100, 0), (1110, 0), (1120, 0), (1130, 0), (1140, 0), (1150, 0), (1160, 0), (1170, 0), (1180, 0), (1190, 0), (1200, 0), (1210, 0), (1220, 0), (1230, 0), (1240, 1), (1250, 0), (1260, 0), (1270, 0), (1280, 0), (1290, 0), (1300, 0), (1310, 0), (1320, 0), (1330, 0), (1340, 0), (1350, 0), (1360, 0), (1370, 0), (1380, 0), (1390, 1), (1400, 1), (1410, 1), (1420, 1), (1430, 0), (1440, 0), (1450, 0), (1460, 0), (1470, 0), (1480, 0), (1490, 0), (1500, 0), (1510, 0), (1520, 0), (1530, 0), (1540, 0), (1550, 1), (1560, 1), (1570, 1), (1580, 1), (1590, 1), (1600, 1), (1610, 1), (1620, 1), (1630, 0), (1640, 0), (1650, 0), (1660, 0), (1670, 0), (1680, 1), (1690, 1), (1700, 1), (1710, 1), (1720, 1), (1730, 1), (1740, 1), (1750, 1), (1760, 1), (1770, 1), (1780, 1), (1790, 0), (1800, 0), (1810, 0), (1820, 0), (1830, 0), (1840, 0), (1850, 0), (1860, 0), (1870, 0), (1880, 0), (1890, 0), (1900, 0), (1910, 0), (1920, 0), (1930, 0), (1940, 0), (1950, 0), (1960, 0), (1970, 0), (1980, 1), (1990, 1), (2000, 1), (2010, 1), (2020, 1), (2030, 0), (2040, 0), (2050, 0)]
Vdin1_4  din1_4  0 PWL (0n 0.0v 9.495n 0.0v 9.505n 0.0v 19.495n 0.0v 19.505n 3.3v 29.495n 3.3v 29.505n 3.3v 39.495n 3.3v 39.505n 3.3v 49.495n 3.3v 49.505n 0.0v 59.495n 0.0v 59.505n 0.0v 69.495n 0.0v 69.505n 3.3v 79.495n 3.3v 79.505n 3.3v 89.495n 3.3v 89.505n 3.3v 99.495n 3.3v 99.505n 3.3v 109.495n 3.3v 109.505n 3.3v 119.495n 3.3v 119.505n 3.3v 129.495n 3.3v 129.505n 3.3v 139.495n 3.3v 139.505n 3.3v 149.495n 3.3v 149.505n 0.0v 159.495n 0.0v 159.505n 0.0v 169.495n 0.0v 169.505n 0.0v 179.495n 0.0v 179.505n 3.3v 189.495n 3.3v 189.505n 3.3v 199.495n 3.3v 199.505n 3.3v 209.495n 3.3v 209.505n 3.3v 219.495n 3.3v 219.505n 3.3v 229.495n 3.3v 229.505n 0.0v 239.495n 0.0v 239.505n 0.0v 249.495n 0.0v 249.505n 0.0v 259.495n 0.0v 259.505n 0.0v 269.495n 0.0v 269.505n 0.0v 279.495n 0.0v 279.505n 0.0v 289.495n 0.0v 289.505n 0.0v 299.495n 0.0v 299.505n 0.0v 309.495n 0.0v 309.505n 0.0v 319.495n 0.0v 319.505n 0.0v 329.495n 0.0v 329.505n 0.0v 339.495n 0.0v 339.505n 0.0v 349.495n 0.0v 349.505n 0.0v 359.495n 0.0v 359.505n 3.3v 369.495n 3.3v 369.505n 3.3v 379.495n 3.3v 379.505n 3.3v 389.495n 3.3v 389.505n 3.3v 399.495n 3.3v 399.505n 3.3v 409.495n 3.3v 409.505n 3.3v 419.495n 3.3v 419.505n 3.3v 429.495n 3.3v 429.505n 3.3v 439.495n 3.3v 439.505n 3.3v 449.495n 3.3v 449.505n 3.3v 459.495n 3.3v 459.505n 3.3v 469.495n 3.3v 469.505n 3.3v 479.495n 3.3v 479.505n 3.3v 489.495n 3.3v 489.505n 3.3v 499.495n 3.3v 499.505n 3.3v 509.495n 3.3v 509.505n 3.3v 519.495n 3.3v 519.505n 3.3v 529.495n 3.3v 529.505n 3.3v 539.495n 3.3v 539.505n 0.0v 549.495n 0.0v 549.505n 0.0v 559.495n 0.0v 559.505n 0.0v 569.495n 0.0v 569.505n 0.0v 579.495n 0.0v 579.505n 0.0v 589.495n 0.0v 589.505n 0.0v 599.495n 0.0v 599.505n 0.0v 609.495n 0.0v 609.505n 0.0v 619.495n 0.0v 619.505n 0.0v 629.495n 0.0v 629.505n 0.0v 639.495n 0.0v 639.505n 0.0v 649.495n 0.0v 649.505n 0.0v 659.495n 0.0v 659.505n 0.0v 669.495n 0.0v 669.505n 0.0v 679.495n 0.0v 679.505n 0.0v 689.495n 0.0v 689.505n 3.3v 699.495n 3.3v 699.505n 3.3v 709.495n 3.3v 709.505n 3.3v 719.495n 3.3v 719.505n 3.3v 729.495n 3.3v 729.505n 3.3v 739.495n 3.3v 739.505n 0.0v 749.495n 0.0v 749.505n 0.0v 759.495n 0.0v 759.505n 0.0v 769.495n 0.0v 769.505n 0.0v 779.495n 0.0v 779.505n 0.0v 789.495n 0.0v 789.505n 0.0v 799.495n 0.0v 799.505n 0.0v 809.495n 0.0v 809.505n 0.0v 819.495n 0.0v 819.505n 0.0v 829.495n 0.0v 829.505n 0.0v 839.495n 0.0v 839.505n 0.0v 849.495n 0.0v 849.505n 0.0v 859.495n 0.0v 859.505n 0.0v 869.495n 0.0v 869.505n 0.0v 879.495n 0.0v 879.505n 0.0v 889.495n 0.0v 889.505n 0.0v 899.495n 0.0v 899.505n 0.0v 909.495n 0.0v 909.505n 3.3v 919.495n 3.3v 919.505n 3.3v 929.495n 3.3v 929.505n 3.3v 939.495n 3.3v 939.505n 0.0v 949.495n 0.0v 949.505n 0.0v 959.495n 0.0v 959.505n 0.0v 969.495n 0.0v 969.505n 0.0v 979.495n 0.0v 979.505n 0.0v 989.495n 0.0v 989.505n 0.0v 999.495n 0.0v 999.505n 0.0v 1009.495n 0.0v 1009.505n 0.0v 1019.495n 0.0v 1019.505n 0.0v 1029.495n 0.0v 1029.505n 0.0v 1039.495n 0.0v 1039.505n 0.0v 1049.495n 0.0v 1049.505n 0.0v 1059.495n 0.0v 1059.505n 0.0v 1069.495n 0.0v 1069.505n 0.0v 1079.495n 0.0v 1079.505n 0.0v 1089.495n 0.0v 1089.505n 0.0v 1099.495n 0.0v 1099.505n 0.0v 1109.495n 0.0v 1109.505n 0.0v 1119.495n 0.0v 1119.505n 0.0v 1129.495n 0.0v 1129.505n 0.0v 1139.495n 0.0v 1139.505n 0.0v 1149.495n 0.0v 1149.505n 0.0v 1159.495n 0.0v 1159.505n 0.0v 1169.495n 0.0v 1169.505n 0.0v 1179.495n 0.0v 1179.505n 0.0v 1189.495n 0.0v 1189.505n 0.0v 1199.495n 0.0v 1199.505n 0.0v 1209.495n 0.0v 1209.505n 0.0v 1219.495n 0.0v 1219.505n 0.0v 1229.495n 0.0v 1229.505n 0.0v 1239.495n 0.0v 1239.505n 3.3v 1249.495n 3.3v 1249.505n 0.0v 1259.495n 0.0v 1259.505n 0.0v 1269.495n 0.0v 1269.505n 0.0v 1279.495n 0.0v 1279.505n 0.0v 1289.495n 0.0v 1289.505n 0.0v 1299.495n 0.0v 1299.505n 0.0v 1309.495n 0.0v 1309.505n 0.0v 1319.495n 0.0v 1319.505n 0.0v 1329.495n 0.0v 1329.505n 0.0v 1339.495n 0.0v 1339.505n 0.0v 1349.495n 0.0v 1349.505n 0.0v 1359.495n 0.0v 1359.505n 0.0v 1369.495n 0.0v 1369.505n 0.0v 1379.495n 0.0v 1379.505n 0.0v 1389.495n 0.0v 1389.505n 3.3v 1399.495n 3.3v 1399.505n 3.3v 1409.495n 3.3v 1409.505n 3.3v 1419.495n 3.3v 1419.505n 3.3v 1429.495n 3.3v 1429.505n 0.0v 1439.495n 0.0v 1439.505n 0.0v 1449.495n 0.0v 1449.505n 0.0v 1459.495n 0.0v 1459.505n 0.0v 1469.495n 0.0v 1469.505n 0.0v 1479.495n 0.0v 1479.505n 0.0v 1489.495n 0.0v 1489.505n 0.0v 1499.495n 0.0v 1499.505n 0.0v 1509.495n 0.0v 1509.505n 0.0v 1519.495n 0.0v 1519.505n 0.0v 1529.495n 0.0v 1529.505n 0.0v 1539.495n 0.0v 1539.505n 0.0v 1549.495n 0.0v 1549.505n 3.3v 1559.495n 3.3v 1559.505n 3.3v 1569.495n 3.3v 1569.505n 3.3v 1579.495n 3.3v 1579.505n 3.3v 1589.495n 3.3v 1589.505n 3.3v 1599.495n 3.3v 1599.505n 3.3v 1609.495n 3.3v 1609.505n 3.3v 1619.495n 3.3v 1619.505n 3.3v 1629.495n 3.3v 1629.505n 0.0v 1639.495n 0.0v 1639.505n 0.0v 1649.495n 0.0v 1649.505n 0.0v 1659.495n 0.0v 1659.505n 0.0v 1669.495n 0.0v 1669.505n 0.0v 1679.495n 0.0v 1679.505n 3.3v 1689.495n 3.3v 1689.505n 3.3v 1699.495n 3.3v 1699.505n 3.3v 1709.495n 3.3v 1709.505n 3.3v 1719.495n 3.3v 1719.505n 3.3v 1729.495n 3.3v 1729.505n 3.3v 1739.495n 3.3v 1739.505n 3.3v 1749.495n 3.3v 1749.505n 3.3v 1759.495n 3.3v 1759.505n 3.3v 1769.495n 3.3v 1769.505n 3.3v 1779.495n 3.3v 1779.505n 3.3v 1789.495n 3.3v 1789.505n 0.0v 1799.495n 0.0v 1799.505n 0.0v 1809.495n 0.0v 1809.505n 0.0v 1819.495n 0.0v 1819.505n 0.0v 1829.495n 0.0v 1829.505n 0.0v 1839.495n 0.0v 1839.505n 0.0v 1849.495n 0.0v 1849.505n 0.0v 1859.495n 0.0v 1859.505n 0.0v 1869.495n 0.0v 1869.505n 0.0v 1879.495n 0.0v 1879.505n 0.0v 1889.495n 0.0v 1889.505n 0.0v 1899.495n 0.0v 1899.505n 0.0v 1909.495n 0.0v 1909.505n 0.0v 1919.495n 0.0v 1919.505n 0.0v 1929.495n 0.0v 1929.505n 0.0v 1939.495n 0.0v 1939.505n 0.0v 1949.495n 0.0v 1949.505n 0.0v 1959.495n 0.0v 1959.505n 0.0v 1969.495n 0.0v 1969.505n 0.0v 1979.495n 0.0v 1979.505n 3.3v 1989.495n 3.3v 1989.505n 3.3v 1999.495n 3.3v 1999.505n 3.3v 2009.495n 3.3v 2009.505n 3.3v 2019.495n 3.3v 2019.505n 3.3v 2029.495n 3.3v 2029.505n 0.0v 2039.495n 0.0v 2039.505n 0.0v 2049.495n 0.0v 2049.505n 0.0v )
* (time, data): [(0, 0), (10, 1), (20, 1), (30, 0), (40, 0), (50, 0), (60, 0), (70, 0), (80, 0), (90, 0), (100, 0), (110, 0), (120, 0), (130, 0), (140, 0), (150, 1), (160, 1), (170, 1), (180, 1), (190, 1), (200, 1), (210, 1), (220, 1), (230, 0), (240, 0), (250, 0), (260, 0), (270, 0), (280, 0), (290, 0), (300, 0), (310, 0), (320, 0), (330, 1), (340, 1), (350, 1), (360, 1), (370, 1), (380, 1), (390, 1), (400, 1), (410, 1), (420, 1), (430, 1), (440, 1), (450, 1), (460, 1), (470, 1), (480, 1), (490, 1), (500, 1), (510, 1), (520, 1), (530, 1), (540, 0), (550, 0), (560, 0), (570, 0), (580, 0), (590, 0), (600, 0), (610, 0), (620, 0), (630, 1), (640, 1), (650, 1), (660, 1), (670, 1), (680, 1), (690, 1), (700, 1), (710, 1), (720, 1), (730, 1), (740, 1), (750, 0), (760, 0), (770, 0), (780, 0), (790, 0), (800, 0), (810, 0), (820, 0), (830, 0), (840, 1), (850, 1), (860, 1), (870, 1), (880, 1), (890, 1), (900, 1), (910, 1), (920, 1), (930, 1), (940, 1), (950, 1), (960, 0), (970, 0), (980, 0), (990, 0), (1000, 0), (1010, 0), (1020, 0), (1030, 0), (1040, 0), (1050, 0), (1060, 0), (1070, 0), (1080, 1), (1090, 0), (1100, 0), (1110, 0), (1120, 0), (1130, 0), (1140, 0), (1150, 0), (1160, 0), (1170, 0), (1180, 0), (1190, 0), (1200, 0), (1210, 0), (1220, 0), (1230, 0), (1240, 0), (1250, 0), (1260, 0), (1270, 0), (1280, 1), (1290, 1), (1300, 1), (1310, 1), (1320, 1), (1330, 1), (1340, 1), (1350, 1), (1360, 0), (1370, 0), (1380, 0), (1390, 1), (1400, 1), (1410, 1), (1420, 1), (1430, 0), (1440, 1), (1450, 1), (1460, 1), (1470, 0), (1480, 1), (1490, 1), (1500, 1), (1510, 1), (1520, 1), (1530, 1), (1540, 1), (1550, 1), (1560, 1), (1570, 1), (1580, 1), (1590, 1), (1600, 1), (1610, 1), (1620, 1), (1630, 1), (1640, 1), (1650, 1), (1660, 0), (1670, 0), (1680, 1), (1690, 1), (1700, 1), (1710, 1), (1720, 1), (1730, 1), (1740, 1), (1750, 1), (1760, 1), (1770, 0), (1780, 0), (1790, 1), (1800, 1), (1810, 1), (1820, 1), (1830, 1), (1840, 1), (1850, 1), (1860, 1), (1870, 1), (1880, 1), (1890, 1), (1900, 1), (1910, 1), (1920, 1), (1930, 1), (1940, 1), (1950, 0), (1960, 0), (1970, 0), (1980, 0), (1990, 0), (2000, 0), (2010, 0), (2020, 1), (2030, 0), (2040, 0), (2050, 0)]
Vdin1_5  din1_5  0 PWL (0n 0.0v 9.495n 0.0v 9.505n 3.3v 19.495n 3.3v 19.505n 3.3v 29.495n 3.3v 29.505n 0.0v 39.495n 0.0v 39.505n 0.0v 49.495n 0.0v 49.505n 0.0v 59.495n 0.0v 59.505n 0.0v 69.495n 0.0v 69.505n 0.0v 79.495n 0.0v 79.505n 0.0v 89.495n 0.0v 89.505n 0.0v 99.495n 0.0v 99.505n 0.0v 109.495n 0.0v 109.505n 0.0v 119.495n 0.0v 119.505n 0.0v 129.495n 0.0v 129.505n 0.0v 139.495n 0.0v 139.505n 0.0v 149.495n 0.0v 149.505n 3.3v 159.495n 3.3v 159.505n 3.3v 169.495n 3.3v 169.505n 3.3v 179.495n 3.3v 179.505n 3.3v 189.495n 3.3v 189.505n 3.3v 199.495n 3.3v 199.505n 3.3v 209.495n 3.3v 209.505n 3.3v 219.495n 3.3v 219.505n 3.3v 229.495n 3.3v 229.505n 0.0v 239.495n 0.0v 239.505n 0.0v 249.495n 0.0v 249.505n 0.0v 259.495n 0.0v 259.505n 0.0v 269.495n 0.0v 269.505n 0.0v 279.495n 0.0v 279.505n 0.0v 289.495n 0.0v 289.505n 0.0v 299.495n 0.0v 299.505n 0.0v 309.495n 0.0v 309.505n 0.0v 319.495n 0.0v 319.505n 0.0v 329.495n 0.0v 329.505n 3.3v 339.495n 3.3v 339.505n 3.3v 349.495n 3.3v 349.505n 3.3v 359.495n 3.3v 359.505n 3.3v 369.495n 3.3v 369.505n 3.3v 379.495n 3.3v 379.505n 3.3v 389.495n 3.3v 389.505n 3.3v 399.495n 3.3v 399.505n 3.3v 409.495n 3.3v 409.505n 3.3v 419.495n 3.3v 419.505n 3.3v 429.495n 3.3v 429.505n 3.3v 439.495n 3.3v 439.505n 3.3v 449.495n 3.3v 449.505n 3.3v 459.495n 3.3v 459.505n 3.3v 469.495n 3.3v 469.505n 3.3v 479.495n 3.3v 479.505n 3.3v 489.495n 3.3v 489.505n 3.3v 499.495n 3.3v 499.505n 3.3v 509.495n 3.3v 509.505n 3.3v 519.495n 3.3v 519.505n 3.3v 529.495n 3.3v 529.505n 3.3v 539.495n 3.3v 539.505n 0.0v 549.495n 0.0v 549.505n 0.0v 559.495n 0.0v 559.505n 0.0v 569.495n 0.0v 569.505n 0.0v 579.495n 0.0v 579.505n 0.0v 589.495n 0.0v 589.505n 0.0v 599.495n 0.0v 599.505n 0.0v 609.495n 0.0v 609.505n 0.0v 619.495n 0.0v 619.505n 0.0v 629.495n 0.0v 629.505n 3.3v 639.495n 3.3v 639.505n 3.3v 649.495n 3.3v 649.505n 3.3v 659.495n 3.3v 659.505n 3.3v 669.495n 3.3v 669.505n 3.3v 679.495n 3.3v 679.505n 3.3v 689.495n 3.3v 689.505n 3.3v 699.495n 3.3v 699.505n 3.3v 709.495n 3.3v 709.505n 3.3v 719.495n 3.3v 719.505n 3.3v 729.495n 3.3v 729.505n 3.3v 739.495n 3.3v 739.505n 3.3v 749.495n 3.3v 749.505n 0.0v 759.495n 0.0v 759.505n 0.0v 769.495n 0.0v 769.505n 0.0v 779.495n 0.0v 779.505n 0.0v 789.495n 0.0v 789.505n 0.0v 799.495n 0.0v 799.505n 0.0v 809.495n 0.0v 809.505n 0.0v 819.495n 0.0v 819.505n 0.0v 829.495n 0.0v 829.505n 0.0v 839.495n 0.0v 839.505n 3.3v 849.495n 3.3v 849.505n 3.3v 859.495n 3.3v 859.505n 3.3v 869.495n 3.3v 869.505n 3.3v 879.495n 3.3v 879.505n 3.3v 889.495n 3.3v 889.505n 3.3v 899.495n 3.3v 899.505n 3.3v 909.495n 3.3v 909.505n 3.3v 919.495n 3.3v 919.505n 3.3v 929.495n 3.3v 929.505n 3.3v 939.495n 3.3v 939.505n 3.3v 949.495n 3.3v 949.505n 3.3v 959.495n 3.3v 959.505n 0.0v 969.495n 0.0v 969.505n 0.0v 979.495n 0.0v 979.505n 0.0v 989.495n 0.0v 989.505n 0.0v 999.495n 0.0v 999.505n 0.0v 1009.495n 0.0v 1009.505n 0.0v 1019.495n 0.0v 1019.505n 0.0v 1029.495n 0.0v 1029.505n 0.0v 1039.495n 0.0v 1039.505n 0.0v 1049.495n 0.0v 1049.505n 0.0v 1059.495n 0.0v 1059.505n 0.0v 1069.495n 0.0v 1069.505n 0.0v 1079.495n 0.0v 1079.505n 3.3v 1089.495n 3.3v 1089.505n 0.0v 1099.495n 0.0v 1099.505n 0.0v 1109.495n 0.0v 1109.505n 0.0v 1119.495n 0.0v 1119.505n 0.0v 1129.495n 0.0v 1129.505n 0.0v 1139.495n 0.0v 1139.505n 0.0v 1149.495n 0.0v 1149.505n 0.0v 1159.495n 0.0v 1159.505n 0.0v 1169.495n 0.0v 1169.505n 0.0v 1179.495n 0.0v 1179.505n 0.0v 1189.495n 0.0v 1189.505n 0.0v 1199.495n 0.0v 1199.505n 0.0v 1209.495n 0.0v 1209.505n 0.0v 1219.495n 0.0v 1219.505n 0.0v 1229.495n 0.0v 1229.505n 0.0v 1239.495n 0.0v 1239.505n 0.0v 1249.495n 0.0v 1249.505n 0.0v 1259.495n 0.0v 1259.505n 0.0v 1269.495n 0.0v 1269.505n 0.0v 1279.495n 0.0v 1279.505n 3.3v 1289.495n 3.3v 1289.505n 3.3v 1299.495n 3.3v 1299.505n 3.3v 1309.495n 3.3v 1309.505n 3.3v 1319.495n 3.3v 1319.505n 3.3v 1329.495n 3.3v 1329.505n 3.3v 1339.495n 3.3v 1339.505n 3.3v 1349.495n 3.3v 1349.505n 3.3v 1359.495n 3.3v 1359.505n 0.0v 1369.495n 0.0v 1369.505n 0.0v 1379.495n 0.0v 1379.505n 0.0v 1389.495n 0.0v 1389.505n 3.3v 1399.495n 3.3v 1399.505n 3.3v 1409.495n 3.3v 1409.505n 3.3v 1419.495n 3.3v 1419.505n 3.3v 1429.495n 3.3v 1429.505n 0.0v 1439.495n 0.0v 1439.505n 3.3v 1449.495n 3.3v 1449.505n 3.3v 1459.495n 3.3v 1459.505n 3.3v 1469.495n 3.3v 1469.505n 0.0v 1479.495n 0.0v 1479.505n 3.3v 1489.495n 3.3v 1489.505n 3.3v 1499.495n 3.3v 1499.505n 3.3v 1509.495n 3.3v 1509.505n 3.3v 1519.495n 3.3v 1519.505n 3.3v 1529.495n 3.3v 1529.505n 3.3v 1539.495n 3.3v 1539.505n 3.3v 1549.495n 3.3v 1549.505n 3.3v 1559.495n 3.3v 1559.505n 3.3v 1569.495n 3.3v 1569.505n 3.3v 1579.495n 3.3v 1579.505n 3.3v 1589.495n 3.3v 1589.505n 3.3v 1599.495n 3.3v 1599.505n 3.3v 1609.495n 3.3v 1609.505n 3.3v 1619.495n 3.3v 1619.505n 3.3v 1629.495n 3.3v 1629.505n 3.3v 1639.495n 3.3v 1639.505n 3.3v 1649.495n 3.3v 1649.505n 3.3v 1659.495n 3.3v 1659.505n 0.0v 1669.495n 0.0v 1669.505n 0.0v 1679.495n 0.0v 1679.505n 3.3v 1689.495n 3.3v 1689.505n 3.3v 1699.495n 3.3v 1699.505n 3.3v 1709.495n 3.3v 1709.505n 3.3v 1719.495n 3.3v 1719.505n 3.3v 1729.495n 3.3v 1729.505n 3.3v 1739.495n 3.3v 1739.505n 3.3v 1749.495n 3.3v 1749.505n 3.3v 1759.495n 3.3v 1759.505n 3.3v 1769.495n 3.3v 1769.505n 0.0v 1779.495n 0.0v 1779.505n 0.0v 1789.495n 0.0v 1789.505n 3.3v 1799.495n 3.3v 1799.505n 3.3v 1809.495n 3.3v 1809.505n 3.3v 1819.495n 3.3v 1819.505n 3.3v 1829.495n 3.3v 1829.505n 3.3v 1839.495n 3.3v 1839.505n 3.3v 1849.495n 3.3v 1849.505n 3.3v 1859.495n 3.3v 1859.505n 3.3v 1869.495n 3.3v 1869.505n 3.3v 1879.495n 3.3v 1879.505n 3.3v 1889.495n 3.3v 1889.505n 3.3v 1899.495n 3.3v 1899.505n 3.3v 1909.495n 3.3v 1909.505n 3.3v 1919.495n 3.3v 1919.505n 3.3v 1929.495n 3.3v 1929.505n 3.3v 1939.495n 3.3v 1939.505n 3.3v 1949.495n 3.3v 1949.505n 0.0v 1959.495n 0.0v 1959.505n 0.0v 1969.495n 0.0v 1969.505n 0.0v 1979.495n 0.0v 1979.505n 0.0v 1989.495n 0.0v 1989.505n 0.0v 1999.495n 0.0v 1999.505n 0.0v 2009.495n 0.0v 2009.505n 0.0v 2019.495n 0.0v 2019.505n 3.3v 2029.495n 3.3v 2029.505n 0.0v 2039.495n 0.0v 2039.505n 0.0v 2049.495n 0.0v 2049.505n 0.0v )
* (time, data): [(0, 0), (10, 0), (20, 0), (30, 1), (40, 1), (50, 1), (60, 1), (70, 0), (80, 0), (90, 0), (100, 0), (110, 0), (120, 0), (130, 0), (140, 0), (150, 0), (160, 1), (170, 1), (180, 1), (190, 1), (200, 1), (210, 1), (220, 1), (230, 0), (240, 0), (250, 0), (260, 0), (270, 0), (280, 0), (290, 0), (300, 0), (310, 0), (320, 0), (330, 1), (340, 1), (350, 1), (360, 0), (370, 0), (380, 0), (390, 0), (400, 0), (410, 0), (420, 0), (430, 0), (440, 0), (450, 0), (460, 0), (470, 0), (480, 0), (490, 0), (500, 0), (510, 0), (520, 0), (530, 0), (540, 1), (550, 1), (560, 1), (570, 1), (580, 1), (590, 1), (600, 1), (610, 1), (620, 1), (630, 0), (640, 0), (650, 0), (660, 0), (670, 0), (680, 0), (690, 0), (700, 0), (710, 0), (720, 0), (730, 0), (740, 1), (750, 1), (760, 1), (770, 1), (780, 1), (790, 1), (800, 0), (810, 0), (820, 1), (830, 1), (840, 0), (850, 0), (860, 0), (870, 0), (880, 0), (890, 0), (900, 0), (910, 0), (920, 0), (930, 0), (940, 0), (950, 0), (960, 1), (970, 1), (980, 1), (990, 1), (1000, 0), (1010, 0), (1020, 0), (1030, 0), (1040, 0), (1050, 0), (1060, 0), (1070, 0), (1080, 0), (1090, 0), (1100, 0), (1110, 0), (1120, 0), (1130, 0), (1140, 0), (1150, 0), (1160, 0), (1170, 0), (1180, 0), (1190, 0), (1200, 0), (1210, 0), (1220, 0), (1230, 0), (1240, 0), (1250, 0), (1260, 0), (1270, 0), (1280, 1), (1290, 1), (1300, 1), (1310, 1), (1320, 1), (1330, 1), (1340, 0), (1350, 0), (1360, 0), (1370, 0), (1380, 0), (1390, 1), (1400, 1), (1410, 1), (1420, 1), (1430, 0), (1440, 1), (1450, 1), (1460, 1), (1470, 1), (1480, 1), (1490, 1), (1500, 1), (1510, 1), (1520, 1), (1530, 1), (1540, 1), (1550, 1), (1560, 1), (1570, 1), (1580, 1), (1590, 1), (1600, 1), (1610, 1), (1620, 1), (1630, 1), (1640, 1), (1650, 1), (1660, 0), (1670, 0), (1680, 1), (1690, 1), (1700, 1), (1710, 1), (1720, 1), (1730, 1), (1740, 1), (1750, 1), (1760, 1), (1770, 0), (1780, 0), (1790, 0), (1800, 0), (1810, 0), (1820, 0), (1830, 0), (1840, 0), (1850, 0), (1860, 0), (1870, 0), (1880, 0), (1890, 0), (1900, 0), (1910, 0), (1920, 0), (1930, 0), (1940, 0), (1950, 0), (1960, 0), (1970, 0), (1980, 1), (1990, 1), (2000, 1), (2010, 1), (2020, 0), (2030, 0), (2040, 0), (2050, 0)]
Vdin1_6  din1_6  0 PWL (0n 0.0v 9.495n 0.0v 9.505n 0.0v 19.495n 0.0v 19.505n 0.0v 29.495n 0.0v 29.505n 3.3v 39.495n 3.3v 39.505n 3.3v 49.495n 3.3v 49.505n 3.3v 59.495n 3.3v 59.505n 3.3v 69.495n 3.3v 69.505n 0.0v 79.495n 0.0v 79.505n 0.0v 89.495n 0.0v 89.505n 0.0v 99.495n 0.0v 99.505n 0.0v 109.495n 0.0v 109.505n 0.0v 119.495n 0.0v 119.505n 0.0v 129.495n 0.0v 129.505n 0.0v 139.495n 0.0v 139.505n 0.0v 149.495n 0.0v 149.505n 0.0v 159.495n 0.0v 159.505n 3.3v 169.495n 3.3v 169.505n 3.3v 179.495n 3.3v 179.505n 3.3v 189.495n 3.3v 189.505n 3.3v 199.495n 3.3v 199.505n 3.3v 209.495n 3.3v 209.505n 3.3v 219.495n 3.3v 219.505n 3.3v 229.495n 3.3v 229.505n 0.0v 239.495n 0.0v 239.505n 0.0v 249.495n 0.0v 249.505n 0.0v 259.495n 0.0v 259.505n 0.0v 269.495n 0.0v 269.505n 0.0v 279.495n 0.0v 279.505n 0.0v 289.495n 0.0v 289.505n 0.0v 299.495n 0.0v 299.505n 0.0v 309.495n 0.0v 309.505n 0.0v 319.495n 0.0v 319.505n 0.0v 329.495n 0.0v 329.505n 3.3v 339.495n 3.3v 339.505n 3.3v 349.495n 3.3v 349.505n 3.3v 359.495n 3.3v 359.505n 0.0v 369.495n 0.0v 369.505n 0.0v 379.495n 0.0v 379.505n 0.0v 389.495n 0.0v 389.505n 0.0v 399.495n 0.0v 399.505n 0.0v 409.495n 0.0v 409.505n 0.0v 419.495n 0.0v 419.505n 0.0v 429.495n 0.0v 429.505n 0.0v 439.495n 0.0v 439.505n 0.0v 449.495n 0.0v 449.505n 0.0v 459.495n 0.0v 459.505n 0.0v 469.495n 0.0v 469.505n 0.0v 479.495n 0.0v 479.505n 0.0v 489.495n 0.0v 489.505n 0.0v 499.495n 0.0v 499.505n 0.0v 509.495n 0.0v 509.505n 0.0v 519.495n 0.0v 519.505n 0.0v 529.495n 0.0v 529.505n 0.0v 539.495n 0.0v 539.505n 3.3v 549.495n 3.3v 549.505n 3.3v 559.495n 3.3v 559.505n 3.3v 569.495n 3.3v 569.505n 3.3v 579.495n 3.3v 579.505n 3.3v 589.495n 3.3v 589.505n 3.3v 599.495n 3.3v 599.505n 3.3v 609.495n 3.3v 609.505n 3.3v 619.495n 3.3v 619.505n 3.3v 629.495n 3.3v 629.505n 0.0v 639.495n 0.0v 639.505n 0.0v 649.495n 0.0v 649.505n 0.0v 659.495n 0.0v 659.505n 0.0v 669.495n 0.0v 669.505n 0.0v 679.495n 0.0v 679.505n 0.0v 689.495n 0.0v 689.505n 0.0v 699.495n 0.0v 699.505n 0.0v 709.495n 0.0v 709.505n 0.0v 719.495n 0.0v 719.505n 0.0v 729.495n 0.0v 729.505n 0.0v 739.495n 0.0v 739.505n 3.3v 749.495n 3.3v 749.505n 3.3v 759.495n 3.3v 759.505n 3.3v 769.495n 3.3v 769.505n 3.3v 779.495n 3.3v 779.505n 3.3v 789.495n 3.3v 789.505n 3.3v 799.495n 3.3v 799.505n 0.0v 809.495n 0.0v 809.505n 0.0v 819.495n 0.0v 819.505n 3.3v 829.495n 3.3v 829.505n 3.3v 839.495n 3.3v 839.505n 0.0v 849.495n 0.0v 849.505n 0.0v 859.495n 0.0v 859.505n 0.0v 869.495n 0.0v 869.505n 0.0v 879.495n 0.0v 879.505n 0.0v 889.495n 0.0v 889.505n 0.0v 899.495n 0.0v 899.505n 0.0v 909.495n 0.0v 909.505n 0.0v 919.495n 0.0v 919.505n 0.0v 929.495n 0.0v 929.505n 0.0v 939.495n 0.0v 939.505n 0.0v 949.495n 0.0v 949.505n 0.0v 959.495n 0.0v 959.505n 3.3v 969.495n 3.3v 969.505n 3.3v 979.495n 3.3v 979.505n 3.3v 989.495n 3.3v 989.505n 3.3v 999.495n 3.3v 999.505n 0.0v 1009.495n 0.0v 1009.505n 0.0v 1019.495n 0.0v 1019.505n 0.0v 1029.495n 0.0v 1029.505n 0.0v 1039.495n 0.0v 1039.505n 0.0v 1049.495n 0.0v 1049.505n 0.0v 1059.495n 0.0v 1059.505n 0.0v 1069.495n 0.0v 1069.505n 0.0v 1079.495n 0.0v 1079.505n 0.0v 1089.495n 0.0v 1089.505n 0.0v 1099.495n 0.0v 1099.505n 0.0v 1109.495n 0.0v 1109.505n 0.0v 1119.495n 0.0v 1119.505n 0.0v 1129.495n 0.0v 1129.505n 0.0v 1139.495n 0.0v 1139.505n 0.0v 1149.495n 0.0v 1149.505n 0.0v 1159.495n 0.0v 1159.505n 0.0v 1169.495n 0.0v 1169.505n 0.0v 1179.495n 0.0v 1179.505n 0.0v 1189.495n 0.0v 1189.505n 0.0v 1199.495n 0.0v 1199.505n 0.0v 1209.495n 0.0v 1209.505n 0.0v 1219.495n 0.0v 1219.505n 0.0v 1229.495n 0.0v 1229.505n 0.0v 1239.495n 0.0v 1239.505n 0.0v 1249.495n 0.0v 1249.505n 0.0v 1259.495n 0.0v 1259.505n 0.0v 1269.495n 0.0v 1269.505n 0.0v 1279.495n 0.0v 1279.505n 3.3v 1289.495n 3.3v 1289.505n 3.3v 1299.495n 3.3v 1299.505n 3.3v 1309.495n 3.3v 1309.505n 3.3v 1319.495n 3.3v 1319.505n 3.3v 1329.495n 3.3v 1329.505n 3.3v 1339.495n 3.3v 1339.505n 0.0v 1349.495n 0.0v 1349.505n 0.0v 1359.495n 0.0v 1359.505n 0.0v 1369.495n 0.0v 1369.505n 0.0v 1379.495n 0.0v 1379.505n 0.0v 1389.495n 0.0v 1389.505n 3.3v 1399.495n 3.3v 1399.505n 3.3v 1409.495n 3.3v 1409.505n 3.3v 1419.495n 3.3v 1419.505n 3.3v 1429.495n 3.3v 1429.505n 0.0v 1439.495n 0.0v 1439.505n 3.3v 1449.495n 3.3v 1449.505n 3.3v 1459.495n 3.3v 1459.505n 3.3v 1469.495n 3.3v 1469.505n 3.3v 1479.495n 3.3v 1479.505n 3.3v 1489.495n 3.3v 1489.505n 3.3v 1499.495n 3.3v 1499.505n 3.3v 1509.495n 3.3v 1509.505n 3.3v 1519.495n 3.3v 1519.505n 3.3v 1529.495n 3.3v 1529.505n 3.3v 1539.495n 3.3v 1539.505n 3.3v 1549.495n 3.3v 1549.505n 3.3v 1559.495n 3.3v 1559.505n 3.3v 1569.495n 3.3v 1569.505n 3.3v 1579.495n 3.3v 1579.505n 3.3v 1589.495n 3.3v 1589.505n 3.3v 1599.495n 3.3v 1599.505n 3.3v 1609.495n 3.3v 1609.505n 3.3v 1619.495n 3.3v 1619.505n 3.3v 1629.495n 3.3v 1629.505n 3.3v 1639.495n 3.3v 1639.505n 3.3v 1649.495n 3.3v 1649.505n 3.3v 1659.495n 3.3v 1659.505n 0.0v 1669.495n 0.0v 1669.505n 0.0v 1679.495n 0.0v 1679.505n 3.3v 1689.495n 3.3v 1689.505n 3.3v 1699.495n 3.3v 1699.505n 3.3v 1709.495n 3.3v 1709.505n 3.3v 1719.495n 3.3v 1719.505n 3.3v 1729.495n 3.3v 1729.505n 3.3v 1739.495n 3.3v 1739.505n 3.3v 1749.495n 3.3v 1749.505n 3.3v 1759.495n 3.3v 1759.505n 3.3v 1769.495n 3.3v 1769.505n 0.0v 1779.495n 0.0v 1779.505n 0.0v 1789.495n 0.0v 1789.505n 0.0v 1799.495n 0.0v 1799.505n 0.0v 1809.495n 0.0v 1809.505n 0.0v 1819.495n 0.0v 1819.505n 0.0v 1829.495n 0.0v 1829.505n 0.0v 1839.495n 0.0v 1839.505n 0.0v 1849.495n 0.0v 1849.505n 0.0v 1859.495n 0.0v 1859.505n 0.0v 1869.495n 0.0v 1869.505n 0.0v 1879.495n 0.0v 1879.505n 0.0v 1889.495n 0.0v 1889.505n 0.0v 1899.495n 0.0v 1899.505n 0.0v 1909.495n 0.0v 1909.505n 0.0v 1919.495n 0.0v 1919.505n 0.0v 1929.495n 0.0v 1929.505n 0.0v 1939.495n 0.0v 1939.505n 0.0v 1949.495n 0.0v 1949.505n 0.0v 1959.495n 0.0v 1959.505n 0.0v 1969.495n 0.0v 1969.505n 0.0v 1979.495n 0.0v 1979.505n 3.3v 1989.495n 3.3v 1989.505n 3.3v 1999.495n 3.3v 1999.505n 3.3v 2009.495n 3.3v 2009.505n 3.3v 2019.495n 3.3v 2019.505n 0.0v 2029.495n 0.0v 2029.505n 0.0v 2039.495n 0.0v 2039.505n 0.0v 2049.495n 0.0v 2049.505n 0.0v )
* (time, data): [(0, 0), (10, 0), (20, 0), (30, 0), (40, 0), (50, 0), (60, 0), (70, 0), (80, 0), (90, 0), (100, 1), (110, 1), (120, 1), (130, 1), (140, 1), (150, 1), (160, 1), (170, 1), (180, 1), (190, 1), (200, 1), (210, 1), (220, 1), (230, 1), (240, 1), (250, 1), (260, 1), (270, 1), (280, 1), (290, 1), (300, 1), (310, 1), (320, 1), (330, 0), (340, 0), (350, 0), (360, 1), (370, 1), (380, 1), (390, 1), (400, 1), (410, 1), (420, 1), (430, 1), (440, 1), (450, 1), (460, 1), (470, 1), (480, 1), (490, 1), (500, 1), (510, 1), (520, 1), (530, 1), (540, 1), (550, 1), (560, 1), (570, 1), (580, 1), (590, 1), (600, 1), (610, 1), (620, 1), (630, 1), (640, 1), (650, 1), (660, 1), (670, 1), (680, 1), (690, 0), (700, 0), (710, 0), (720, 0), (730, 0), (740, 1), (750, 0), (760, 0), (770, 1), (780, 1), (790, 1), (800, 1), (810, 1), (820, 0), (830, 0), (840, 1), (850, 1), (860, 1), (870, 1), (880, 1), (890, 1), (900, 1), (910, 1), (920, 1), (930, 1), (940, 0), (950, 0), (960, 1), (970, 1), (980, 1), (990, 1), (1000, 0), (1010, 0), (1020, 0), (1030, 0), (1040, 0), (1050, 0), (1060, 0), (1070, 0), (1080, 1), (1090, 0), (1100, 0), (1110, 0), (1120, 0), (1130, 0), (1140, 0), (1150, 0), (1160, 0), (1170, 0), (1180, 0), (1190, 0), (1200, 0), (1210, 0), (1220, 0), (1230, 0), (1240, 0), (1250, 1), (1260, 1), (1270, 1), (1280, 1), (1290, 1), (1300, 1), (1310, 1), (1320, 1), (1330, 1), (1340, 1), (1350, 1), (1360, 1), (1370, 1), (1380, 1), (1390, 1), (1400, 1), (1410, 1), (1420, 1), (1430, 0), (1440, 0), (1450, 0), (1460, 0), (1470, 0), (1480, 1), (1490, 1), (1500, 1), (1510, 1), (1520, 1), (1530, 1), (1540, 1), (1550, 1), (1560, 1), (1570, 1), (1580, 1), (1590, 1), (1600, 1), (1610, 0), (1620, 0), (1630, 0), (1640, 0), (1650, 0), (1660, 0), (1670, 0), (1680, 1), (1690, 1), (1700, 1), (1710, 1), (1720, 1), (1730, 1), (1740, 1), (1750, 1), (1760, 1), (1770, 1), (1780, 1), (1790, 1), (1800, 1), (1810, 1), (1820, 1), (1830, 1), (1840, 1), (1850, 1), (1860, 1), (1870, 1), (1880, 1), (1890, 1), (1900, 1), (1910, 1), (1920, 1), (1930, 1), (1940, 1), (1950, 1), (1960, 1), (1970, 1), (1980, 1), (1990, 1), (2000, 1), (2010, 1), (2020, 1), (2030, 1), (2040, 1), (2050, 1)]
Vdin1_7  din1_7  0 PWL (0n 0.0v 9.495n 0.0v 9.505n 0.0v 19.495n 0.0v 19.505n 0.0v 29.495n 0.0v 29.505n 0.0v 39.495n 0.0v 39.505n 0.0v 49.495n 0.0v 49.505n 0.0v 59.495n 0.0v 59.505n 0.0v 69.495n 0.0v 69.505n 0.0v 79.495n 0.0v 79.505n 0.0v 89.495n 0.0v 89.505n 0.0v 99.495n 0.0v 99.505n 3.3v 109.495n 3.3v 109.505n 3.3v 119.495n 3.3v 119.505n 3.3v 129.495n 3.3v 129.505n 3.3v 139.495n 3.3v 139.505n 3.3v 149.495n 3.3v 149.505n 3.3v 159.495n 3.3v 159.505n 3.3v 169.495n 3.3v 169.505n 3.3v 179.495n 3.3v 179.505n 3.3v 189.495n 3.3v 189.505n 3.3v 199.495n 3.3v 199.505n 3.3v 209.495n 3.3v 209.505n 3.3v 219.495n 3.3v 219.505n 3.3v 229.495n 3.3v 229.505n 3.3v 239.495n 3.3v 239.505n 3.3v 249.495n 3.3v 249.505n 3.3v 259.495n 3.3v 259.505n 3.3v 269.495n 3.3v 269.505n 3.3v 279.495n 3.3v 279.505n 3.3v 289.495n 3.3v 289.505n 3.3v 299.495n 3.3v 299.505n 3.3v 309.495n 3.3v 309.505n 3.3v 319.495n 3.3v 319.505n 3.3v 329.495n 3.3v 329.505n 0.0v 339.495n 0.0v 339.505n 0.0v 349.495n 0.0v 349.505n 0.0v 359.495n 0.0v 359.505n 3.3v 369.495n 3.3v 369.505n 3.3v 379.495n 3.3v 379.505n 3.3v 389.495n 3.3v 389.505n 3.3v 399.495n 3.3v 399.505n 3.3v 409.495n 3.3v 409.505n 3.3v 419.495n 3.3v 419.505n 3.3v 429.495n 3.3v 429.505n 3.3v 439.495n 3.3v 439.505n 3.3v 449.495n 3.3v 449.505n 3.3v 459.495n 3.3v 459.505n 3.3v 469.495n 3.3v 469.505n 3.3v 479.495n 3.3v 479.505n 3.3v 489.495n 3.3v 489.505n 3.3v 499.495n 3.3v 499.505n 3.3v 509.495n 3.3v 509.505n 3.3v 519.495n 3.3v 519.505n 3.3v 529.495n 3.3v 529.505n 3.3v 539.495n 3.3v 539.505n 3.3v 549.495n 3.3v 549.505n 3.3v 559.495n 3.3v 559.505n 3.3v 569.495n 3.3v 569.505n 3.3v 579.495n 3.3v 579.505n 3.3v 589.495n 3.3v 589.505n 3.3v 599.495n 3.3v 599.505n 3.3v 609.495n 3.3v 609.505n 3.3v 619.495n 3.3v 619.505n 3.3v 629.495n 3.3v 629.505n 3.3v 639.495n 3.3v 639.505n 3.3v 649.495n 3.3v 649.505n 3.3v 659.495n 3.3v 659.505n 3.3v 669.495n 3.3v 669.505n 3.3v 679.495n 3.3v 679.505n 3.3v 689.495n 3.3v 689.505n 0.0v 699.495n 0.0v 699.505n 0.0v 709.495n 0.0v 709.505n 0.0v 719.495n 0.0v 719.505n 0.0v 729.495n 0.0v 729.505n 0.0v 739.495n 0.0v 739.505n 3.3v 749.495n 3.3v 749.505n 0.0v 759.495n 0.0v 759.505n 0.0v 769.495n 0.0v 769.505n 3.3v 779.495n 3.3v 779.505n 3.3v 789.495n 3.3v 789.505n 3.3v 799.495n 3.3v 799.505n 3.3v 809.495n 3.3v 809.505n 3.3v 819.495n 3.3v 819.505n 0.0v 829.495n 0.0v 829.505n 0.0v 839.495n 0.0v 839.505n 3.3v 849.495n 3.3v 849.505n 3.3v 859.495n 3.3v 859.505n 3.3v 869.495n 3.3v 869.505n 3.3v 879.495n 3.3v 879.505n 3.3v 889.495n 3.3v 889.505n 3.3v 899.495n 3.3v 899.505n 3.3v 909.495n 3.3v 909.505n 3.3v 919.495n 3.3v 919.505n 3.3v 929.495n 3.3v 929.505n 3.3v 939.495n 3.3v 939.505n 0.0v 949.495n 0.0v 949.505n 0.0v 959.495n 0.0v 959.505n 3.3v 969.495n 3.3v 969.505n 3.3v 979.495n 3.3v 979.505n 3.3v 989.495n 3.3v 989.505n 3.3v 999.495n 3.3v 999.505n 0.0v 1009.495n 0.0v 1009.505n 0.0v 1019.495n 0.0v 1019.505n 0.0v 1029.495n 0.0v 1029.505n 0.0v 1039.495n 0.0v 1039.505n 0.0v 1049.495n 0.0v 1049.505n 0.0v 1059.495n 0.0v 1059.505n 0.0v 1069.495n 0.0v 1069.505n 0.0v 1079.495n 0.0v 1079.505n 3.3v 1089.495n 3.3v 1089.505n 0.0v 1099.495n 0.0v 1099.505n 0.0v 1109.495n 0.0v 1109.505n 0.0v 1119.495n 0.0v 1119.505n 0.0v 1129.495n 0.0v 1129.505n 0.0v 1139.495n 0.0v 1139.505n 0.0v 1149.495n 0.0v 1149.505n 0.0v 1159.495n 0.0v 1159.505n 0.0v 1169.495n 0.0v 1169.505n 0.0v 1179.495n 0.0v 1179.505n 0.0v 1189.495n 0.0v 1189.505n 0.0v 1199.495n 0.0v 1199.505n 0.0v 1209.495n 0.0v 1209.505n 0.0v 1219.495n 0.0v 1219.505n 0.0v 1229.495n 0.0v 1229.505n 0.0v 1239.495n 0.0v 1239.505n 0.0v 1249.495n 0.0v 1249.505n 3.3v 1259.495n 3.3v 1259.505n 3.3v 1269.495n 3.3v 1269.505n 3.3v 1279.495n 3.3v 1279.505n 3.3v 1289.495n 3.3v 1289.505n 3.3v 1299.495n 3.3v 1299.505n 3.3v 1309.495n 3.3v 1309.505n 3.3v 1319.495n 3.3v 1319.505n 3.3v 1329.495n 3.3v 1329.505n 3.3v 1339.495n 3.3v 1339.505n 3.3v 1349.495n 3.3v 1349.505n 3.3v 1359.495n 3.3v 1359.505n 3.3v 1369.495n 3.3v 1369.505n 3.3v 1379.495n 3.3v 1379.505n 3.3v 1389.495n 3.3v 1389.505n 3.3v 1399.495n 3.3v 1399.505n 3.3v 1409.495n 3.3v 1409.505n 3.3v 1419.495n 3.3v 1419.505n 3.3v 1429.495n 3.3v 1429.505n 0.0v 1439.495n 0.0v 1439.505n 0.0v 1449.495n 0.0v 1449.505n 0.0v 1459.495n 0.0v 1459.505n 0.0v 1469.495n 0.0v 1469.505n 0.0v 1479.495n 0.0v 1479.505n 3.3v 1489.495n 3.3v 1489.505n 3.3v 1499.495n 3.3v 1499.505n 3.3v 1509.495n 3.3v 1509.505n 3.3v 1519.495n 3.3v 1519.505n 3.3v 1529.495n 3.3v 1529.505n 3.3v 1539.495n 3.3v 1539.505n 3.3v 1549.495n 3.3v 1549.505n 3.3v 1559.495n 3.3v 1559.505n 3.3v 1569.495n 3.3v 1569.505n 3.3v 1579.495n 3.3v 1579.505n 3.3v 1589.495n 3.3v 1589.505n 3.3v 1599.495n 3.3v 1599.505n 3.3v 1609.495n 3.3v 1609.505n 0.0v 1619.495n 0.0v 1619.505n 0.0v 1629.495n 0.0v 1629.505n 0.0v 1639.495n 0.0v 1639.505n 0.0v 1649.495n 0.0v 1649.505n 0.0v 1659.495n 0.0v 1659.505n 0.0v 1669.495n 0.0v 1669.505n 0.0v 1679.495n 0.0v 1679.505n 3.3v 1689.495n 3.3v 1689.505n 3.3v 1699.495n 3.3v 1699.505n 3.3v 1709.495n 3.3v 1709.505n 3.3v 1719.495n 3.3v 1719.505n 3.3v 1729.495n 3.3v 1729.505n 3.3v 1739.495n 3.3v 1739.505n 3.3v 1749.495n 3.3v 1749.505n 3.3v 1759.495n 3.3v 1759.505n 3.3v 1769.495n 3.3v 1769.505n 3.3v 1779.495n 3.3v 1779.505n 3.3v 1789.495n 3.3v 1789.505n 3.3v 1799.495n 3.3v 1799.505n 3.3v 1809.495n 3.3v 1809.505n 3.3v 1819.495n 3.3v 1819.505n 3.3v 1829.495n 3.3v 1829.505n 3.3v 1839.495n 3.3v 1839.505n 3.3v 1849.495n 3.3v 1849.505n 3.3v 1859.495n 3.3v 1859.505n 3.3v 1869.495n 3.3v 1869.505n 3.3v 1879.495n 3.3v 1879.505n 3.3v 1889.495n 3.3v 1889.505n 3.3v 1899.495n 3.3v 1899.505n 3.3v 1909.495n 3.3v 1909.505n 3.3v 1919.495n 3.3v 1919.505n 3.3v 1929.495n 3.3v 1929.505n 3.3v 1939.495n 3.3v 1939.505n 3.3v 1949.495n 3.3v 1949.505n 3.3v 1959.495n 3.3v 1959.505n 3.3v 1969.495n 3.3v 1969.505n 3.3v 1979.495n 3.3v 1979.505n 3.3v 1989.495n 3.3v 1989.505n 3.3v 1999.495n 3.3v 1999.505n 3.3v 2009.495n 3.3v 2009.505n 3.3v 2019.495n 3.3v 2019.505n 3.3v 2029.495n 3.3v 2029.505n 3.3v 2039.495n 3.3v 2039.505n 3.3v 2049.495n 3.3v 2049.505n 3.3v )
* (time, data): [(0, 0), (10, 1), (20, 1), (30, 0), (40, 0), (50, 0), (60, 1), (70, 1), (80, 1), (90, 1), (100, 1), (110, 1), (120, 1), (130, 1), (140, 1), (150, 0), (160, 0), (170, 0), (180, 0), (190, 0), (200, 0), (210, 0), (220, 0), (230, 0), (240, 0), (250, 0), (260, 0), (270, 0), (280, 0), (290, 0), (300, 0), (310, 0), (320, 0), (330, 1), (340, 1), (350, 1), (360, 0), (370, 0), (380, 0), (390, 0), (400, 0), (410, 0), (420, 0), (430, 0), (440, 0), (450, 0), (460, 0), (470, 0), (480, 0), (490, 0), (500, 0), (510, 0), (520, 0), (530, 0), (540, 0), (550, 0), (560, 0), (570, 0), (580, 0), (590, 0), (600, 0), (610, 1), (620, 1), (630, 0), (640, 0), (650, 0), (660, 0), (670, 0), (680, 0), (690, 1), (700, 1), (710, 1), (720, 1), (730, 1), (740, 1), (750, 1), (760, 1), (770, 0), (780, 0), (790, 0), (800, 0), (810, 0), (820, 1), (830, 1), (840, 1), (850, 1), (860, 1), (870, 1), (880, 1), (890, 1), (900, 1), (910, 0), (920, 0), (930, 0), (940, 0), (950, 0), (960, 0), (970, 0), (980, 0), (990, 0), (1000, 1), (1010, 1), (1020, 1), (1030, 1), (1040, 1), (1050, 1), (1060, 1), (1070, 1), (1080, 1), (1090, 0), (1100, 0), (1110, 0), (1120, 0), (1130, 0), (1140, 0), (1150, 0), (1160, 0), (1170, 0), (1180, 0), (1190, 0), (1200, 0), (1210, 0), (1220, 0), (1230, 0), (1240, 0), (1250, 0), (1260, 0), (1270, 0), (1280, 0), (1290, 0), (1300, 0), (1310, 0), (1320, 0), (1330, 0), (1340, 0), (1350, 0), (1360, 0), (1370, 0), (1380, 0), (1390, 1), (1400, 1), (1410, 1), (1420, 1), (1430, 1), (1440, 1), (1450, 1), (1460, 1), (1470, 0), (1480, 0), (1490, 0), (1500, 0), (1510, 0), (1520, 0), (1530, 0), (1540, 0), (1550, 1), (1560, 1), (1570, 1), (1580, 1), (1590, 1), (1600, 1), (1610, 1), (1620, 1), (1630, 0), (1640, 0), (1650, 0), (1660, 0), (1670, 0), (1680, 0), (1690, 0), (1700, 0), (1710, 0), (1720, 0), (1730, 0), (1740, 0), (1750, 0), (1760, 0), (1770, 0), (1780, 0), (1790, 0), (1800, 0), (1810, 0), (1820, 0), (1830, 0), (1840, 0), (1850, 0), (1860, 0), (1870, 0), (1880, 0), (1890, 0), (1900, 0), (1910, 0), (1920, 0), (1930, 0), (1940, 0), (1950, 1), (1960, 1), (1970, 1), (1980, 1), (1990, 1), (2000, 1), (2010, 1), (2020, 0), (2030, 0), (2040, 0), (2050, 0)]
Vdin1_8  din1_8  0 PWL (0n 0.0v 9.495n 0.0v 9.505n 3.3v 19.495n 3.3v 19.505n 3.3v 29.495n 3.3v 29.505n 0.0v 39.495n 0.0v 39.505n 0.0v 49.495n 0.0v 49.505n 0.0v 59.495n 0.0v 59.505n 3.3v 69.495n 3.3v 69.505n 3.3v 79.495n 3.3v 79.505n 3.3v 89.495n 3.3v 89.505n 3.3v 99.495n 3.3v 99.505n 3.3v 109.495n 3.3v 109.505n 3.3v 119.495n 3.3v 119.505n 3.3v 129.495n 3.3v 129.505n 3.3v 139.495n 3.3v 139.505n 3.3v 149.495n 3.3v 149.505n 0.0v 159.495n 0.0v 159.505n 0.0v 169.495n 0.0v 169.505n 0.0v 179.495n 0.0v 179.505n 0.0v 189.495n 0.0v 189.505n 0.0v 199.495n 0.0v 199.505n 0.0v 209.495n 0.0v 209.505n 0.0v 219.495n 0.0v 219.505n 0.0v 229.495n 0.0v 229.505n 0.0v 239.495n 0.0v 239.505n 0.0v 249.495n 0.0v 249.505n 0.0v 259.495n 0.0v 259.505n 0.0v 269.495n 0.0v 269.505n 0.0v 279.495n 0.0v 279.505n 0.0v 289.495n 0.0v 289.505n 0.0v 299.495n 0.0v 299.505n 0.0v 309.495n 0.0v 309.505n 0.0v 319.495n 0.0v 319.505n 0.0v 329.495n 0.0v 329.505n 3.3v 339.495n 3.3v 339.505n 3.3v 349.495n 3.3v 349.505n 3.3v 359.495n 3.3v 359.505n 0.0v 369.495n 0.0v 369.505n 0.0v 379.495n 0.0v 379.505n 0.0v 389.495n 0.0v 389.505n 0.0v 399.495n 0.0v 399.505n 0.0v 409.495n 0.0v 409.505n 0.0v 419.495n 0.0v 419.505n 0.0v 429.495n 0.0v 429.505n 0.0v 439.495n 0.0v 439.505n 0.0v 449.495n 0.0v 449.505n 0.0v 459.495n 0.0v 459.505n 0.0v 469.495n 0.0v 469.505n 0.0v 479.495n 0.0v 479.505n 0.0v 489.495n 0.0v 489.505n 0.0v 499.495n 0.0v 499.505n 0.0v 509.495n 0.0v 509.505n 0.0v 519.495n 0.0v 519.505n 0.0v 529.495n 0.0v 529.505n 0.0v 539.495n 0.0v 539.505n 0.0v 549.495n 0.0v 549.505n 0.0v 559.495n 0.0v 559.505n 0.0v 569.495n 0.0v 569.505n 0.0v 579.495n 0.0v 579.505n 0.0v 589.495n 0.0v 589.505n 0.0v 599.495n 0.0v 599.505n 0.0v 609.495n 0.0v 609.505n 3.3v 619.495n 3.3v 619.505n 3.3v 629.495n 3.3v 629.505n 0.0v 639.495n 0.0v 639.505n 0.0v 649.495n 0.0v 649.505n 0.0v 659.495n 0.0v 659.505n 0.0v 669.495n 0.0v 669.505n 0.0v 679.495n 0.0v 679.505n 0.0v 689.495n 0.0v 689.505n 3.3v 699.495n 3.3v 699.505n 3.3v 709.495n 3.3v 709.505n 3.3v 719.495n 3.3v 719.505n 3.3v 729.495n 3.3v 729.505n 3.3v 739.495n 3.3v 739.505n 3.3v 749.495n 3.3v 749.505n 3.3v 759.495n 3.3v 759.505n 3.3v 769.495n 3.3v 769.505n 0.0v 779.495n 0.0v 779.505n 0.0v 789.495n 0.0v 789.505n 0.0v 799.495n 0.0v 799.505n 0.0v 809.495n 0.0v 809.505n 0.0v 819.495n 0.0v 819.505n 3.3v 829.495n 3.3v 829.505n 3.3v 839.495n 3.3v 839.505n 3.3v 849.495n 3.3v 849.505n 3.3v 859.495n 3.3v 859.505n 3.3v 869.495n 3.3v 869.505n 3.3v 879.495n 3.3v 879.505n 3.3v 889.495n 3.3v 889.505n 3.3v 899.495n 3.3v 899.505n 3.3v 909.495n 3.3v 909.505n 0.0v 919.495n 0.0v 919.505n 0.0v 929.495n 0.0v 929.505n 0.0v 939.495n 0.0v 939.505n 0.0v 949.495n 0.0v 949.505n 0.0v 959.495n 0.0v 959.505n 0.0v 969.495n 0.0v 969.505n 0.0v 979.495n 0.0v 979.505n 0.0v 989.495n 0.0v 989.505n 0.0v 999.495n 0.0v 999.505n 3.3v 1009.495n 3.3v 1009.505n 3.3v 1019.495n 3.3v 1019.505n 3.3v 1029.495n 3.3v 1029.505n 3.3v 1039.495n 3.3v 1039.505n 3.3v 1049.495n 3.3v 1049.505n 3.3v 1059.495n 3.3v 1059.505n 3.3v 1069.495n 3.3v 1069.505n 3.3v 1079.495n 3.3v 1079.505n 3.3v 1089.495n 3.3v 1089.505n 0.0v 1099.495n 0.0v 1099.505n 0.0v 1109.495n 0.0v 1109.505n 0.0v 1119.495n 0.0v 1119.505n 0.0v 1129.495n 0.0v 1129.505n 0.0v 1139.495n 0.0v 1139.505n 0.0v 1149.495n 0.0v 1149.505n 0.0v 1159.495n 0.0v 1159.505n 0.0v 1169.495n 0.0v 1169.505n 0.0v 1179.495n 0.0v 1179.505n 0.0v 1189.495n 0.0v 1189.505n 0.0v 1199.495n 0.0v 1199.505n 0.0v 1209.495n 0.0v 1209.505n 0.0v 1219.495n 0.0v 1219.505n 0.0v 1229.495n 0.0v 1229.505n 0.0v 1239.495n 0.0v 1239.505n 0.0v 1249.495n 0.0v 1249.505n 0.0v 1259.495n 0.0v 1259.505n 0.0v 1269.495n 0.0v 1269.505n 0.0v 1279.495n 0.0v 1279.505n 0.0v 1289.495n 0.0v 1289.505n 0.0v 1299.495n 0.0v 1299.505n 0.0v 1309.495n 0.0v 1309.505n 0.0v 1319.495n 0.0v 1319.505n 0.0v 1329.495n 0.0v 1329.505n 0.0v 1339.495n 0.0v 1339.505n 0.0v 1349.495n 0.0v 1349.505n 0.0v 1359.495n 0.0v 1359.505n 0.0v 1369.495n 0.0v 1369.505n 0.0v 1379.495n 0.0v 1379.505n 0.0v 1389.495n 0.0v 1389.505n 3.3v 1399.495n 3.3v 1399.505n 3.3v 1409.495n 3.3v 1409.505n 3.3v 1419.495n 3.3v 1419.505n 3.3v 1429.495n 3.3v 1429.505n 3.3v 1439.495n 3.3v 1439.505n 3.3v 1449.495n 3.3v 1449.505n 3.3v 1459.495n 3.3v 1459.505n 3.3v 1469.495n 3.3v 1469.505n 0.0v 1479.495n 0.0v 1479.505n 0.0v 1489.495n 0.0v 1489.505n 0.0v 1499.495n 0.0v 1499.505n 0.0v 1509.495n 0.0v 1509.505n 0.0v 1519.495n 0.0v 1519.505n 0.0v 1529.495n 0.0v 1529.505n 0.0v 1539.495n 0.0v 1539.505n 0.0v 1549.495n 0.0v 1549.505n 3.3v 1559.495n 3.3v 1559.505n 3.3v 1569.495n 3.3v 1569.505n 3.3v 1579.495n 3.3v 1579.505n 3.3v 1589.495n 3.3v 1589.505n 3.3v 1599.495n 3.3v 1599.505n 3.3v 1609.495n 3.3v 1609.505n 3.3v 1619.495n 3.3v 1619.505n 3.3v 1629.495n 3.3v 1629.505n 0.0v 1639.495n 0.0v 1639.505n 0.0v 1649.495n 0.0v 1649.505n 0.0v 1659.495n 0.0v 1659.505n 0.0v 1669.495n 0.0v 1669.505n 0.0v 1679.495n 0.0v 1679.505n 0.0v 1689.495n 0.0v 1689.505n 0.0v 1699.495n 0.0v 1699.505n 0.0v 1709.495n 0.0v 1709.505n 0.0v 1719.495n 0.0v 1719.505n 0.0v 1729.495n 0.0v 1729.505n 0.0v 1739.495n 0.0v 1739.505n 0.0v 1749.495n 0.0v 1749.505n 0.0v 1759.495n 0.0v 1759.505n 0.0v 1769.495n 0.0v 1769.505n 0.0v 1779.495n 0.0v 1779.505n 0.0v 1789.495n 0.0v 1789.505n 0.0v 1799.495n 0.0v 1799.505n 0.0v 1809.495n 0.0v 1809.505n 0.0v 1819.495n 0.0v 1819.505n 0.0v 1829.495n 0.0v 1829.505n 0.0v 1839.495n 0.0v 1839.505n 0.0v 1849.495n 0.0v 1849.505n 0.0v 1859.495n 0.0v 1859.505n 0.0v 1869.495n 0.0v 1869.505n 0.0v 1879.495n 0.0v 1879.505n 0.0v 1889.495n 0.0v 1889.505n 0.0v 1899.495n 0.0v 1899.505n 0.0v 1909.495n 0.0v 1909.505n 0.0v 1919.495n 0.0v 1919.505n 0.0v 1929.495n 0.0v 1929.505n 0.0v 1939.495n 0.0v 1939.505n 0.0v 1949.495n 0.0v 1949.505n 3.3v 1959.495n 3.3v 1959.505n 3.3v 1969.495n 3.3v 1969.505n 3.3v 1979.495n 3.3v 1979.505n 3.3v 1989.495n 3.3v 1989.505n 3.3v 1999.495n 3.3v 1999.505n 3.3v 2009.495n 3.3v 2009.505n 3.3v 2019.495n 3.3v 2019.505n 0.0v 2029.495n 0.0v 2029.505n 0.0v 2039.495n 0.0v 2039.505n 0.0v 2049.495n 0.0v 2049.505n 0.0v )
* (time, data): [(0, 0), (10, 0), (20, 1), (30, 1), (40, 1), (50, 0), (60, 1), (70, 1), (80, 1), (90, 1), (100, 0), (110, 0), (120, 0), (130, 0), (140, 0), (150, 0), (160, 0), (170, 0), (180, 0), (190, 0), (200, 0), (210, 0), (220, 0), (230, 0), (240, 0), (250, 0), (260, 0), (270, 0), (280, 0), (290, 0), (300, 0), (310, 0), (320, 0), (330, 1), (340, 1), (350, 1), (360, 1), (370, 1), (380, 1), (390, 1), (400, 1), (410, 1), (420, 1), (430, 1), (440, 0), (450, 0), (460, 0), (470, 0), (480, 0), (490, 0), (500, 0), (510, 0), (520, 0), (530, 0), (540, 0), (550, 0), (560, 0), (570, 0), (580, 0), (590, 0), (600, 0), (610, 0), (620, 0), (630, 0), (640, 0), (650, 0), (660, 0), (670, 0), (680, 0), (690, 1), (700, 1), (710, 1), (720, 1), (730, 1), (740, 1), (750, 1), (760, 1), (770, 0), (780, 0), (790, 0), (800, 1), (810, 1), (820, 0), (830, 0), (840, 1), (850, 1), (860, 1), (870, 1), (880, 1), (890, 1), (900, 1), (910, 0), (920, 0), (930, 0), (940, 0), (950, 0), (960, 0), (970, 0), (980, 0), (990, 0), (1000, 1), (1010, 1), (1020, 1), (1030, 1), (1040, 1), (1050, 1), (1060, 1), (1070, 1), (1080, 1), (1090, 0), (1100, 0), (1110, 0), (1120, 0), (1130, 0), (1140, 0), (1150, 0), (1160, 0), (1170, 0), (1180, 0), (1190, 0), (1200, 0), (1210, 0), (1220, 0), (1230, 0), (1240, 0), (1250, 0), (1260, 0), (1270, 0), (1280, 0), (1290, 0), (1300, 0), (1310, 0), (1320, 1), (1330, 1), (1340, 1), (1350, 1), (1360, 1), (1370, 1), (1380, 1), (1390, 0), (1400, 0), (1410, 0), (1420, 0), (1430, 1), (1440, 0), (1450, 0), (1460, 0), (1470, 1), (1480, 0), (1490, 0), (1500, 0), (1510, 0), (1520, 0), (1530, 0), (1540, 0), (1550, 1), (1560, 1), (1570, 1), (1580, 1), (1590, 1), (1600, 1), (1610, 1), (1620, 1), (1630, 0), (1640, 0), (1650, 0), (1660, 1), (1670, 1), (1680, 0), (1690, 0), (1700, 0), (1710, 0), (1720, 0), (1730, 0), (1740, 0), (1750, 0), (1760, 0), (1770, 0), (1780, 0), (1790, 1), (1800, 1), (1810, 1), (1820, 1), (1830, 1), (1840, 1), (1850, 1), (1860, 1), (1870, 1), (1880, 1), (1890, 1), (1900, 1), (1910, 1), (1920, 1), (1930, 1), (1940, 1), (1950, 1), (1960, 1), (1970, 1), (1980, 1), (1990, 1), (2000, 1), (2010, 1), (2020, 0), (2030, 1), (2040, 1), (2050, 1)]
Vdin1_9  din1_9  0 PWL (0n 0.0v 9.495n 0.0v 9.505n 0.0v 19.495n 0.0v 19.505n 3.3v 29.495n 3.3v 29.505n 3.3v 39.495n 3.3v 39.505n 3.3v 49.495n 3.3v 49.505n 0.0v 59.495n 0.0v 59.505n 3.3v 69.495n 3.3v 69.505n 3.3v 79.495n 3.3v 79.505n 3.3v 89.495n 3.3v 89.505n 3.3v 99.495n 3.3v 99.505n 0.0v 109.495n 0.0v 109.505n 0.0v 119.495n 0.0v 119.505n 0.0v 129.495n 0.0v 129.505n 0.0v 139.495n 0.0v 139.505n 0.0v 149.495n 0.0v 149.505n 0.0v 159.495n 0.0v 159.505n 0.0v 169.495n 0.0v 169.505n 0.0v 179.495n 0.0v 179.505n 0.0v 189.495n 0.0v 189.505n 0.0v 199.495n 0.0v 199.505n 0.0v 209.495n 0.0v 209.505n 0.0v 219.495n 0.0v 219.505n 0.0v 229.495n 0.0v 229.505n 0.0v 239.495n 0.0v 239.505n 0.0v 249.495n 0.0v 249.505n 0.0v 259.495n 0.0v 259.505n 0.0v 269.495n 0.0v 269.505n 0.0v 279.495n 0.0v 279.505n 0.0v 289.495n 0.0v 289.505n 0.0v 299.495n 0.0v 299.505n 0.0v 309.495n 0.0v 309.505n 0.0v 319.495n 0.0v 319.505n 0.0v 329.495n 0.0v 329.505n 3.3v 339.495n 3.3v 339.505n 3.3v 349.495n 3.3v 349.505n 3.3v 359.495n 3.3v 359.505n 3.3v 369.495n 3.3v 369.505n 3.3v 379.495n 3.3v 379.505n 3.3v 389.495n 3.3v 389.505n 3.3v 399.495n 3.3v 399.505n 3.3v 409.495n 3.3v 409.505n 3.3v 419.495n 3.3v 419.505n 3.3v 429.495n 3.3v 429.505n 3.3v 439.495n 3.3v 439.505n 0.0v 449.495n 0.0v 449.505n 0.0v 459.495n 0.0v 459.505n 0.0v 469.495n 0.0v 469.505n 0.0v 479.495n 0.0v 479.505n 0.0v 489.495n 0.0v 489.505n 0.0v 499.495n 0.0v 499.505n 0.0v 509.495n 0.0v 509.505n 0.0v 519.495n 0.0v 519.505n 0.0v 529.495n 0.0v 529.505n 0.0v 539.495n 0.0v 539.505n 0.0v 549.495n 0.0v 549.505n 0.0v 559.495n 0.0v 559.505n 0.0v 569.495n 0.0v 569.505n 0.0v 579.495n 0.0v 579.505n 0.0v 589.495n 0.0v 589.505n 0.0v 599.495n 0.0v 599.505n 0.0v 609.495n 0.0v 609.505n 0.0v 619.495n 0.0v 619.505n 0.0v 629.495n 0.0v 629.505n 0.0v 639.495n 0.0v 639.505n 0.0v 649.495n 0.0v 649.505n 0.0v 659.495n 0.0v 659.505n 0.0v 669.495n 0.0v 669.505n 0.0v 679.495n 0.0v 679.505n 0.0v 689.495n 0.0v 689.505n 3.3v 699.495n 3.3v 699.505n 3.3v 709.495n 3.3v 709.505n 3.3v 719.495n 3.3v 719.505n 3.3v 729.495n 3.3v 729.505n 3.3v 739.495n 3.3v 739.505n 3.3v 749.495n 3.3v 749.505n 3.3v 759.495n 3.3v 759.505n 3.3v 769.495n 3.3v 769.505n 0.0v 779.495n 0.0v 779.505n 0.0v 789.495n 0.0v 789.505n 0.0v 799.495n 0.0v 799.505n 3.3v 809.495n 3.3v 809.505n 3.3v 819.495n 3.3v 819.505n 0.0v 829.495n 0.0v 829.505n 0.0v 839.495n 0.0v 839.505n 3.3v 849.495n 3.3v 849.505n 3.3v 859.495n 3.3v 859.505n 3.3v 869.495n 3.3v 869.505n 3.3v 879.495n 3.3v 879.505n 3.3v 889.495n 3.3v 889.505n 3.3v 899.495n 3.3v 899.505n 3.3v 909.495n 3.3v 909.505n 0.0v 919.495n 0.0v 919.505n 0.0v 929.495n 0.0v 929.505n 0.0v 939.495n 0.0v 939.505n 0.0v 949.495n 0.0v 949.505n 0.0v 959.495n 0.0v 959.505n 0.0v 969.495n 0.0v 969.505n 0.0v 979.495n 0.0v 979.505n 0.0v 989.495n 0.0v 989.505n 0.0v 999.495n 0.0v 999.505n 3.3v 1009.495n 3.3v 1009.505n 3.3v 1019.495n 3.3v 1019.505n 3.3v 1029.495n 3.3v 1029.505n 3.3v 1039.495n 3.3v 1039.505n 3.3v 1049.495n 3.3v 1049.505n 3.3v 1059.495n 3.3v 1059.505n 3.3v 1069.495n 3.3v 1069.505n 3.3v 1079.495n 3.3v 1079.505n 3.3v 1089.495n 3.3v 1089.505n 0.0v 1099.495n 0.0v 1099.505n 0.0v 1109.495n 0.0v 1109.505n 0.0v 1119.495n 0.0v 1119.505n 0.0v 1129.495n 0.0v 1129.505n 0.0v 1139.495n 0.0v 1139.505n 0.0v 1149.495n 0.0v 1149.505n 0.0v 1159.495n 0.0v 1159.505n 0.0v 1169.495n 0.0v 1169.505n 0.0v 1179.495n 0.0v 1179.505n 0.0v 1189.495n 0.0v 1189.505n 0.0v 1199.495n 0.0v 1199.505n 0.0v 1209.495n 0.0v 1209.505n 0.0v 1219.495n 0.0v 1219.505n 0.0v 1229.495n 0.0v 1229.505n 0.0v 1239.495n 0.0v 1239.505n 0.0v 1249.495n 0.0v 1249.505n 0.0v 1259.495n 0.0v 1259.505n 0.0v 1269.495n 0.0v 1269.505n 0.0v 1279.495n 0.0v 1279.505n 0.0v 1289.495n 0.0v 1289.505n 0.0v 1299.495n 0.0v 1299.505n 0.0v 1309.495n 0.0v 1309.505n 0.0v 1319.495n 0.0v 1319.505n 3.3v 1329.495n 3.3v 1329.505n 3.3v 1339.495n 3.3v 1339.505n 3.3v 1349.495n 3.3v 1349.505n 3.3v 1359.495n 3.3v 1359.505n 3.3v 1369.495n 3.3v 1369.505n 3.3v 1379.495n 3.3v 1379.505n 3.3v 1389.495n 3.3v 1389.505n 0.0v 1399.495n 0.0v 1399.505n 0.0v 1409.495n 0.0v 1409.505n 0.0v 1419.495n 0.0v 1419.505n 0.0v 1429.495n 0.0v 1429.505n 3.3v 1439.495n 3.3v 1439.505n 0.0v 1449.495n 0.0v 1449.505n 0.0v 1459.495n 0.0v 1459.505n 0.0v 1469.495n 0.0v 1469.505n 3.3v 1479.495n 3.3v 1479.505n 0.0v 1489.495n 0.0v 1489.505n 0.0v 1499.495n 0.0v 1499.505n 0.0v 1509.495n 0.0v 1509.505n 0.0v 1519.495n 0.0v 1519.505n 0.0v 1529.495n 0.0v 1529.505n 0.0v 1539.495n 0.0v 1539.505n 0.0v 1549.495n 0.0v 1549.505n 3.3v 1559.495n 3.3v 1559.505n 3.3v 1569.495n 3.3v 1569.505n 3.3v 1579.495n 3.3v 1579.505n 3.3v 1589.495n 3.3v 1589.505n 3.3v 1599.495n 3.3v 1599.505n 3.3v 1609.495n 3.3v 1609.505n 3.3v 1619.495n 3.3v 1619.505n 3.3v 1629.495n 3.3v 1629.505n 0.0v 1639.495n 0.0v 1639.505n 0.0v 1649.495n 0.0v 1649.505n 0.0v 1659.495n 0.0v 1659.505n 3.3v 1669.495n 3.3v 1669.505n 3.3v 1679.495n 3.3v 1679.505n 0.0v 1689.495n 0.0v 1689.505n 0.0v 1699.495n 0.0v 1699.505n 0.0v 1709.495n 0.0v 1709.505n 0.0v 1719.495n 0.0v 1719.505n 0.0v 1729.495n 0.0v 1729.505n 0.0v 1739.495n 0.0v 1739.505n 0.0v 1749.495n 0.0v 1749.505n 0.0v 1759.495n 0.0v 1759.505n 0.0v 1769.495n 0.0v 1769.505n 0.0v 1779.495n 0.0v 1779.505n 0.0v 1789.495n 0.0v 1789.505n 3.3v 1799.495n 3.3v 1799.505n 3.3v 1809.495n 3.3v 1809.505n 3.3v 1819.495n 3.3v 1819.505n 3.3v 1829.495n 3.3v 1829.505n 3.3v 1839.495n 3.3v 1839.505n 3.3v 1849.495n 3.3v 1849.505n 3.3v 1859.495n 3.3v 1859.505n 3.3v 1869.495n 3.3v 1869.505n 3.3v 1879.495n 3.3v 1879.505n 3.3v 1889.495n 3.3v 1889.505n 3.3v 1899.495n 3.3v 1899.505n 3.3v 1909.495n 3.3v 1909.505n 3.3v 1919.495n 3.3v 1919.505n 3.3v 1929.495n 3.3v 1929.505n 3.3v 1939.495n 3.3v 1939.505n 3.3v 1949.495n 3.3v 1949.505n 3.3v 1959.495n 3.3v 1959.505n 3.3v 1969.495n 3.3v 1969.505n 3.3v 1979.495n 3.3v 1979.505n 3.3v 1989.495n 3.3v 1989.505n 3.3v 1999.495n 3.3v 1999.505n 3.3v 2009.495n 3.3v 2009.505n 3.3v 2019.495n 3.3v 2019.505n 0.0v 2029.495n 0.0v 2029.505n 3.3v 2039.495n 3.3v 2039.505n 3.3v 2049.495n 3.3v 2049.505n 3.3v )
* (time, data): [(0, 0), (10, 0), (20, 1), (30, 1), (40, 1), (50, 0), (60, 1), (70, 0), (80, 0), (90, 0), (100, 0), (110, 0), (120, 0), (130, 0), (140, 0), (150, 0), (160, 1), (170, 1), (180, 1), (190, 1), (200, 1), (210, 1), (220, 1), (230, 0), (240, 0), (250, 0), (260, 0), (270, 0), (280, 0), (290, 0), (300, 0), (310, 0), (320, 0), (330, 0), (340, 0), (350, 0), (360, 0), (370, 0), (380, 0), (390, 0), (400, 0), (410, 0), (420, 0), (430, 0), (440, 0), (450, 0), (460, 0), (470, 0), (480, 0), (490, 0), (500, 0), (510, 0), (520, 0), (530, 0), (540, 1), (550, 1), (560, 1), (570, 1), (580, 1), (590, 1), (600, 1), (610, 0), (620, 0), (630, 0), (640, 0), (650, 0), (660, 0), (670, 0), (680, 0), (690, 1), (700, 1), (710, 1), (720, 1), (730, 1), (740, 1), (750, 1), (760, 1), (770, 1), (780, 1), (790, 1), (800, 0), (810, 0), (820, 0), (830, 0), (840, 1), (850, 1), (860, 1), (870, 1), (880, 1), (890, 1), (900, 1), (910, 1), (920, 1), (930, 1), (940, 0), (950, 0), (960, 1), (970, 1), (980, 1), (990, 1), (1000, 0), (1010, 0), (1020, 0), (1030, 0), (1040, 0), (1050, 0), (1060, 0), (1070, 0), (1080, 0), (1090, 0), (1100, 0), (1110, 0), (1120, 0), (1130, 0), (1140, 0), (1150, 0), (1160, 0), (1170, 0), (1180, 0), (1190, 0), (1200, 0), (1210, 0), (1220, 0), (1230, 0), (1240, 1), (1250, 0), (1260, 0), (1270, 0), (1280, 1), (1290, 1), (1300, 1), (1310, 1), (1320, 1), (1330, 1), (1340, 1), (1350, 1), (1360, 1), (1370, 1), (1380, 1), (1390, 1), (1400, 1), (1410, 1), (1420, 1), (1430, 0), (1440, 0), (1450, 0), (1460, 0), (1470, 1), (1480, 1), (1490, 1), (1500, 1), (1510, 1), (1520, 1), (1530, 1), (1540, 1), (1550, 0), (1560, 0), (1570, 0), (1580, 0), (1590, 0), (1600, 0), (1610, 0), (1620, 0), (1630, 1), (1640, 1), (1650, 1), (1660, 1), (1670, 1), (1680, 0), (1690, 0), (1700, 0), (1710, 0), (1720, 0), (1730, 0), (1740, 0), (1750, 0), (1760, 0), (1770, 1), (1780, 1), (1790, 0), (1800, 0), (1810, 0), (1820, 0), (1830, 0), (1840, 0), (1850, 0), (1860, 0), (1870, 0), (1880, 0), (1890, 0), (1900, 0), (1910, 0), (1920, 0), (1930, 0), (1940, 0), (1950, 1), (1960, 1), (1970, 1), (1980, 1), (1990, 1), (2000, 1), (2010, 1), (2020, 0), (2030, 0), (2040, 0), (2050, 0)]
Vdin1_10  din1_10  0 PWL (0n 0.0v 9.495n 0.0v 9.505n 0.0v 19.495n 0.0v 19.505n 3.3v 29.495n 3.3v 29.505n 3.3v 39.495n 3.3v 39.505n 3.3v 49.495n 3.3v 49.505n 0.0v 59.495n 0.0v 59.505n 3.3v 69.495n 3.3v 69.505n 0.0v 79.495n 0.0v 79.505n 0.0v 89.495n 0.0v 89.505n 0.0v 99.495n 0.0v 99.505n 0.0v 109.495n 0.0v 109.505n 0.0v 119.495n 0.0v 119.505n 0.0v 129.495n 0.0v 129.505n 0.0v 139.495n 0.0v 139.505n 0.0v 149.495n 0.0v 149.505n 0.0v 159.495n 0.0v 159.505n 3.3v 169.495n 3.3v 169.505n 3.3v 179.495n 3.3v 179.505n 3.3v 189.495n 3.3v 189.505n 3.3v 199.495n 3.3v 199.505n 3.3v 209.495n 3.3v 209.505n 3.3v 219.495n 3.3v 219.505n 3.3v 229.495n 3.3v 229.505n 0.0v 239.495n 0.0v 239.505n 0.0v 249.495n 0.0v 249.505n 0.0v 259.495n 0.0v 259.505n 0.0v 269.495n 0.0v 269.505n 0.0v 279.495n 0.0v 279.505n 0.0v 289.495n 0.0v 289.505n 0.0v 299.495n 0.0v 299.505n 0.0v 309.495n 0.0v 309.505n 0.0v 319.495n 0.0v 319.505n 0.0v 329.495n 0.0v 329.505n 0.0v 339.495n 0.0v 339.505n 0.0v 349.495n 0.0v 349.505n 0.0v 359.495n 0.0v 359.505n 0.0v 369.495n 0.0v 369.505n 0.0v 379.495n 0.0v 379.505n 0.0v 389.495n 0.0v 389.505n 0.0v 399.495n 0.0v 399.505n 0.0v 409.495n 0.0v 409.505n 0.0v 419.495n 0.0v 419.505n 0.0v 429.495n 0.0v 429.505n 0.0v 439.495n 0.0v 439.505n 0.0v 449.495n 0.0v 449.505n 0.0v 459.495n 0.0v 459.505n 0.0v 469.495n 0.0v 469.505n 0.0v 479.495n 0.0v 479.505n 0.0v 489.495n 0.0v 489.505n 0.0v 499.495n 0.0v 499.505n 0.0v 509.495n 0.0v 509.505n 0.0v 519.495n 0.0v 519.505n 0.0v 529.495n 0.0v 529.505n 0.0v 539.495n 0.0v 539.505n 3.3v 549.495n 3.3v 549.505n 3.3v 559.495n 3.3v 559.505n 3.3v 569.495n 3.3v 569.505n 3.3v 579.495n 3.3v 579.505n 3.3v 589.495n 3.3v 589.505n 3.3v 599.495n 3.3v 599.505n 3.3v 609.495n 3.3v 609.505n 0.0v 619.495n 0.0v 619.505n 0.0v 629.495n 0.0v 629.505n 0.0v 639.495n 0.0v 639.505n 0.0v 649.495n 0.0v 649.505n 0.0v 659.495n 0.0v 659.505n 0.0v 669.495n 0.0v 669.505n 0.0v 679.495n 0.0v 679.505n 0.0v 689.495n 0.0v 689.505n 3.3v 699.495n 3.3v 699.505n 3.3v 709.495n 3.3v 709.505n 3.3v 719.495n 3.3v 719.505n 3.3v 729.495n 3.3v 729.505n 3.3v 739.495n 3.3v 739.505n 3.3v 749.495n 3.3v 749.505n 3.3v 759.495n 3.3v 759.505n 3.3v 769.495n 3.3v 769.505n 3.3v 779.495n 3.3v 779.505n 3.3v 789.495n 3.3v 789.505n 3.3v 799.495n 3.3v 799.505n 0.0v 809.495n 0.0v 809.505n 0.0v 819.495n 0.0v 819.505n 0.0v 829.495n 0.0v 829.505n 0.0v 839.495n 0.0v 839.505n 3.3v 849.495n 3.3v 849.505n 3.3v 859.495n 3.3v 859.505n 3.3v 869.495n 3.3v 869.505n 3.3v 879.495n 3.3v 879.505n 3.3v 889.495n 3.3v 889.505n 3.3v 899.495n 3.3v 899.505n 3.3v 909.495n 3.3v 909.505n 3.3v 919.495n 3.3v 919.505n 3.3v 929.495n 3.3v 929.505n 3.3v 939.495n 3.3v 939.505n 0.0v 949.495n 0.0v 949.505n 0.0v 959.495n 0.0v 959.505n 3.3v 969.495n 3.3v 969.505n 3.3v 979.495n 3.3v 979.505n 3.3v 989.495n 3.3v 989.505n 3.3v 999.495n 3.3v 999.505n 0.0v 1009.495n 0.0v 1009.505n 0.0v 1019.495n 0.0v 1019.505n 0.0v 1029.495n 0.0v 1029.505n 0.0v 1039.495n 0.0v 1039.505n 0.0v 1049.495n 0.0v 1049.505n 0.0v 1059.495n 0.0v 1059.505n 0.0v 1069.495n 0.0v 1069.505n 0.0v 1079.495n 0.0v 1079.505n 0.0v 1089.495n 0.0v 1089.505n 0.0v 1099.495n 0.0v 1099.505n 0.0v 1109.495n 0.0v 1109.505n 0.0v 1119.495n 0.0v 1119.505n 0.0v 1129.495n 0.0v 1129.505n 0.0v 1139.495n 0.0v 1139.505n 0.0v 1149.495n 0.0v 1149.505n 0.0v 1159.495n 0.0v 1159.505n 0.0v 1169.495n 0.0v 1169.505n 0.0v 1179.495n 0.0v 1179.505n 0.0v 1189.495n 0.0v 1189.505n 0.0v 1199.495n 0.0v 1199.505n 0.0v 1209.495n 0.0v 1209.505n 0.0v 1219.495n 0.0v 1219.505n 0.0v 1229.495n 0.0v 1229.505n 0.0v 1239.495n 0.0v 1239.505n 3.3v 1249.495n 3.3v 1249.505n 0.0v 1259.495n 0.0v 1259.505n 0.0v 1269.495n 0.0v 1269.505n 0.0v 1279.495n 0.0v 1279.505n 3.3v 1289.495n 3.3v 1289.505n 3.3v 1299.495n 3.3v 1299.505n 3.3v 1309.495n 3.3v 1309.505n 3.3v 1319.495n 3.3v 1319.505n 3.3v 1329.495n 3.3v 1329.505n 3.3v 1339.495n 3.3v 1339.505n 3.3v 1349.495n 3.3v 1349.505n 3.3v 1359.495n 3.3v 1359.505n 3.3v 1369.495n 3.3v 1369.505n 3.3v 1379.495n 3.3v 1379.505n 3.3v 1389.495n 3.3v 1389.505n 3.3v 1399.495n 3.3v 1399.505n 3.3v 1409.495n 3.3v 1409.505n 3.3v 1419.495n 3.3v 1419.505n 3.3v 1429.495n 3.3v 1429.505n 0.0v 1439.495n 0.0v 1439.505n 0.0v 1449.495n 0.0v 1449.505n 0.0v 1459.495n 0.0v 1459.505n 0.0v 1469.495n 0.0v 1469.505n 3.3v 1479.495n 3.3v 1479.505n 3.3v 1489.495n 3.3v 1489.505n 3.3v 1499.495n 3.3v 1499.505n 3.3v 1509.495n 3.3v 1509.505n 3.3v 1519.495n 3.3v 1519.505n 3.3v 1529.495n 3.3v 1529.505n 3.3v 1539.495n 3.3v 1539.505n 3.3v 1549.495n 3.3v 1549.505n 0.0v 1559.495n 0.0v 1559.505n 0.0v 1569.495n 0.0v 1569.505n 0.0v 1579.495n 0.0v 1579.505n 0.0v 1589.495n 0.0v 1589.505n 0.0v 1599.495n 0.0v 1599.505n 0.0v 1609.495n 0.0v 1609.505n 0.0v 1619.495n 0.0v 1619.505n 0.0v 1629.495n 0.0v 1629.505n 3.3v 1639.495n 3.3v 1639.505n 3.3v 1649.495n 3.3v 1649.505n 3.3v 1659.495n 3.3v 1659.505n 3.3v 1669.495n 3.3v 1669.505n 3.3v 1679.495n 3.3v 1679.505n 0.0v 1689.495n 0.0v 1689.505n 0.0v 1699.495n 0.0v 1699.505n 0.0v 1709.495n 0.0v 1709.505n 0.0v 1719.495n 0.0v 1719.505n 0.0v 1729.495n 0.0v 1729.505n 0.0v 1739.495n 0.0v 1739.505n 0.0v 1749.495n 0.0v 1749.505n 0.0v 1759.495n 0.0v 1759.505n 0.0v 1769.495n 0.0v 1769.505n 3.3v 1779.495n 3.3v 1779.505n 3.3v 1789.495n 3.3v 1789.505n 0.0v 1799.495n 0.0v 1799.505n 0.0v 1809.495n 0.0v 1809.505n 0.0v 1819.495n 0.0v 1819.505n 0.0v 1829.495n 0.0v 1829.505n 0.0v 1839.495n 0.0v 1839.505n 0.0v 1849.495n 0.0v 1849.505n 0.0v 1859.495n 0.0v 1859.505n 0.0v 1869.495n 0.0v 1869.505n 0.0v 1879.495n 0.0v 1879.505n 0.0v 1889.495n 0.0v 1889.505n 0.0v 1899.495n 0.0v 1899.505n 0.0v 1909.495n 0.0v 1909.505n 0.0v 1919.495n 0.0v 1919.505n 0.0v 1929.495n 0.0v 1929.505n 0.0v 1939.495n 0.0v 1939.505n 0.0v 1949.495n 0.0v 1949.505n 3.3v 1959.495n 3.3v 1959.505n 3.3v 1969.495n 3.3v 1969.505n 3.3v 1979.495n 3.3v 1979.505n 3.3v 1989.495n 3.3v 1989.505n 3.3v 1999.495n 3.3v 1999.505n 3.3v 2009.495n 3.3v 2009.505n 3.3v 2019.495n 3.3v 2019.505n 0.0v 2029.495n 0.0v 2029.505n 0.0v 2039.495n 0.0v 2039.505n 0.0v 2049.495n 0.0v 2049.505n 0.0v )
* (time, data): [(0, 0), (10, 0), (20, 0), (30, 0), (40, 0), (50, 0), (60, 0), (70, 1), (80, 1), (90, 1), (100, 1), (110, 1), (120, 1), (130, 1), (140, 1), (150, 0), (160, 0), (170, 0), (180, 1), (190, 1), (200, 1), (210, 1), (220, 1), (230, 0), (240, 0), (250, 0), (260, 0), (270, 0), (280, 0), (290, 0), (300, 0), (310, 0), (320, 0), (330, 0), (340, 0), (350, 0), (360, 1), (370, 1), (380, 1), (390, 1), (400, 1), (410, 1), (420, 1), (430, 1), (440, 0), (450, 0), (460, 0), (470, 0), (480, 0), (490, 0), (500, 0), (510, 0), (520, 0), (530, 0), (540, 1), (550, 1), (560, 1), (570, 1), (580, 1), (590, 1), (600, 1), (610, 0), (620, 0), (630, 0), (640, 0), (650, 0), (660, 0), (670, 0), (680, 0), (690, 0), (700, 0), (710, 0), (720, 0), (730, 0), (740, 1), (750, 0), (760, 0), (770, 0), (780, 0), (790, 0), (800, 0), (810, 0), (820, 1), (830, 1), (840, 1), (850, 1), (860, 1), (870, 1), (880, 1), (890, 1), (900, 1), (910, 1), (920, 1), (930, 1), (940, 1), (950, 1), (960, 1), (970, 1), (980, 1), (990, 1), (1000, 1), (1010, 1), (1020, 1), (1030, 1), (1040, 1), (1050, 1), (1060, 1), (1070, 1), (1080, 1), (1090, 1), (1100, 1), (1110, 1), (1120, 1), (1130, 1), (1140, 1), (1150, 1), (1160, 1), (1170, 1), (1180, 1), (1190, 1), (1200, 1), (1210, 1), (1220, 1), (1230, 1), (1240, 0), (1250, 0), (1260, 0), (1270, 0), (1280, 0), (1290, 0), (1300, 0), (1310, 0), (1320, 1), (1330, 1), (1340, 1), (1350, 1), (1360, 1), (1370, 1), (1380, 1), (1390, 1), (1400, 1), (1410, 1), (1420, 1), (1430, 1), (1440, 1), (1450, 1), (1460, 1), (1470, 0), (1480, 1), (1490, 1), (1500, 1), (1510, 1), (1520, 1), (1530, 1), (1540, 1), (1550, 1), (1560, 1), (1570, 0), (1580, 0), (1590, 0), (1600, 0), (1610, 0), (1620, 0), (1630, 1), (1640, 1), (1650, 1), (1660, 0), (1670, 0), (1680, 0), (1690, 0), (1700, 0), (1710, 0), (1720, 0), (1730, 0), (1740, 0), (1750, 0), (1760, 0), (1770, 0), (1780, 0), (1790, 0), (1800, 0), (1810, 0), (1820, 0), (1830, 0), (1840, 0), (1850, 0), (1860, 0), (1870, 0), (1880, 0), (1890, 0), (1900, 0), (1910, 0), (1920, 0), (1930, 0), (1940, 0), (1950, 1), (1960, 1), (1970, 1), (1980, 1), (1990, 1), (2000, 1), (2010, 1), (2020, 0), (2030, 1), (2040, 1), (2050, 1)]
Vdin1_11  din1_11  0 PWL (0n 0.0v 9.495n 0.0v 9.505n 0.0v 19.495n 0.0v 19.505n 0.0v 29.495n 0.0v 29.505n 0.0v 39.495n 0.0v 39.505n 0.0v 49.495n 0.0v 49.505n 0.0v 59.495n 0.0v 59.505n 0.0v 69.495n 0.0v 69.505n 3.3v 79.495n 3.3v 79.505n 3.3v 89.495n 3.3v 89.505n 3.3v 99.495n 3.3v 99.505n 3.3v 109.495n 3.3v 109.505n 3.3v 119.495n 3.3v 119.505n 3.3v 129.495n 3.3v 129.505n 3.3v 139.495n 3.3v 139.505n 3.3v 149.495n 3.3v 149.505n 0.0v 159.495n 0.0v 159.505n 0.0v 169.495n 0.0v 169.505n 0.0v 179.495n 0.0v 179.505n 3.3v 189.495n 3.3v 189.505n 3.3v 199.495n 3.3v 199.505n 3.3v 209.495n 3.3v 209.505n 3.3v 219.495n 3.3v 219.505n 3.3v 229.495n 3.3v 229.505n 0.0v 239.495n 0.0v 239.505n 0.0v 249.495n 0.0v 249.505n 0.0v 259.495n 0.0v 259.505n 0.0v 269.495n 0.0v 269.505n 0.0v 279.495n 0.0v 279.505n 0.0v 289.495n 0.0v 289.505n 0.0v 299.495n 0.0v 299.505n 0.0v 309.495n 0.0v 309.505n 0.0v 319.495n 0.0v 319.505n 0.0v 329.495n 0.0v 329.505n 0.0v 339.495n 0.0v 339.505n 0.0v 349.495n 0.0v 349.505n 0.0v 359.495n 0.0v 359.505n 3.3v 369.495n 3.3v 369.505n 3.3v 379.495n 3.3v 379.505n 3.3v 389.495n 3.3v 389.505n 3.3v 399.495n 3.3v 399.505n 3.3v 409.495n 3.3v 409.505n 3.3v 419.495n 3.3v 419.505n 3.3v 429.495n 3.3v 429.505n 3.3v 439.495n 3.3v 439.505n 0.0v 449.495n 0.0v 449.505n 0.0v 459.495n 0.0v 459.505n 0.0v 469.495n 0.0v 469.505n 0.0v 479.495n 0.0v 479.505n 0.0v 489.495n 0.0v 489.505n 0.0v 499.495n 0.0v 499.505n 0.0v 509.495n 0.0v 509.505n 0.0v 519.495n 0.0v 519.505n 0.0v 529.495n 0.0v 529.505n 0.0v 539.495n 0.0v 539.505n 3.3v 549.495n 3.3v 549.505n 3.3v 559.495n 3.3v 559.505n 3.3v 569.495n 3.3v 569.505n 3.3v 579.495n 3.3v 579.505n 3.3v 589.495n 3.3v 589.505n 3.3v 599.495n 3.3v 599.505n 3.3v 609.495n 3.3v 609.505n 0.0v 619.495n 0.0v 619.505n 0.0v 629.495n 0.0v 629.505n 0.0v 639.495n 0.0v 639.505n 0.0v 649.495n 0.0v 649.505n 0.0v 659.495n 0.0v 659.505n 0.0v 669.495n 0.0v 669.505n 0.0v 679.495n 0.0v 679.505n 0.0v 689.495n 0.0v 689.505n 0.0v 699.495n 0.0v 699.505n 0.0v 709.495n 0.0v 709.505n 0.0v 719.495n 0.0v 719.505n 0.0v 729.495n 0.0v 729.505n 0.0v 739.495n 0.0v 739.505n 3.3v 749.495n 3.3v 749.505n 0.0v 759.495n 0.0v 759.505n 0.0v 769.495n 0.0v 769.505n 0.0v 779.495n 0.0v 779.505n 0.0v 789.495n 0.0v 789.505n 0.0v 799.495n 0.0v 799.505n 0.0v 809.495n 0.0v 809.505n 0.0v 819.495n 0.0v 819.505n 3.3v 829.495n 3.3v 829.505n 3.3v 839.495n 3.3v 839.505n 3.3v 849.495n 3.3v 849.505n 3.3v 859.495n 3.3v 859.505n 3.3v 869.495n 3.3v 869.505n 3.3v 879.495n 3.3v 879.505n 3.3v 889.495n 3.3v 889.505n 3.3v 899.495n 3.3v 899.505n 3.3v 909.495n 3.3v 909.505n 3.3v 919.495n 3.3v 919.505n 3.3v 929.495n 3.3v 929.505n 3.3v 939.495n 3.3v 939.505n 3.3v 949.495n 3.3v 949.505n 3.3v 959.495n 3.3v 959.505n 3.3v 969.495n 3.3v 969.505n 3.3v 979.495n 3.3v 979.505n 3.3v 989.495n 3.3v 989.505n 3.3v 999.495n 3.3v 999.505n 3.3v 1009.495n 3.3v 1009.505n 3.3v 1019.495n 3.3v 1019.505n 3.3v 1029.495n 3.3v 1029.505n 3.3v 1039.495n 3.3v 1039.505n 3.3v 1049.495n 3.3v 1049.505n 3.3v 1059.495n 3.3v 1059.505n 3.3v 1069.495n 3.3v 1069.505n 3.3v 1079.495n 3.3v 1079.505n 3.3v 1089.495n 3.3v 1089.505n 3.3v 1099.495n 3.3v 1099.505n 3.3v 1109.495n 3.3v 1109.505n 3.3v 1119.495n 3.3v 1119.505n 3.3v 1129.495n 3.3v 1129.505n 3.3v 1139.495n 3.3v 1139.505n 3.3v 1149.495n 3.3v 1149.505n 3.3v 1159.495n 3.3v 1159.505n 3.3v 1169.495n 3.3v 1169.505n 3.3v 1179.495n 3.3v 1179.505n 3.3v 1189.495n 3.3v 1189.505n 3.3v 1199.495n 3.3v 1199.505n 3.3v 1209.495n 3.3v 1209.505n 3.3v 1219.495n 3.3v 1219.505n 3.3v 1229.495n 3.3v 1229.505n 3.3v 1239.495n 3.3v 1239.505n 0.0v 1249.495n 0.0v 1249.505n 0.0v 1259.495n 0.0v 1259.505n 0.0v 1269.495n 0.0v 1269.505n 0.0v 1279.495n 0.0v 1279.505n 0.0v 1289.495n 0.0v 1289.505n 0.0v 1299.495n 0.0v 1299.505n 0.0v 1309.495n 0.0v 1309.505n 0.0v 1319.495n 0.0v 1319.505n 3.3v 1329.495n 3.3v 1329.505n 3.3v 1339.495n 3.3v 1339.505n 3.3v 1349.495n 3.3v 1349.505n 3.3v 1359.495n 3.3v 1359.505n 3.3v 1369.495n 3.3v 1369.505n 3.3v 1379.495n 3.3v 1379.505n 3.3v 1389.495n 3.3v 1389.505n 3.3v 1399.495n 3.3v 1399.505n 3.3v 1409.495n 3.3v 1409.505n 3.3v 1419.495n 3.3v 1419.505n 3.3v 1429.495n 3.3v 1429.505n 3.3v 1439.495n 3.3v 1439.505n 3.3v 1449.495n 3.3v 1449.505n 3.3v 1459.495n 3.3v 1459.505n 3.3v 1469.495n 3.3v 1469.505n 0.0v 1479.495n 0.0v 1479.505n 3.3v 1489.495n 3.3v 1489.505n 3.3v 1499.495n 3.3v 1499.505n 3.3v 1509.495n 3.3v 1509.505n 3.3v 1519.495n 3.3v 1519.505n 3.3v 1529.495n 3.3v 1529.505n 3.3v 1539.495n 3.3v 1539.505n 3.3v 1549.495n 3.3v 1549.505n 3.3v 1559.495n 3.3v 1559.505n 3.3v 1569.495n 3.3v 1569.505n 0.0v 1579.495n 0.0v 1579.505n 0.0v 1589.495n 0.0v 1589.505n 0.0v 1599.495n 0.0v 1599.505n 0.0v 1609.495n 0.0v 1609.505n 0.0v 1619.495n 0.0v 1619.505n 0.0v 1629.495n 0.0v 1629.505n 3.3v 1639.495n 3.3v 1639.505n 3.3v 1649.495n 3.3v 1649.505n 3.3v 1659.495n 3.3v 1659.505n 0.0v 1669.495n 0.0v 1669.505n 0.0v 1679.495n 0.0v 1679.505n 0.0v 1689.495n 0.0v 1689.505n 0.0v 1699.495n 0.0v 1699.505n 0.0v 1709.495n 0.0v 1709.505n 0.0v 1719.495n 0.0v 1719.505n 0.0v 1729.495n 0.0v 1729.505n 0.0v 1739.495n 0.0v 1739.505n 0.0v 1749.495n 0.0v 1749.505n 0.0v 1759.495n 0.0v 1759.505n 0.0v 1769.495n 0.0v 1769.505n 0.0v 1779.495n 0.0v 1779.505n 0.0v 1789.495n 0.0v 1789.505n 0.0v 1799.495n 0.0v 1799.505n 0.0v 1809.495n 0.0v 1809.505n 0.0v 1819.495n 0.0v 1819.505n 0.0v 1829.495n 0.0v 1829.505n 0.0v 1839.495n 0.0v 1839.505n 0.0v 1849.495n 0.0v 1849.505n 0.0v 1859.495n 0.0v 1859.505n 0.0v 1869.495n 0.0v 1869.505n 0.0v 1879.495n 0.0v 1879.505n 0.0v 1889.495n 0.0v 1889.505n 0.0v 1899.495n 0.0v 1899.505n 0.0v 1909.495n 0.0v 1909.505n 0.0v 1919.495n 0.0v 1919.505n 0.0v 1929.495n 0.0v 1929.505n 0.0v 1939.495n 0.0v 1939.505n 0.0v 1949.495n 0.0v 1949.505n 3.3v 1959.495n 3.3v 1959.505n 3.3v 1969.495n 3.3v 1969.505n 3.3v 1979.495n 3.3v 1979.505n 3.3v 1989.495n 3.3v 1989.505n 3.3v 1999.495n 3.3v 1999.505n 3.3v 2009.495n 3.3v 2009.505n 3.3v 2019.495n 3.3v 2019.505n 0.0v 2029.495n 0.0v 2029.505n 3.3v 2039.495n 3.3v 2039.505n 3.3v 2049.495n 3.3v 2049.505n 3.3v )
* (time, data): [(0, 0), (10, 1), (20, 0), (30, 0), (40, 0), (50, 1), (60, 0), (70, 0), (80, 0), (90, 0), (100, 0), (110, 0), (120, 0), (130, 0), (140, 0), (150, 1), (160, 1), (170, 1), (180, 1), (190, 1), (200, 1), (210, 1), (220, 1), (230, 0), (240, 0), (250, 0), (260, 0), (270, 0), (280, 0), (290, 0), (300, 0), (310, 0), (320, 0), (330, 0), (340, 0), (350, 0), (360, 0), (370, 0), (380, 0), (390, 0), (400, 0), (410, 0), (420, 0), (430, 0), (440, 0), (450, 0), (460, 0), (470, 0), (480, 0), (490, 0), (500, 0), (510, 0), (520, 0), (530, 0), (540, 0), (550, 0), (560, 0), (570, 0), (580, 0), (590, 0), (600, 0), (610, 0), (620, 0), (630, 0), (640, 0), (650, 0), (660, 0), (670, 0), (680, 0), (690, 1), (700, 1), (710, 1), (720, 1), (730, 1), (740, 1), (750, 1), (760, 1), (770, 0), (780, 0), (790, 0), (800, 0), (810, 0), (820, 1), (830, 1), (840, 1), (850, 1), (860, 1), (870, 1), (880, 1), (890, 1), (900, 1), (910, 1), (920, 1), (930, 1), (940, 0), (950, 0), (960, 1), (970, 1), (980, 1), (990, 1), (1000, 0), (1010, 0), (1020, 0), (1030, 0), (1040, 0), (1050, 0), (1060, 0), (1070, 0), (1080, 1), (1090, 1), (1100, 1), (1110, 1), (1120, 1), (1130, 1), (1140, 1), (1150, 1), (1160, 1), (1170, 1), (1180, 1), (1190, 1), (1200, 1), (1210, 1), (1220, 1), (1230, 1), (1240, 0), (1250, 1), (1260, 1), (1270, 1), (1280, 0), (1290, 0), (1300, 0), (1310, 0), (1320, 0), (1330, 0), (1340, 0), (1350, 0), (1360, 0), (1370, 0), (1380, 0), (1390, 0), (1400, 0), (1410, 0), (1420, 0), (1430, 0), (1440, 1), (1450, 1), (1460, 1), (1470, 0), (1480, 1), (1490, 1), (1500, 1), (1510, 1), (1520, 1), (1530, 1), (1540, 1), (1550, 1), (1560, 1), (1570, 0), (1580, 0), (1590, 0), (1600, 0), (1610, 1), (1620, 1), (1630, 0), (1640, 0), (1650, 0), (1660, 0), (1670, 0), (1680, 1), (1690, 1), (1700, 1), (1710, 1), (1720, 1), (1730, 1), (1740, 1), (1750, 1), (1760, 1), (1770, 1), (1780, 1), (1790, 1), (1800, 1), (1810, 1), (1820, 1), (1830, 1), (1840, 1), (1850, 1), (1860, 1), (1870, 1), (1880, 1), (1890, 1), (1900, 1), (1910, 1), (1920, 1), (1930, 1), (1940, 1), (1950, 1), (1960, 1), (1970, 1), (1980, 0), (1990, 0), (2000, 0), (2010, 0), (2020, 0), (2030, 1), (2040, 1), (2050, 1)]
Vdin1_12  din1_12  0 PWL (0n 0.0v 9.495n 0.0v 9.505n 3.3v 19.495n 3.3v 19.505n 0.0v 29.495n 0.0v 29.505n 0.0v 39.495n 0.0v 39.505n 0.0v 49.495n 0.0v 49.505n 3.3v 59.495n 3.3v 59.505n 0.0v 69.495n 0.0v 69.505n 0.0v 79.495n 0.0v 79.505n 0.0v 89.495n 0.0v 89.505n 0.0v 99.495n 0.0v 99.505n 0.0v 109.495n 0.0v 109.505n 0.0v 119.495n 0.0v 119.505n 0.0v 129.495n 0.0v 129.505n 0.0v 139.495n 0.0v 139.505n 0.0v 149.495n 0.0v 149.505n 3.3v 159.495n 3.3v 159.505n 3.3v 169.495n 3.3v 169.505n 3.3v 179.495n 3.3v 179.505n 3.3v 189.495n 3.3v 189.505n 3.3v 199.495n 3.3v 199.505n 3.3v 209.495n 3.3v 209.505n 3.3v 219.495n 3.3v 219.505n 3.3v 229.495n 3.3v 229.505n 0.0v 239.495n 0.0v 239.505n 0.0v 249.495n 0.0v 249.505n 0.0v 259.495n 0.0v 259.505n 0.0v 269.495n 0.0v 269.505n 0.0v 279.495n 0.0v 279.505n 0.0v 289.495n 0.0v 289.505n 0.0v 299.495n 0.0v 299.505n 0.0v 309.495n 0.0v 309.505n 0.0v 319.495n 0.0v 319.505n 0.0v 329.495n 0.0v 329.505n 0.0v 339.495n 0.0v 339.505n 0.0v 349.495n 0.0v 349.505n 0.0v 359.495n 0.0v 359.505n 0.0v 369.495n 0.0v 369.505n 0.0v 379.495n 0.0v 379.505n 0.0v 389.495n 0.0v 389.505n 0.0v 399.495n 0.0v 399.505n 0.0v 409.495n 0.0v 409.505n 0.0v 419.495n 0.0v 419.505n 0.0v 429.495n 0.0v 429.505n 0.0v 439.495n 0.0v 439.505n 0.0v 449.495n 0.0v 449.505n 0.0v 459.495n 0.0v 459.505n 0.0v 469.495n 0.0v 469.505n 0.0v 479.495n 0.0v 479.505n 0.0v 489.495n 0.0v 489.505n 0.0v 499.495n 0.0v 499.505n 0.0v 509.495n 0.0v 509.505n 0.0v 519.495n 0.0v 519.505n 0.0v 529.495n 0.0v 529.505n 0.0v 539.495n 0.0v 539.505n 0.0v 549.495n 0.0v 549.505n 0.0v 559.495n 0.0v 559.505n 0.0v 569.495n 0.0v 569.505n 0.0v 579.495n 0.0v 579.505n 0.0v 589.495n 0.0v 589.505n 0.0v 599.495n 0.0v 599.505n 0.0v 609.495n 0.0v 609.505n 0.0v 619.495n 0.0v 619.505n 0.0v 629.495n 0.0v 629.505n 0.0v 639.495n 0.0v 639.505n 0.0v 649.495n 0.0v 649.505n 0.0v 659.495n 0.0v 659.505n 0.0v 669.495n 0.0v 669.505n 0.0v 679.495n 0.0v 679.505n 0.0v 689.495n 0.0v 689.505n 3.3v 699.495n 3.3v 699.505n 3.3v 709.495n 3.3v 709.505n 3.3v 719.495n 3.3v 719.505n 3.3v 729.495n 3.3v 729.505n 3.3v 739.495n 3.3v 739.505n 3.3v 749.495n 3.3v 749.505n 3.3v 759.495n 3.3v 759.505n 3.3v 769.495n 3.3v 769.505n 0.0v 779.495n 0.0v 779.505n 0.0v 789.495n 0.0v 789.505n 0.0v 799.495n 0.0v 799.505n 0.0v 809.495n 0.0v 809.505n 0.0v 819.495n 0.0v 819.505n 3.3v 829.495n 3.3v 829.505n 3.3v 839.495n 3.3v 839.505n 3.3v 849.495n 3.3v 849.505n 3.3v 859.495n 3.3v 859.505n 3.3v 869.495n 3.3v 869.505n 3.3v 879.495n 3.3v 879.505n 3.3v 889.495n 3.3v 889.505n 3.3v 899.495n 3.3v 899.505n 3.3v 909.495n 3.3v 909.505n 3.3v 919.495n 3.3v 919.505n 3.3v 929.495n 3.3v 929.505n 3.3v 939.495n 3.3v 939.505n 0.0v 949.495n 0.0v 949.505n 0.0v 959.495n 0.0v 959.505n 3.3v 969.495n 3.3v 969.505n 3.3v 979.495n 3.3v 979.505n 3.3v 989.495n 3.3v 989.505n 3.3v 999.495n 3.3v 999.505n 0.0v 1009.495n 0.0v 1009.505n 0.0v 1019.495n 0.0v 1019.505n 0.0v 1029.495n 0.0v 1029.505n 0.0v 1039.495n 0.0v 1039.505n 0.0v 1049.495n 0.0v 1049.505n 0.0v 1059.495n 0.0v 1059.505n 0.0v 1069.495n 0.0v 1069.505n 0.0v 1079.495n 0.0v 1079.505n 3.3v 1089.495n 3.3v 1089.505n 3.3v 1099.495n 3.3v 1099.505n 3.3v 1109.495n 3.3v 1109.505n 3.3v 1119.495n 3.3v 1119.505n 3.3v 1129.495n 3.3v 1129.505n 3.3v 1139.495n 3.3v 1139.505n 3.3v 1149.495n 3.3v 1149.505n 3.3v 1159.495n 3.3v 1159.505n 3.3v 1169.495n 3.3v 1169.505n 3.3v 1179.495n 3.3v 1179.505n 3.3v 1189.495n 3.3v 1189.505n 3.3v 1199.495n 3.3v 1199.505n 3.3v 1209.495n 3.3v 1209.505n 3.3v 1219.495n 3.3v 1219.505n 3.3v 1229.495n 3.3v 1229.505n 3.3v 1239.495n 3.3v 1239.505n 0.0v 1249.495n 0.0v 1249.505n 3.3v 1259.495n 3.3v 1259.505n 3.3v 1269.495n 3.3v 1269.505n 3.3v 1279.495n 3.3v 1279.505n 0.0v 1289.495n 0.0v 1289.505n 0.0v 1299.495n 0.0v 1299.505n 0.0v 1309.495n 0.0v 1309.505n 0.0v 1319.495n 0.0v 1319.505n 0.0v 1329.495n 0.0v 1329.505n 0.0v 1339.495n 0.0v 1339.505n 0.0v 1349.495n 0.0v 1349.505n 0.0v 1359.495n 0.0v 1359.505n 0.0v 1369.495n 0.0v 1369.505n 0.0v 1379.495n 0.0v 1379.505n 0.0v 1389.495n 0.0v 1389.505n 0.0v 1399.495n 0.0v 1399.505n 0.0v 1409.495n 0.0v 1409.505n 0.0v 1419.495n 0.0v 1419.505n 0.0v 1429.495n 0.0v 1429.505n 0.0v 1439.495n 0.0v 1439.505n 3.3v 1449.495n 3.3v 1449.505n 3.3v 1459.495n 3.3v 1459.505n 3.3v 1469.495n 3.3v 1469.505n 0.0v 1479.495n 0.0v 1479.505n 3.3v 1489.495n 3.3v 1489.505n 3.3v 1499.495n 3.3v 1499.505n 3.3v 1509.495n 3.3v 1509.505n 3.3v 1519.495n 3.3v 1519.505n 3.3v 1529.495n 3.3v 1529.505n 3.3v 1539.495n 3.3v 1539.505n 3.3v 1549.495n 3.3v 1549.505n 3.3v 1559.495n 3.3v 1559.505n 3.3v 1569.495n 3.3v 1569.505n 0.0v 1579.495n 0.0v 1579.505n 0.0v 1589.495n 0.0v 1589.505n 0.0v 1599.495n 0.0v 1599.505n 0.0v 1609.495n 0.0v 1609.505n 3.3v 1619.495n 3.3v 1619.505n 3.3v 1629.495n 3.3v 1629.505n 0.0v 1639.495n 0.0v 1639.505n 0.0v 1649.495n 0.0v 1649.505n 0.0v 1659.495n 0.0v 1659.505n 0.0v 1669.495n 0.0v 1669.505n 0.0v 1679.495n 0.0v 1679.505n 3.3v 1689.495n 3.3v 1689.505n 3.3v 1699.495n 3.3v 1699.505n 3.3v 1709.495n 3.3v 1709.505n 3.3v 1719.495n 3.3v 1719.505n 3.3v 1729.495n 3.3v 1729.505n 3.3v 1739.495n 3.3v 1739.505n 3.3v 1749.495n 3.3v 1749.505n 3.3v 1759.495n 3.3v 1759.505n 3.3v 1769.495n 3.3v 1769.505n 3.3v 1779.495n 3.3v 1779.505n 3.3v 1789.495n 3.3v 1789.505n 3.3v 1799.495n 3.3v 1799.505n 3.3v 1809.495n 3.3v 1809.505n 3.3v 1819.495n 3.3v 1819.505n 3.3v 1829.495n 3.3v 1829.505n 3.3v 1839.495n 3.3v 1839.505n 3.3v 1849.495n 3.3v 1849.505n 3.3v 1859.495n 3.3v 1859.505n 3.3v 1869.495n 3.3v 1869.505n 3.3v 1879.495n 3.3v 1879.505n 3.3v 1889.495n 3.3v 1889.505n 3.3v 1899.495n 3.3v 1899.505n 3.3v 1909.495n 3.3v 1909.505n 3.3v 1919.495n 3.3v 1919.505n 3.3v 1929.495n 3.3v 1929.505n 3.3v 1939.495n 3.3v 1939.505n 3.3v 1949.495n 3.3v 1949.505n 3.3v 1959.495n 3.3v 1959.505n 3.3v 1969.495n 3.3v 1969.505n 3.3v 1979.495n 3.3v 1979.505n 0.0v 1989.495n 0.0v 1989.505n 0.0v 1999.495n 0.0v 1999.505n 0.0v 2009.495n 0.0v 2009.505n 0.0v 2019.495n 0.0v 2019.505n 0.0v 2029.495n 0.0v 2029.505n 3.3v 2039.495n 3.3v 2039.505n 3.3v 2049.495n 3.3v 2049.505n 3.3v )
* (time, data): [(0, 0), (10, 0), (20, 1), (30, 0), (40, 0), (50, 1), (60, 1), (70, 0), (80, 0), (90, 0), (100, 1), (110, 1), (120, 1), (130, 1), (140, 1), (150, 0), (160, 0), (170, 0), (180, 1), (190, 1), (200, 1), (210, 1), (220, 1), (230, 0), (240, 0), (250, 0), (260, 0), (270, 0), (280, 0), (290, 0), (300, 0), (310, 0), (320, 0), (330, 1), (340, 1), (350, 1), (360, 1), (370, 1), (380, 1), (390, 1), (400, 1), (410, 1), (420, 1), (430, 1), (440, 0), (450, 0), (460, 0), (470, 0), (480, 0), (490, 0), (500, 0), (510, 0), (520, 0), (530, 0), (540, 0), (550, 0), (560, 0), (570, 0), (580, 0), (590, 0), (600, 0), (610, 1), (620, 1), (630, 0), (640, 0), (650, 0), (660, 0), (670, 0), (680, 0), (690, 0), (700, 0), (710, 0), (720, 0), (730, 0), (740, 0), (750, 0), (760, 0), (770, 1), (780, 1), (790, 1), (800, 0), (810, 0), (820, 0), (830, 0), (840, 0), (850, 0), (860, 0), (870, 0), (880, 0), (890, 0), (900, 0), (910, 0), (920, 0), (930, 0), (940, 1), (950, 1), (960, 0), (970, 0), (980, 0), (990, 0), (1000, 0), (1010, 0), (1020, 0), (1030, 0), (1040, 0), (1050, 0), (1060, 0), (1070, 0), (1080, 1), (1090, 0), (1100, 0), (1110, 0), (1120, 0), (1130, 0), (1140, 0), (1150, 0), (1160, 0), (1170, 0), (1180, 0), (1190, 0), (1200, 0), (1210, 0), (1220, 0), (1230, 0), (1240, 1), (1250, 0), (1260, 0), (1270, 0), (1280, 1), (1290, 1), (1300, 1), (1310, 1), (1320, 1), (1330, 1), (1340, 0), (1350, 0), (1360, 0), (1370, 0), (1380, 0), (1390, 1), (1400, 1), (1410, 1), (1420, 1), (1430, 0), (1440, 1), (1450, 1), (1460, 1), (1470, 1), (1480, 0), (1490, 0), (1500, 0), (1510, 0), (1520, 0), (1530, 0), (1540, 0), (1550, 0), (1560, 0), (1570, 0), (1580, 0), (1590, 0), (1600, 0), (1610, 1), (1620, 1), (1630, 0), (1640, 0), (1650, 0), (1660, 0), (1670, 0), (1680, 0), (1690, 0), (1700, 0), (1710, 0), (1720, 0), (1730, 0), (1740, 0), (1750, 0), (1760, 0), (1770, 1), (1780, 1), (1790, 0), (1800, 0), (1810, 0), (1820, 0), (1830, 0), (1840, 0), (1850, 0), (1860, 0), (1870, 0), (1880, 0), (1890, 0), (1900, 0), (1910, 0), (1920, 0), (1930, 0), (1940, 0), (1950, 0), (1960, 0), (1970, 0), (1980, 1), (1990, 1), (2000, 1), (2010, 1), (2020, 0), (2030, 0), (2040, 0), (2050, 0)]
Vdin1_13  din1_13  0 PWL (0n 0.0v 9.495n 0.0v 9.505n 0.0v 19.495n 0.0v 19.505n 3.3v 29.495n 3.3v 29.505n 0.0v 39.495n 0.0v 39.505n 0.0v 49.495n 0.0v 49.505n 3.3v 59.495n 3.3v 59.505n 3.3v 69.495n 3.3v 69.505n 0.0v 79.495n 0.0v 79.505n 0.0v 89.495n 0.0v 89.505n 0.0v 99.495n 0.0v 99.505n 3.3v 109.495n 3.3v 109.505n 3.3v 119.495n 3.3v 119.505n 3.3v 129.495n 3.3v 129.505n 3.3v 139.495n 3.3v 139.505n 3.3v 149.495n 3.3v 149.505n 0.0v 159.495n 0.0v 159.505n 0.0v 169.495n 0.0v 169.505n 0.0v 179.495n 0.0v 179.505n 3.3v 189.495n 3.3v 189.505n 3.3v 199.495n 3.3v 199.505n 3.3v 209.495n 3.3v 209.505n 3.3v 219.495n 3.3v 219.505n 3.3v 229.495n 3.3v 229.505n 0.0v 239.495n 0.0v 239.505n 0.0v 249.495n 0.0v 249.505n 0.0v 259.495n 0.0v 259.505n 0.0v 269.495n 0.0v 269.505n 0.0v 279.495n 0.0v 279.505n 0.0v 289.495n 0.0v 289.505n 0.0v 299.495n 0.0v 299.505n 0.0v 309.495n 0.0v 309.505n 0.0v 319.495n 0.0v 319.505n 0.0v 329.495n 0.0v 329.505n 3.3v 339.495n 3.3v 339.505n 3.3v 349.495n 3.3v 349.505n 3.3v 359.495n 3.3v 359.505n 3.3v 369.495n 3.3v 369.505n 3.3v 379.495n 3.3v 379.505n 3.3v 389.495n 3.3v 389.505n 3.3v 399.495n 3.3v 399.505n 3.3v 409.495n 3.3v 409.505n 3.3v 419.495n 3.3v 419.505n 3.3v 429.495n 3.3v 429.505n 3.3v 439.495n 3.3v 439.505n 0.0v 449.495n 0.0v 449.505n 0.0v 459.495n 0.0v 459.505n 0.0v 469.495n 0.0v 469.505n 0.0v 479.495n 0.0v 479.505n 0.0v 489.495n 0.0v 489.505n 0.0v 499.495n 0.0v 499.505n 0.0v 509.495n 0.0v 509.505n 0.0v 519.495n 0.0v 519.505n 0.0v 529.495n 0.0v 529.505n 0.0v 539.495n 0.0v 539.505n 0.0v 549.495n 0.0v 549.505n 0.0v 559.495n 0.0v 559.505n 0.0v 569.495n 0.0v 569.505n 0.0v 579.495n 0.0v 579.505n 0.0v 589.495n 0.0v 589.505n 0.0v 599.495n 0.0v 599.505n 0.0v 609.495n 0.0v 609.505n 3.3v 619.495n 3.3v 619.505n 3.3v 629.495n 3.3v 629.505n 0.0v 639.495n 0.0v 639.505n 0.0v 649.495n 0.0v 649.505n 0.0v 659.495n 0.0v 659.505n 0.0v 669.495n 0.0v 669.505n 0.0v 679.495n 0.0v 679.505n 0.0v 689.495n 0.0v 689.505n 0.0v 699.495n 0.0v 699.505n 0.0v 709.495n 0.0v 709.505n 0.0v 719.495n 0.0v 719.505n 0.0v 729.495n 0.0v 729.505n 0.0v 739.495n 0.0v 739.505n 0.0v 749.495n 0.0v 749.505n 0.0v 759.495n 0.0v 759.505n 0.0v 769.495n 0.0v 769.505n 3.3v 779.495n 3.3v 779.505n 3.3v 789.495n 3.3v 789.505n 3.3v 799.495n 3.3v 799.505n 0.0v 809.495n 0.0v 809.505n 0.0v 819.495n 0.0v 819.505n 0.0v 829.495n 0.0v 829.505n 0.0v 839.495n 0.0v 839.505n 0.0v 849.495n 0.0v 849.505n 0.0v 859.495n 0.0v 859.505n 0.0v 869.495n 0.0v 869.505n 0.0v 879.495n 0.0v 879.505n 0.0v 889.495n 0.0v 889.505n 0.0v 899.495n 0.0v 899.505n 0.0v 909.495n 0.0v 909.505n 0.0v 919.495n 0.0v 919.505n 0.0v 929.495n 0.0v 929.505n 0.0v 939.495n 0.0v 939.505n 3.3v 949.495n 3.3v 949.505n 3.3v 959.495n 3.3v 959.505n 0.0v 969.495n 0.0v 969.505n 0.0v 979.495n 0.0v 979.505n 0.0v 989.495n 0.0v 989.505n 0.0v 999.495n 0.0v 999.505n 0.0v 1009.495n 0.0v 1009.505n 0.0v 1019.495n 0.0v 1019.505n 0.0v 1029.495n 0.0v 1029.505n 0.0v 1039.495n 0.0v 1039.505n 0.0v 1049.495n 0.0v 1049.505n 0.0v 1059.495n 0.0v 1059.505n 0.0v 1069.495n 0.0v 1069.505n 0.0v 1079.495n 0.0v 1079.505n 3.3v 1089.495n 3.3v 1089.505n 0.0v 1099.495n 0.0v 1099.505n 0.0v 1109.495n 0.0v 1109.505n 0.0v 1119.495n 0.0v 1119.505n 0.0v 1129.495n 0.0v 1129.505n 0.0v 1139.495n 0.0v 1139.505n 0.0v 1149.495n 0.0v 1149.505n 0.0v 1159.495n 0.0v 1159.505n 0.0v 1169.495n 0.0v 1169.505n 0.0v 1179.495n 0.0v 1179.505n 0.0v 1189.495n 0.0v 1189.505n 0.0v 1199.495n 0.0v 1199.505n 0.0v 1209.495n 0.0v 1209.505n 0.0v 1219.495n 0.0v 1219.505n 0.0v 1229.495n 0.0v 1229.505n 0.0v 1239.495n 0.0v 1239.505n 3.3v 1249.495n 3.3v 1249.505n 0.0v 1259.495n 0.0v 1259.505n 0.0v 1269.495n 0.0v 1269.505n 0.0v 1279.495n 0.0v 1279.505n 3.3v 1289.495n 3.3v 1289.505n 3.3v 1299.495n 3.3v 1299.505n 3.3v 1309.495n 3.3v 1309.505n 3.3v 1319.495n 3.3v 1319.505n 3.3v 1329.495n 3.3v 1329.505n 3.3v 1339.495n 3.3v 1339.505n 0.0v 1349.495n 0.0v 1349.505n 0.0v 1359.495n 0.0v 1359.505n 0.0v 1369.495n 0.0v 1369.505n 0.0v 1379.495n 0.0v 1379.505n 0.0v 1389.495n 0.0v 1389.505n 3.3v 1399.495n 3.3v 1399.505n 3.3v 1409.495n 3.3v 1409.505n 3.3v 1419.495n 3.3v 1419.505n 3.3v 1429.495n 3.3v 1429.505n 0.0v 1439.495n 0.0v 1439.505n 3.3v 1449.495n 3.3v 1449.505n 3.3v 1459.495n 3.3v 1459.505n 3.3v 1469.495n 3.3v 1469.505n 3.3v 1479.495n 3.3v 1479.505n 0.0v 1489.495n 0.0v 1489.505n 0.0v 1499.495n 0.0v 1499.505n 0.0v 1509.495n 0.0v 1509.505n 0.0v 1519.495n 0.0v 1519.505n 0.0v 1529.495n 0.0v 1529.505n 0.0v 1539.495n 0.0v 1539.505n 0.0v 1549.495n 0.0v 1549.505n 0.0v 1559.495n 0.0v 1559.505n 0.0v 1569.495n 0.0v 1569.505n 0.0v 1579.495n 0.0v 1579.505n 0.0v 1589.495n 0.0v 1589.505n 0.0v 1599.495n 0.0v 1599.505n 0.0v 1609.495n 0.0v 1609.505n 3.3v 1619.495n 3.3v 1619.505n 3.3v 1629.495n 3.3v 1629.505n 0.0v 1639.495n 0.0v 1639.505n 0.0v 1649.495n 0.0v 1649.505n 0.0v 1659.495n 0.0v 1659.505n 0.0v 1669.495n 0.0v 1669.505n 0.0v 1679.495n 0.0v 1679.505n 0.0v 1689.495n 0.0v 1689.505n 0.0v 1699.495n 0.0v 1699.505n 0.0v 1709.495n 0.0v 1709.505n 0.0v 1719.495n 0.0v 1719.505n 0.0v 1729.495n 0.0v 1729.505n 0.0v 1739.495n 0.0v 1739.505n 0.0v 1749.495n 0.0v 1749.505n 0.0v 1759.495n 0.0v 1759.505n 0.0v 1769.495n 0.0v 1769.505n 3.3v 1779.495n 3.3v 1779.505n 3.3v 1789.495n 3.3v 1789.505n 0.0v 1799.495n 0.0v 1799.505n 0.0v 1809.495n 0.0v 1809.505n 0.0v 1819.495n 0.0v 1819.505n 0.0v 1829.495n 0.0v 1829.505n 0.0v 1839.495n 0.0v 1839.505n 0.0v 1849.495n 0.0v 1849.505n 0.0v 1859.495n 0.0v 1859.505n 0.0v 1869.495n 0.0v 1869.505n 0.0v 1879.495n 0.0v 1879.505n 0.0v 1889.495n 0.0v 1889.505n 0.0v 1899.495n 0.0v 1899.505n 0.0v 1909.495n 0.0v 1909.505n 0.0v 1919.495n 0.0v 1919.505n 0.0v 1929.495n 0.0v 1929.505n 0.0v 1939.495n 0.0v 1939.505n 0.0v 1949.495n 0.0v 1949.505n 0.0v 1959.495n 0.0v 1959.505n 0.0v 1969.495n 0.0v 1969.505n 0.0v 1979.495n 0.0v 1979.505n 3.3v 1989.495n 3.3v 1989.505n 3.3v 1999.495n 3.3v 1999.505n 3.3v 2009.495n 3.3v 2009.505n 3.3v 2019.495n 3.3v 2019.505n 0.0v 2029.495n 0.0v 2029.505n 0.0v 2039.495n 0.0v 2039.505n 0.0v 2049.495n 0.0v 2049.505n 0.0v )
* (time, data): [(0, 0), (10, 0), (20, 0), (30, 0), (40, 0), (50, 0), (60, 1), (70, 0), (80, 0), (90, 0), (100, 0), (110, 0), (120, 0), (130, 0), (140, 0), (150, 0), (160, 0), (170, 0), (180, 1), (190, 1), (200, 1), (210, 1), (220, 1), (230, 1), (240, 1), (250, 1), (260, 1), (270, 1), (280, 1), (290, 1), (300, 1), (310, 1), (320, 1), (330, 0), (340, 0), (350, 0), (360, 1), (370, 1), (380, 1), (390, 1), (400, 1), (410, 1), (420, 1), (430, 1), (440, 0), (450, 0), (460, 0), (470, 0), (480, 0), (490, 0), (500, 0), (510, 0), (520, 0), (530, 0), (540, 1), (550, 1), (560, 1), (570, 1), (580, 1), (590, 1), (600, 1), (610, 0), (620, 0), (630, 1), (640, 1), (650, 1), (660, 1), (670, 1), (680, 1), (690, 1), (700, 1), (710, 1), (720, 1), (730, 1), (740, 0), (750, 1), (760, 1), (770, 1), (780, 1), (790, 1), (800, 0), (810, 0), (820, 1), (830, 1), (840, 1), (850, 1), (860, 1), (870, 1), (880, 1), (890, 1), (900, 1), (910, 1), (920, 1), (930, 1), (940, 0), (950, 0), (960, 0), (970, 0), (980, 0), (990, 0), (1000, 1), (1010, 1), (1020, 1), (1030, 1), (1040, 1), (1050, 1), (1060, 1), (1070, 1), (1080, 0), (1090, 0), (1100, 0), (1110, 0), (1120, 0), (1130, 0), (1140, 0), (1150, 0), (1160, 0), (1170, 0), (1180, 0), (1190, 0), (1200, 0), (1210, 0), (1220, 0), (1230, 0), (1240, 0), (1250, 1), (1260, 1), (1270, 1), (1280, 1), (1290, 1), (1300, 1), (1310, 1), (1320, 1), (1330, 1), (1340, 0), (1350, 0), (1360, 1), (1370, 1), (1380, 1), (1390, 0), (1400, 0), (1410, 0), (1420, 0), (1430, 1), (1440, 0), (1450, 0), (1460, 0), (1470, 1), (1480, 0), (1490, 0), (1500, 0), (1510, 0), (1520, 0), (1530, 0), (1540, 0), (1550, 0), (1560, 0), (1570, 1), (1580, 1), (1590, 1), (1600, 1), (1610, 1), (1620, 1), (1630, 1), (1640, 1), (1650, 1), (1660, 1), (1670, 1), (1680, 1), (1690, 1), (1700, 1), (1710, 1), (1720, 1), (1730, 1), (1740, 1), (1750, 1), (1760, 1), (1770, 1), (1780, 1), (1790, 0), (1800, 0), (1810, 0), (1820, 0), (1830, 0), (1840, 0), (1850, 0), (1860, 0), (1870, 0), (1880, 0), (1890, 0), (1900, 0), (1910, 0), (1920, 0), (1930, 0), (1940, 0), (1950, 0), (1960, 0), (1970, 0), (1980, 1), (1990, 1), (2000, 1), (2010, 1), (2020, 0), (2030, 1), (2040, 1), (2050, 1)]
Vdin1_14  din1_14  0 PWL (0n 0.0v 9.495n 0.0v 9.505n 0.0v 19.495n 0.0v 19.505n 0.0v 29.495n 0.0v 29.505n 0.0v 39.495n 0.0v 39.505n 0.0v 49.495n 0.0v 49.505n 0.0v 59.495n 0.0v 59.505n 3.3v 69.495n 3.3v 69.505n 0.0v 79.495n 0.0v 79.505n 0.0v 89.495n 0.0v 89.505n 0.0v 99.495n 0.0v 99.505n 0.0v 109.495n 0.0v 109.505n 0.0v 119.495n 0.0v 119.505n 0.0v 129.495n 0.0v 129.505n 0.0v 139.495n 0.0v 139.505n 0.0v 149.495n 0.0v 149.505n 0.0v 159.495n 0.0v 159.505n 0.0v 169.495n 0.0v 169.505n 0.0v 179.495n 0.0v 179.505n 3.3v 189.495n 3.3v 189.505n 3.3v 199.495n 3.3v 199.505n 3.3v 209.495n 3.3v 209.505n 3.3v 219.495n 3.3v 219.505n 3.3v 229.495n 3.3v 229.505n 3.3v 239.495n 3.3v 239.505n 3.3v 249.495n 3.3v 249.505n 3.3v 259.495n 3.3v 259.505n 3.3v 269.495n 3.3v 269.505n 3.3v 279.495n 3.3v 279.505n 3.3v 289.495n 3.3v 289.505n 3.3v 299.495n 3.3v 299.505n 3.3v 309.495n 3.3v 309.505n 3.3v 319.495n 3.3v 319.505n 3.3v 329.495n 3.3v 329.505n 0.0v 339.495n 0.0v 339.505n 0.0v 349.495n 0.0v 349.505n 0.0v 359.495n 0.0v 359.505n 3.3v 369.495n 3.3v 369.505n 3.3v 379.495n 3.3v 379.505n 3.3v 389.495n 3.3v 389.505n 3.3v 399.495n 3.3v 399.505n 3.3v 409.495n 3.3v 409.505n 3.3v 419.495n 3.3v 419.505n 3.3v 429.495n 3.3v 429.505n 3.3v 439.495n 3.3v 439.505n 0.0v 449.495n 0.0v 449.505n 0.0v 459.495n 0.0v 459.505n 0.0v 469.495n 0.0v 469.505n 0.0v 479.495n 0.0v 479.505n 0.0v 489.495n 0.0v 489.505n 0.0v 499.495n 0.0v 499.505n 0.0v 509.495n 0.0v 509.505n 0.0v 519.495n 0.0v 519.505n 0.0v 529.495n 0.0v 529.505n 0.0v 539.495n 0.0v 539.505n 3.3v 549.495n 3.3v 549.505n 3.3v 559.495n 3.3v 559.505n 3.3v 569.495n 3.3v 569.505n 3.3v 579.495n 3.3v 579.505n 3.3v 589.495n 3.3v 589.505n 3.3v 599.495n 3.3v 599.505n 3.3v 609.495n 3.3v 609.505n 0.0v 619.495n 0.0v 619.505n 0.0v 629.495n 0.0v 629.505n 3.3v 639.495n 3.3v 639.505n 3.3v 649.495n 3.3v 649.505n 3.3v 659.495n 3.3v 659.505n 3.3v 669.495n 3.3v 669.505n 3.3v 679.495n 3.3v 679.505n 3.3v 689.495n 3.3v 689.505n 3.3v 699.495n 3.3v 699.505n 3.3v 709.495n 3.3v 709.505n 3.3v 719.495n 3.3v 719.505n 3.3v 729.495n 3.3v 729.505n 3.3v 739.495n 3.3v 739.505n 0.0v 749.495n 0.0v 749.505n 3.3v 759.495n 3.3v 759.505n 3.3v 769.495n 3.3v 769.505n 3.3v 779.495n 3.3v 779.505n 3.3v 789.495n 3.3v 789.505n 3.3v 799.495n 3.3v 799.505n 0.0v 809.495n 0.0v 809.505n 0.0v 819.495n 0.0v 819.505n 3.3v 829.495n 3.3v 829.505n 3.3v 839.495n 3.3v 839.505n 3.3v 849.495n 3.3v 849.505n 3.3v 859.495n 3.3v 859.505n 3.3v 869.495n 3.3v 869.505n 3.3v 879.495n 3.3v 879.505n 3.3v 889.495n 3.3v 889.505n 3.3v 899.495n 3.3v 899.505n 3.3v 909.495n 3.3v 909.505n 3.3v 919.495n 3.3v 919.505n 3.3v 929.495n 3.3v 929.505n 3.3v 939.495n 3.3v 939.505n 0.0v 949.495n 0.0v 949.505n 0.0v 959.495n 0.0v 959.505n 0.0v 969.495n 0.0v 969.505n 0.0v 979.495n 0.0v 979.505n 0.0v 989.495n 0.0v 989.505n 0.0v 999.495n 0.0v 999.505n 3.3v 1009.495n 3.3v 1009.505n 3.3v 1019.495n 3.3v 1019.505n 3.3v 1029.495n 3.3v 1029.505n 3.3v 1039.495n 3.3v 1039.505n 3.3v 1049.495n 3.3v 1049.505n 3.3v 1059.495n 3.3v 1059.505n 3.3v 1069.495n 3.3v 1069.505n 3.3v 1079.495n 3.3v 1079.505n 0.0v 1089.495n 0.0v 1089.505n 0.0v 1099.495n 0.0v 1099.505n 0.0v 1109.495n 0.0v 1109.505n 0.0v 1119.495n 0.0v 1119.505n 0.0v 1129.495n 0.0v 1129.505n 0.0v 1139.495n 0.0v 1139.505n 0.0v 1149.495n 0.0v 1149.505n 0.0v 1159.495n 0.0v 1159.505n 0.0v 1169.495n 0.0v 1169.505n 0.0v 1179.495n 0.0v 1179.505n 0.0v 1189.495n 0.0v 1189.505n 0.0v 1199.495n 0.0v 1199.505n 0.0v 1209.495n 0.0v 1209.505n 0.0v 1219.495n 0.0v 1219.505n 0.0v 1229.495n 0.0v 1229.505n 0.0v 1239.495n 0.0v 1239.505n 0.0v 1249.495n 0.0v 1249.505n 3.3v 1259.495n 3.3v 1259.505n 3.3v 1269.495n 3.3v 1269.505n 3.3v 1279.495n 3.3v 1279.505n 3.3v 1289.495n 3.3v 1289.505n 3.3v 1299.495n 3.3v 1299.505n 3.3v 1309.495n 3.3v 1309.505n 3.3v 1319.495n 3.3v 1319.505n 3.3v 1329.495n 3.3v 1329.505n 3.3v 1339.495n 3.3v 1339.505n 0.0v 1349.495n 0.0v 1349.505n 0.0v 1359.495n 0.0v 1359.505n 3.3v 1369.495n 3.3v 1369.505n 3.3v 1379.495n 3.3v 1379.505n 3.3v 1389.495n 3.3v 1389.505n 0.0v 1399.495n 0.0v 1399.505n 0.0v 1409.495n 0.0v 1409.505n 0.0v 1419.495n 0.0v 1419.505n 0.0v 1429.495n 0.0v 1429.505n 3.3v 1439.495n 3.3v 1439.505n 0.0v 1449.495n 0.0v 1449.505n 0.0v 1459.495n 0.0v 1459.505n 0.0v 1469.495n 0.0v 1469.505n 3.3v 1479.495n 3.3v 1479.505n 0.0v 1489.495n 0.0v 1489.505n 0.0v 1499.495n 0.0v 1499.505n 0.0v 1509.495n 0.0v 1509.505n 0.0v 1519.495n 0.0v 1519.505n 0.0v 1529.495n 0.0v 1529.505n 0.0v 1539.495n 0.0v 1539.505n 0.0v 1549.495n 0.0v 1549.505n 0.0v 1559.495n 0.0v 1559.505n 0.0v 1569.495n 0.0v 1569.505n 3.3v 1579.495n 3.3v 1579.505n 3.3v 1589.495n 3.3v 1589.505n 3.3v 1599.495n 3.3v 1599.505n 3.3v 1609.495n 3.3v 1609.505n 3.3v 1619.495n 3.3v 1619.505n 3.3v 1629.495n 3.3v 1629.505n 3.3v 1639.495n 3.3v 1639.505n 3.3v 1649.495n 3.3v 1649.505n 3.3v 1659.495n 3.3v 1659.505n 3.3v 1669.495n 3.3v 1669.505n 3.3v 1679.495n 3.3v 1679.505n 3.3v 1689.495n 3.3v 1689.505n 3.3v 1699.495n 3.3v 1699.505n 3.3v 1709.495n 3.3v 1709.505n 3.3v 1719.495n 3.3v 1719.505n 3.3v 1729.495n 3.3v 1729.505n 3.3v 1739.495n 3.3v 1739.505n 3.3v 1749.495n 3.3v 1749.505n 3.3v 1759.495n 3.3v 1759.505n 3.3v 1769.495n 3.3v 1769.505n 3.3v 1779.495n 3.3v 1779.505n 3.3v 1789.495n 3.3v 1789.505n 0.0v 1799.495n 0.0v 1799.505n 0.0v 1809.495n 0.0v 1809.505n 0.0v 1819.495n 0.0v 1819.505n 0.0v 1829.495n 0.0v 1829.505n 0.0v 1839.495n 0.0v 1839.505n 0.0v 1849.495n 0.0v 1849.505n 0.0v 1859.495n 0.0v 1859.505n 0.0v 1869.495n 0.0v 1869.505n 0.0v 1879.495n 0.0v 1879.505n 0.0v 1889.495n 0.0v 1889.505n 0.0v 1899.495n 0.0v 1899.505n 0.0v 1909.495n 0.0v 1909.505n 0.0v 1919.495n 0.0v 1919.505n 0.0v 1929.495n 0.0v 1929.505n 0.0v 1939.495n 0.0v 1939.505n 0.0v 1949.495n 0.0v 1949.505n 0.0v 1959.495n 0.0v 1959.505n 0.0v 1969.495n 0.0v 1969.505n 0.0v 1979.495n 0.0v 1979.505n 3.3v 1989.495n 3.3v 1989.505n 3.3v 1999.495n 3.3v 1999.505n 3.3v 2009.495n 3.3v 2009.505n 3.3v 2019.495n 3.3v 2019.505n 0.0v 2029.495n 0.0v 2029.505n 3.3v 2039.495n 3.3v 2039.505n 3.3v 2049.495n 3.3v 2049.505n 3.3v )
* (time, data): [(0, 0), (10, 0), (20, 0), (30, 0), (40, 0), (50, 1), (60, 1), (70, 1), (80, 1), (90, 1), (100, 0), (110, 0), (120, 0), (130, 0), (140, 0), (150, 1), (160, 1), (170, 1), (180, 1), (190, 1), (200, 1), (210, 1), (220, 1), (230, 0), (240, 0), (250, 0), (260, 0), (270, 0), (280, 0), (290, 0), (300, 0), (310, 0), (320, 0), (330, 0), (340, 0), (350, 0), (360, 1), (370, 1), (380, 1), (390, 1), (400, 1), (410, 1), (420, 1), (430, 1), (440, 1), (450, 1), (460, 1), (470, 1), (480, 1), (490, 1), (500, 1), (510, 1), (520, 1), (530, 1), (540, 1), (550, 1), (560, 1), (570, 1), (580, 1), (590, 1), (600, 1), (610, 1), (620, 1), (630, 1), (640, 1), (650, 1), (660, 1), (670, 1), (680, 1), (690, 0), (700, 0), (710, 0), (720, 0), (730, 0), (740, 1), (750, 0), (760, 0), (770, 0), (780, 0), (790, 0), (800, 0), (810, 0), (820, 0), (830, 0), (840, 0), (850, 0), (860, 0), (870, 0), (880, 0), (890, 0), (900, 0), (910, 0), (920, 0), (930, 0), (940, 0), (950, 0), (960, 0), (970, 0), (980, 0), (990, 0), (1000, 1), (1010, 1), (1020, 1), (1030, 1), (1040, 1), (1050, 1), (1060, 1), (1070, 1), (1080, 1), (1090, 1), (1100, 1), (1110, 1), (1120, 1), (1130, 1), (1140, 1), (1150, 1), (1160, 1), (1170, 1), (1180, 1), (1190, 1), (1200, 1), (1210, 1), (1220, 1), (1230, 1), (1240, 0), (1250, 0), (1260, 0), (1270, 0), (1280, 0), (1290, 0), (1300, 0), (1310, 0), (1320, 1), (1330, 1), (1340, 0), (1350, 0), (1360, 1), (1370, 1), (1380, 1), (1390, 0), (1400, 0), (1410, 0), (1420, 0), (1430, 0), (1440, 1), (1450, 1), (1460, 1), (1470, 0), (1480, 1), (1490, 1), (1500, 1), (1510, 1), (1520, 1), (1530, 1), (1540, 1), (1550, 1), (1560, 1), (1570, 1), (1580, 1), (1590, 1), (1600, 1), (1610, 0), (1620, 0), (1630, 0), (1640, 0), (1650, 0), (1660, 0), (1670, 0), (1680, 1), (1690, 1), (1700, 1), (1710, 1), (1720, 1), (1730, 1), (1740, 1), (1750, 1), (1760, 1), (1770, 1), (1780, 1), (1790, 0), (1800, 0), (1810, 0), (1820, 0), (1830, 0), (1840, 0), (1850, 0), (1860, 0), (1870, 0), (1880, 0), (1890, 0), (1900, 0), (1910, 0), (1920, 0), (1930, 0), (1940, 0), (1950, 0), (1960, 0), (1970, 0), (1980, 0), (1990, 0), (2000, 0), (2010, 0), (2020, 1), (2030, 1), (2040, 1), (2050, 1)]
Vdin1_15  din1_15  0 PWL (0n 0.0v 9.495n 0.0v 9.505n 0.0v 19.495n 0.0v 19.505n 0.0v 29.495n 0.0v 29.505n 0.0v 39.495n 0.0v 39.505n 0.0v 49.495n 0.0v 49.505n 3.3v 59.495n 3.3v 59.505n 3.3v 69.495n 3.3v 69.505n 3.3v 79.495n 3.3v 79.505n 3.3v 89.495n 3.3v 89.505n 3.3v 99.495n 3.3v 99.505n 0.0v 109.495n 0.0v 109.505n 0.0v 119.495n 0.0v 119.505n 0.0v 129.495n 0.0v 129.505n 0.0v 139.495n 0.0v 139.505n 0.0v 149.495n 0.0v 149.505n 3.3v 159.495n 3.3v 159.505n 3.3v 169.495n 3.3v 169.505n 3.3v 179.495n 3.3v 179.505n 3.3v 189.495n 3.3v 189.505n 3.3v 199.495n 3.3v 199.505n 3.3v 209.495n 3.3v 209.505n 3.3v 219.495n 3.3v 219.505n 3.3v 229.495n 3.3v 229.505n 0.0v 239.495n 0.0v 239.505n 0.0v 249.495n 0.0v 249.505n 0.0v 259.495n 0.0v 259.505n 0.0v 269.495n 0.0v 269.505n 0.0v 279.495n 0.0v 279.505n 0.0v 289.495n 0.0v 289.505n 0.0v 299.495n 0.0v 299.505n 0.0v 309.495n 0.0v 309.505n 0.0v 319.495n 0.0v 319.505n 0.0v 329.495n 0.0v 329.505n 0.0v 339.495n 0.0v 339.505n 0.0v 349.495n 0.0v 349.505n 0.0v 359.495n 0.0v 359.505n 3.3v 369.495n 3.3v 369.505n 3.3v 379.495n 3.3v 379.505n 3.3v 389.495n 3.3v 389.505n 3.3v 399.495n 3.3v 399.505n 3.3v 409.495n 3.3v 409.505n 3.3v 419.495n 3.3v 419.505n 3.3v 429.495n 3.3v 429.505n 3.3v 439.495n 3.3v 439.505n 3.3v 449.495n 3.3v 449.505n 3.3v 459.495n 3.3v 459.505n 3.3v 469.495n 3.3v 469.505n 3.3v 479.495n 3.3v 479.505n 3.3v 489.495n 3.3v 489.505n 3.3v 499.495n 3.3v 499.505n 3.3v 509.495n 3.3v 509.505n 3.3v 519.495n 3.3v 519.505n 3.3v 529.495n 3.3v 529.505n 3.3v 539.495n 3.3v 539.505n 3.3v 549.495n 3.3v 549.505n 3.3v 559.495n 3.3v 559.505n 3.3v 569.495n 3.3v 569.505n 3.3v 579.495n 3.3v 579.505n 3.3v 589.495n 3.3v 589.505n 3.3v 599.495n 3.3v 599.505n 3.3v 609.495n 3.3v 609.505n 3.3v 619.495n 3.3v 619.505n 3.3v 629.495n 3.3v 629.505n 3.3v 639.495n 3.3v 639.505n 3.3v 649.495n 3.3v 649.505n 3.3v 659.495n 3.3v 659.505n 3.3v 669.495n 3.3v 669.505n 3.3v 679.495n 3.3v 679.505n 3.3v 689.495n 3.3v 689.505n 0.0v 699.495n 0.0v 699.505n 0.0v 709.495n 0.0v 709.505n 0.0v 719.495n 0.0v 719.505n 0.0v 729.495n 0.0v 729.505n 0.0v 739.495n 0.0v 739.505n 3.3v 749.495n 3.3v 749.505n 0.0v 759.495n 0.0v 759.505n 0.0v 769.495n 0.0v 769.505n 0.0v 779.495n 0.0v 779.505n 0.0v 789.495n 0.0v 789.505n 0.0v 799.495n 0.0v 799.505n 0.0v 809.495n 0.0v 809.505n 0.0v 819.495n 0.0v 819.505n 0.0v 829.495n 0.0v 829.505n 0.0v 839.495n 0.0v 839.505n 0.0v 849.495n 0.0v 849.505n 0.0v 859.495n 0.0v 859.505n 0.0v 869.495n 0.0v 869.505n 0.0v 879.495n 0.0v 879.505n 0.0v 889.495n 0.0v 889.505n 0.0v 899.495n 0.0v 899.505n 0.0v 909.495n 0.0v 909.505n 0.0v 919.495n 0.0v 919.505n 0.0v 929.495n 0.0v 929.505n 0.0v 939.495n 0.0v 939.505n 0.0v 949.495n 0.0v 949.505n 0.0v 959.495n 0.0v 959.505n 0.0v 969.495n 0.0v 969.505n 0.0v 979.495n 0.0v 979.505n 0.0v 989.495n 0.0v 989.505n 0.0v 999.495n 0.0v 999.505n 3.3v 1009.495n 3.3v 1009.505n 3.3v 1019.495n 3.3v 1019.505n 3.3v 1029.495n 3.3v 1029.505n 3.3v 1039.495n 3.3v 1039.505n 3.3v 1049.495n 3.3v 1049.505n 3.3v 1059.495n 3.3v 1059.505n 3.3v 1069.495n 3.3v 1069.505n 3.3v 1079.495n 3.3v 1079.505n 3.3v 1089.495n 3.3v 1089.505n 3.3v 1099.495n 3.3v 1099.505n 3.3v 1109.495n 3.3v 1109.505n 3.3v 1119.495n 3.3v 1119.505n 3.3v 1129.495n 3.3v 1129.505n 3.3v 1139.495n 3.3v 1139.505n 3.3v 1149.495n 3.3v 1149.505n 3.3v 1159.495n 3.3v 1159.505n 3.3v 1169.495n 3.3v 1169.505n 3.3v 1179.495n 3.3v 1179.505n 3.3v 1189.495n 3.3v 1189.505n 3.3v 1199.495n 3.3v 1199.505n 3.3v 1209.495n 3.3v 1209.505n 3.3v 1219.495n 3.3v 1219.505n 3.3v 1229.495n 3.3v 1229.505n 3.3v 1239.495n 3.3v 1239.505n 0.0v 1249.495n 0.0v 1249.505n 0.0v 1259.495n 0.0v 1259.505n 0.0v 1269.495n 0.0v 1269.505n 0.0v 1279.495n 0.0v 1279.505n 0.0v 1289.495n 0.0v 1289.505n 0.0v 1299.495n 0.0v 1299.505n 0.0v 1309.495n 0.0v 1309.505n 0.0v 1319.495n 0.0v 1319.505n 3.3v 1329.495n 3.3v 1329.505n 3.3v 1339.495n 3.3v 1339.505n 0.0v 1349.495n 0.0v 1349.505n 0.0v 1359.495n 0.0v 1359.505n 3.3v 1369.495n 3.3v 1369.505n 3.3v 1379.495n 3.3v 1379.505n 3.3v 1389.495n 3.3v 1389.505n 0.0v 1399.495n 0.0v 1399.505n 0.0v 1409.495n 0.0v 1409.505n 0.0v 1419.495n 0.0v 1419.505n 0.0v 1429.495n 0.0v 1429.505n 0.0v 1439.495n 0.0v 1439.505n 3.3v 1449.495n 3.3v 1449.505n 3.3v 1459.495n 3.3v 1459.505n 3.3v 1469.495n 3.3v 1469.505n 0.0v 1479.495n 0.0v 1479.505n 3.3v 1489.495n 3.3v 1489.505n 3.3v 1499.495n 3.3v 1499.505n 3.3v 1509.495n 3.3v 1509.505n 3.3v 1519.495n 3.3v 1519.505n 3.3v 1529.495n 3.3v 1529.505n 3.3v 1539.495n 3.3v 1539.505n 3.3v 1549.495n 3.3v 1549.505n 3.3v 1559.495n 3.3v 1559.505n 3.3v 1569.495n 3.3v 1569.505n 3.3v 1579.495n 3.3v 1579.505n 3.3v 1589.495n 3.3v 1589.505n 3.3v 1599.495n 3.3v 1599.505n 3.3v 1609.495n 3.3v 1609.505n 0.0v 1619.495n 0.0v 1619.505n 0.0v 1629.495n 0.0v 1629.505n 0.0v 1639.495n 0.0v 1639.505n 0.0v 1649.495n 0.0v 1649.505n 0.0v 1659.495n 0.0v 1659.505n 0.0v 1669.495n 0.0v 1669.505n 0.0v 1679.495n 0.0v 1679.505n 3.3v 1689.495n 3.3v 1689.505n 3.3v 1699.495n 3.3v 1699.505n 3.3v 1709.495n 3.3v 1709.505n 3.3v 1719.495n 3.3v 1719.505n 3.3v 1729.495n 3.3v 1729.505n 3.3v 1739.495n 3.3v 1739.505n 3.3v 1749.495n 3.3v 1749.505n 3.3v 1759.495n 3.3v 1759.505n 3.3v 1769.495n 3.3v 1769.505n 3.3v 1779.495n 3.3v 1779.505n 3.3v 1789.495n 3.3v 1789.505n 0.0v 1799.495n 0.0v 1799.505n 0.0v 1809.495n 0.0v 1809.505n 0.0v 1819.495n 0.0v 1819.505n 0.0v 1829.495n 0.0v 1829.505n 0.0v 1839.495n 0.0v 1839.505n 0.0v 1849.495n 0.0v 1849.505n 0.0v 1859.495n 0.0v 1859.505n 0.0v 1869.495n 0.0v 1869.505n 0.0v 1879.495n 0.0v 1879.505n 0.0v 1889.495n 0.0v 1889.505n 0.0v 1899.495n 0.0v 1899.505n 0.0v 1909.495n 0.0v 1909.505n 0.0v 1919.495n 0.0v 1919.505n 0.0v 1929.495n 0.0v 1929.505n 0.0v 1939.495n 0.0v 1939.505n 0.0v 1949.495n 0.0v 1949.505n 0.0v 1959.495n 0.0v 1959.505n 0.0v 1969.495n 0.0v 1969.505n 0.0v 1979.495n 0.0v 1979.505n 0.0v 1989.495n 0.0v 1989.505n 0.0v 1999.495n 0.0v 1999.505n 0.0v 2009.495n 0.0v 2009.505n 0.0v 2019.495n 0.0v 2019.505n 3.3v 2029.495n 3.3v 2029.505n 3.3v 2039.495n 3.3v 2039.505n 3.3v 2049.495n 3.3v 2049.505n 3.3v )
* (time, data): [(0, 0), (10, 1), (20, 0), (30, 0), (40, 0), (50, 0), (60, 0), (70, 1), (80, 1), (90, 1), (100, 1), (110, 1), (120, 1), (130, 1), (140, 1), (150, 0), (160, 0), (170, 0), (180, 1), (190, 1), (200, 1), (210, 1), (220, 1), (230, 0), (240, 0), (250, 0), (260, 0), (270, 0), (280, 0), (290, 0), (300, 0), (310, 0), (320, 0), (330, 0), (340, 0), (350, 0), (360, 0), (370, 0), (380, 0), (390, 0), (400, 0), (410, 0), (420, 0), (430, 0), (440, 1), (450, 1), (460, 1), (470, 1), (480, 1), (490, 1), (500, 1), (510, 1), (520, 1), (530, 1), (540, 1), (550, 1), (560, 1), (570, 1), (580, 1), (590, 1), (600, 1), (610, 0), (620, 0), (630, 0), (640, 0), (650, 0), (660, 0), (670, 0), (680, 0), (690, 0), (700, 0), (710, 0), (720, 0), (730, 0), (740, 0), (750, 1), (760, 1), (770, 1), (780, 1), (790, 1), (800, 1), (810, 1), (820, 0), (830, 0), (840, 0), (850, 0), (860, 0), (870, 0), (880, 0), (890, 0), (900, 0), (910, 0), (920, 0), (930, 0), (940, 1), (950, 1), (960, 1), (970, 1), (980, 1), (990, 1), (1000, 1), (1010, 1), (1020, 1), (1030, 1), (1040, 1), (1050, 1), (1060, 1), (1070, 1), (1080, 1), (1090, 0), (1100, 0), (1110, 0), (1120, 0), (1130, 0), (1140, 0), (1150, 0), (1160, 0), (1170, 0), (1180, 0), (1190, 0), (1200, 0), (1210, 0), (1220, 0), (1230, 0), (1240, 1), (1250, 0), (1260, 0), (1270, 0), (1280, 1), (1290, 1), (1300, 1), (1310, 1), (1320, 1), (1330, 1), (1340, 1), (1350, 1), (1360, 0), (1370, 0), (1380, 0), (1390, 0), (1400, 0), (1410, 0), (1420, 0), (1430, 0), (1440, 0), (1450, 0), (1460, 0), (1470, 1), (1480, 0), (1490, 0), (1500, 0), (1510, 0), (1520, 0), (1530, 0), (1540, 0), (1550, 0), (1560, 0), (1570, 0), (1580, 0), (1590, 0), (1600, 0), (1610, 0), (1620, 0), (1630, 1), (1640, 1), (1650, 1), (1660, 1), (1670, 1), (1680, 1), (1690, 1), (1700, 1), (1710, 1), (1720, 1), (1730, 1), (1740, 1), (1750, 1), (1760, 1), (1770, 1), (1780, 1), (1790, 1), (1800, 1), (1810, 1), (1820, 1), (1830, 1), (1840, 1), (1850, 1), (1860, 1), (1870, 1), (1880, 1), (1890, 1), (1900, 1), (1910, 1), (1920, 1), (1930, 1), (1940, 1), (1950, 1), (1960, 1), (1970, 1), (1980, 1), (1990, 1), (2000, 1), (2010, 1), (2020, 0), (2030, 0), (2040, 0), (2050, 0)]
Vdin1_16  din1_16  0 PWL (0n 0.0v 9.495n 0.0v 9.505n 3.3v 19.495n 3.3v 19.505n 0.0v 29.495n 0.0v 29.505n 0.0v 39.495n 0.0v 39.505n 0.0v 49.495n 0.0v 49.505n 0.0v 59.495n 0.0v 59.505n 0.0v 69.495n 0.0v 69.505n 3.3v 79.495n 3.3v 79.505n 3.3v 89.495n 3.3v 89.505n 3.3v 99.495n 3.3v 99.505n 3.3v 109.495n 3.3v 109.505n 3.3v 119.495n 3.3v 119.505n 3.3v 129.495n 3.3v 129.505n 3.3v 139.495n 3.3v 139.505n 3.3v 149.495n 3.3v 149.505n 0.0v 159.495n 0.0v 159.505n 0.0v 169.495n 0.0v 169.505n 0.0v 179.495n 0.0v 179.505n 3.3v 189.495n 3.3v 189.505n 3.3v 199.495n 3.3v 199.505n 3.3v 209.495n 3.3v 209.505n 3.3v 219.495n 3.3v 219.505n 3.3v 229.495n 3.3v 229.505n 0.0v 239.495n 0.0v 239.505n 0.0v 249.495n 0.0v 249.505n 0.0v 259.495n 0.0v 259.505n 0.0v 269.495n 0.0v 269.505n 0.0v 279.495n 0.0v 279.505n 0.0v 289.495n 0.0v 289.505n 0.0v 299.495n 0.0v 299.505n 0.0v 309.495n 0.0v 309.505n 0.0v 319.495n 0.0v 319.505n 0.0v 329.495n 0.0v 329.505n 0.0v 339.495n 0.0v 339.505n 0.0v 349.495n 0.0v 349.505n 0.0v 359.495n 0.0v 359.505n 0.0v 369.495n 0.0v 369.505n 0.0v 379.495n 0.0v 379.505n 0.0v 389.495n 0.0v 389.505n 0.0v 399.495n 0.0v 399.505n 0.0v 409.495n 0.0v 409.505n 0.0v 419.495n 0.0v 419.505n 0.0v 429.495n 0.0v 429.505n 0.0v 439.495n 0.0v 439.505n 3.3v 449.495n 3.3v 449.505n 3.3v 459.495n 3.3v 459.505n 3.3v 469.495n 3.3v 469.505n 3.3v 479.495n 3.3v 479.505n 3.3v 489.495n 3.3v 489.505n 3.3v 499.495n 3.3v 499.505n 3.3v 509.495n 3.3v 509.505n 3.3v 519.495n 3.3v 519.505n 3.3v 529.495n 3.3v 529.505n 3.3v 539.495n 3.3v 539.505n 3.3v 549.495n 3.3v 549.505n 3.3v 559.495n 3.3v 559.505n 3.3v 569.495n 3.3v 569.505n 3.3v 579.495n 3.3v 579.505n 3.3v 589.495n 3.3v 589.505n 3.3v 599.495n 3.3v 599.505n 3.3v 609.495n 3.3v 609.505n 0.0v 619.495n 0.0v 619.505n 0.0v 629.495n 0.0v 629.505n 0.0v 639.495n 0.0v 639.505n 0.0v 649.495n 0.0v 649.505n 0.0v 659.495n 0.0v 659.505n 0.0v 669.495n 0.0v 669.505n 0.0v 679.495n 0.0v 679.505n 0.0v 689.495n 0.0v 689.505n 0.0v 699.495n 0.0v 699.505n 0.0v 709.495n 0.0v 709.505n 0.0v 719.495n 0.0v 719.505n 0.0v 729.495n 0.0v 729.505n 0.0v 739.495n 0.0v 739.505n 0.0v 749.495n 0.0v 749.505n 3.3v 759.495n 3.3v 759.505n 3.3v 769.495n 3.3v 769.505n 3.3v 779.495n 3.3v 779.505n 3.3v 789.495n 3.3v 789.505n 3.3v 799.495n 3.3v 799.505n 3.3v 809.495n 3.3v 809.505n 3.3v 819.495n 3.3v 819.505n 0.0v 829.495n 0.0v 829.505n 0.0v 839.495n 0.0v 839.505n 0.0v 849.495n 0.0v 849.505n 0.0v 859.495n 0.0v 859.505n 0.0v 869.495n 0.0v 869.505n 0.0v 879.495n 0.0v 879.505n 0.0v 889.495n 0.0v 889.505n 0.0v 899.495n 0.0v 899.505n 0.0v 909.495n 0.0v 909.505n 0.0v 919.495n 0.0v 919.505n 0.0v 929.495n 0.0v 929.505n 0.0v 939.495n 0.0v 939.505n 3.3v 949.495n 3.3v 949.505n 3.3v 959.495n 3.3v 959.505n 3.3v 969.495n 3.3v 969.505n 3.3v 979.495n 3.3v 979.505n 3.3v 989.495n 3.3v 989.505n 3.3v 999.495n 3.3v 999.505n 3.3v 1009.495n 3.3v 1009.505n 3.3v 1019.495n 3.3v 1019.505n 3.3v 1029.495n 3.3v 1029.505n 3.3v 1039.495n 3.3v 1039.505n 3.3v 1049.495n 3.3v 1049.505n 3.3v 1059.495n 3.3v 1059.505n 3.3v 1069.495n 3.3v 1069.505n 3.3v 1079.495n 3.3v 1079.505n 3.3v 1089.495n 3.3v 1089.505n 0.0v 1099.495n 0.0v 1099.505n 0.0v 1109.495n 0.0v 1109.505n 0.0v 1119.495n 0.0v 1119.505n 0.0v 1129.495n 0.0v 1129.505n 0.0v 1139.495n 0.0v 1139.505n 0.0v 1149.495n 0.0v 1149.505n 0.0v 1159.495n 0.0v 1159.505n 0.0v 1169.495n 0.0v 1169.505n 0.0v 1179.495n 0.0v 1179.505n 0.0v 1189.495n 0.0v 1189.505n 0.0v 1199.495n 0.0v 1199.505n 0.0v 1209.495n 0.0v 1209.505n 0.0v 1219.495n 0.0v 1219.505n 0.0v 1229.495n 0.0v 1229.505n 0.0v 1239.495n 0.0v 1239.505n 3.3v 1249.495n 3.3v 1249.505n 0.0v 1259.495n 0.0v 1259.505n 0.0v 1269.495n 0.0v 1269.505n 0.0v 1279.495n 0.0v 1279.505n 3.3v 1289.495n 3.3v 1289.505n 3.3v 1299.495n 3.3v 1299.505n 3.3v 1309.495n 3.3v 1309.505n 3.3v 1319.495n 3.3v 1319.505n 3.3v 1329.495n 3.3v 1329.505n 3.3v 1339.495n 3.3v 1339.505n 3.3v 1349.495n 3.3v 1349.505n 3.3v 1359.495n 3.3v 1359.505n 0.0v 1369.495n 0.0v 1369.505n 0.0v 1379.495n 0.0v 1379.505n 0.0v 1389.495n 0.0v 1389.505n 0.0v 1399.495n 0.0v 1399.505n 0.0v 1409.495n 0.0v 1409.505n 0.0v 1419.495n 0.0v 1419.505n 0.0v 1429.495n 0.0v 1429.505n 0.0v 1439.495n 0.0v 1439.505n 0.0v 1449.495n 0.0v 1449.505n 0.0v 1459.495n 0.0v 1459.505n 0.0v 1469.495n 0.0v 1469.505n 3.3v 1479.495n 3.3v 1479.505n 0.0v 1489.495n 0.0v 1489.505n 0.0v 1499.495n 0.0v 1499.505n 0.0v 1509.495n 0.0v 1509.505n 0.0v 1519.495n 0.0v 1519.505n 0.0v 1529.495n 0.0v 1529.505n 0.0v 1539.495n 0.0v 1539.505n 0.0v 1549.495n 0.0v 1549.505n 0.0v 1559.495n 0.0v 1559.505n 0.0v 1569.495n 0.0v 1569.505n 0.0v 1579.495n 0.0v 1579.505n 0.0v 1589.495n 0.0v 1589.505n 0.0v 1599.495n 0.0v 1599.505n 0.0v 1609.495n 0.0v 1609.505n 0.0v 1619.495n 0.0v 1619.505n 0.0v 1629.495n 0.0v 1629.505n 3.3v 1639.495n 3.3v 1639.505n 3.3v 1649.495n 3.3v 1649.505n 3.3v 1659.495n 3.3v 1659.505n 3.3v 1669.495n 3.3v 1669.505n 3.3v 1679.495n 3.3v 1679.505n 3.3v 1689.495n 3.3v 1689.505n 3.3v 1699.495n 3.3v 1699.505n 3.3v 1709.495n 3.3v 1709.505n 3.3v 1719.495n 3.3v 1719.505n 3.3v 1729.495n 3.3v 1729.505n 3.3v 1739.495n 3.3v 1739.505n 3.3v 1749.495n 3.3v 1749.505n 3.3v 1759.495n 3.3v 1759.505n 3.3v 1769.495n 3.3v 1769.505n 3.3v 1779.495n 3.3v 1779.505n 3.3v 1789.495n 3.3v 1789.505n 3.3v 1799.495n 3.3v 1799.505n 3.3v 1809.495n 3.3v 1809.505n 3.3v 1819.495n 3.3v 1819.505n 3.3v 1829.495n 3.3v 1829.505n 3.3v 1839.495n 3.3v 1839.505n 3.3v 1849.495n 3.3v 1849.505n 3.3v 1859.495n 3.3v 1859.505n 3.3v 1869.495n 3.3v 1869.505n 3.3v 1879.495n 3.3v 1879.505n 3.3v 1889.495n 3.3v 1889.505n 3.3v 1899.495n 3.3v 1899.505n 3.3v 1909.495n 3.3v 1909.505n 3.3v 1919.495n 3.3v 1919.505n 3.3v 1929.495n 3.3v 1929.505n 3.3v 1939.495n 3.3v 1939.505n 3.3v 1949.495n 3.3v 1949.505n 3.3v 1959.495n 3.3v 1959.505n 3.3v 1969.495n 3.3v 1969.505n 3.3v 1979.495n 3.3v 1979.505n 3.3v 1989.495n 3.3v 1989.505n 3.3v 1999.495n 3.3v 1999.505n 3.3v 2009.495n 3.3v 2009.505n 3.3v 2019.495n 3.3v 2019.505n 0.0v 2029.495n 0.0v 2029.505n 0.0v 2039.495n 0.0v 2039.505n 0.0v 2049.495n 0.0v 2049.505n 0.0v )
* (time, data): [(0, 0), (10, 0), (20, 0), (30, 1), (40, 1), (50, 1), (60, 1), (70, 0), (80, 0), (90, 0), (100, 1), (110, 1), (120, 1), (130, 1), (140, 1), (150, 0), (160, 1), (170, 1), (180, 1), (190, 1), (200, 1), (210, 1), (220, 1), (230, 0), (240, 0), (250, 0), (260, 0), (270, 0), (280, 0), (290, 0), (300, 0), (310, 0), (320, 0), (330, 1), (340, 1), (350, 1), (360, 1), (370, 1), (380, 1), (390, 1), (400, 1), (410, 1), (420, 1), (430, 1), (440, 1), (450, 1), (460, 1), (470, 1), (480, 1), (490, 1), (500, 1), (510, 1), (520, 1), (530, 1), (540, 0), (550, 0), (560, 0), (570, 0), (580, 0), (590, 0), (600, 0), (610, 1), (620, 1), (630, 0), (640, 0), (650, 0), (660, 0), (670, 0), (680, 0), (690, 0), (700, 0), (710, 0), (720, 0), (730, 0), (740, 1), (750, 1), (760, 1), (770, 0), (780, 0), (790, 0), (800, 1), (810, 1), (820, 1), (830, 1), (840, 1), (850, 1), (860, 1), (870, 1), (880, 1), (890, 1), (900, 1), (910, 0), (920, 0), (930, 0), (940, 1), (950, 1), (960, 1), (970, 1), (980, 1), (990, 1), (1000, 1), (1010, 1), (1020, 1), (1030, 1), (1040, 1), (1050, 1), (1060, 1), (1070, 1), (1080, 1), (1090, 0), (1100, 0), (1110, 0), (1120, 0), (1130, 0), (1140, 0), (1150, 0), (1160, 0), (1170, 0), (1180, 0), (1190, 0), (1200, 0), (1210, 0), (1220, 0), (1230, 0), (1240, 0), (1250, 0), (1260, 0), (1270, 0), (1280, 0), (1290, 0), (1300, 0), (1310, 0), (1320, 0), (1330, 0), (1340, 1), (1350, 1), (1360, 0), (1370, 0), (1380, 0), (1390, 0), (1400, 0), (1410, 0), (1420, 0), (1430, 0), (1440, 1), (1450, 1), (1460, 1), (1470, 1), (1480, 0), (1490, 0), (1500, 0), (1510, 0), (1520, 0), (1530, 0), (1540, 0), (1550, 1), (1560, 1), (1570, 0), (1580, 0), (1590, 0), (1600, 0), (1610, 1), (1620, 1), (1630, 0), (1640, 0), (1650, 0), (1660, 0), (1670, 0), (1680, 1), (1690, 1), (1700, 1), (1710, 1), (1720, 1), (1730, 1), (1740, 1), (1750, 1), (1760, 1), (1770, 1), (1780, 1), (1790, 1), (1800, 1), (1810, 1), (1820, 1), (1830, 1), (1840, 1), (1850, 1), (1860, 1), (1870, 1), (1880, 1), (1890, 1), (1900, 1), (1910, 1), (1920, 1), (1930, 1), (1940, 1), (1950, 0), (1960, 0), (1970, 0), (1980, 0), (1990, 0), (2000, 0), (2010, 0), (2020, 1), (2030, 0), (2040, 0), (2050, 0)]
Vdin1_17  din1_17  0 PWL (0n 0.0v 9.495n 0.0v 9.505n 0.0v 19.495n 0.0v 19.505n 0.0v 29.495n 0.0v 29.505n 3.3v 39.495n 3.3v 39.505n 3.3v 49.495n 3.3v 49.505n 3.3v 59.495n 3.3v 59.505n 3.3v 69.495n 3.3v 69.505n 0.0v 79.495n 0.0v 79.505n 0.0v 89.495n 0.0v 89.505n 0.0v 99.495n 0.0v 99.505n 3.3v 109.495n 3.3v 109.505n 3.3v 119.495n 3.3v 119.505n 3.3v 129.495n 3.3v 129.505n 3.3v 139.495n 3.3v 139.505n 3.3v 149.495n 3.3v 149.505n 0.0v 159.495n 0.0v 159.505n 3.3v 169.495n 3.3v 169.505n 3.3v 179.495n 3.3v 179.505n 3.3v 189.495n 3.3v 189.505n 3.3v 199.495n 3.3v 199.505n 3.3v 209.495n 3.3v 209.505n 3.3v 219.495n 3.3v 219.505n 3.3v 229.495n 3.3v 229.505n 0.0v 239.495n 0.0v 239.505n 0.0v 249.495n 0.0v 249.505n 0.0v 259.495n 0.0v 259.505n 0.0v 269.495n 0.0v 269.505n 0.0v 279.495n 0.0v 279.505n 0.0v 289.495n 0.0v 289.505n 0.0v 299.495n 0.0v 299.505n 0.0v 309.495n 0.0v 309.505n 0.0v 319.495n 0.0v 319.505n 0.0v 329.495n 0.0v 329.505n 3.3v 339.495n 3.3v 339.505n 3.3v 349.495n 3.3v 349.505n 3.3v 359.495n 3.3v 359.505n 3.3v 369.495n 3.3v 369.505n 3.3v 379.495n 3.3v 379.505n 3.3v 389.495n 3.3v 389.505n 3.3v 399.495n 3.3v 399.505n 3.3v 409.495n 3.3v 409.505n 3.3v 419.495n 3.3v 419.505n 3.3v 429.495n 3.3v 429.505n 3.3v 439.495n 3.3v 439.505n 3.3v 449.495n 3.3v 449.505n 3.3v 459.495n 3.3v 459.505n 3.3v 469.495n 3.3v 469.505n 3.3v 479.495n 3.3v 479.505n 3.3v 489.495n 3.3v 489.505n 3.3v 499.495n 3.3v 499.505n 3.3v 509.495n 3.3v 509.505n 3.3v 519.495n 3.3v 519.505n 3.3v 529.495n 3.3v 529.505n 3.3v 539.495n 3.3v 539.505n 0.0v 549.495n 0.0v 549.505n 0.0v 559.495n 0.0v 559.505n 0.0v 569.495n 0.0v 569.505n 0.0v 579.495n 0.0v 579.505n 0.0v 589.495n 0.0v 589.505n 0.0v 599.495n 0.0v 599.505n 0.0v 609.495n 0.0v 609.505n 3.3v 619.495n 3.3v 619.505n 3.3v 629.495n 3.3v 629.505n 0.0v 639.495n 0.0v 639.505n 0.0v 649.495n 0.0v 649.505n 0.0v 659.495n 0.0v 659.505n 0.0v 669.495n 0.0v 669.505n 0.0v 679.495n 0.0v 679.505n 0.0v 689.495n 0.0v 689.505n 0.0v 699.495n 0.0v 699.505n 0.0v 709.495n 0.0v 709.505n 0.0v 719.495n 0.0v 719.505n 0.0v 729.495n 0.0v 729.505n 0.0v 739.495n 0.0v 739.505n 3.3v 749.495n 3.3v 749.505n 3.3v 759.495n 3.3v 759.505n 3.3v 769.495n 3.3v 769.505n 0.0v 779.495n 0.0v 779.505n 0.0v 789.495n 0.0v 789.505n 0.0v 799.495n 0.0v 799.505n 3.3v 809.495n 3.3v 809.505n 3.3v 819.495n 3.3v 819.505n 3.3v 829.495n 3.3v 829.505n 3.3v 839.495n 3.3v 839.505n 3.3v 849.495n 3.3v 849.505n 3.3v 859.495n 3.3v 859.505n 3.3v 869.495n 3.3v 869.505n 3.3v 879.495n 3.3v 879.505n 3.3v 889.495n 3.3v 889.505n 3.3v 899.495n 3.3v 899.505n 3.3v 909.495n 3.3v 909.505n 0.0v 919.495n 0.0v 919.505n 0.0v 929.495n 0.0v 929.505n 0.0v 939.495n 0.0v 939.505n 3.3v 949.495n 3.3v 949.505n 3.3v 959.495n 3.3v 959.505n 3.3v 969.495n 3.3v 969.505n 3.3v 979.495n 3.3v 979.505n 3.3v 989.495n 3.3v 989.505n 3.3v 999.495n 3.3v 999.505n 3.3v 1009.495n 3.3v 1009.505n 3.3v 1019.495n 3.3v 1019.505n 3.3v 1029.495n 3.3v 1029.505n 3.3v 1039.495n 3.3v 1039.505n 3.3v 1049.495n 3.3v 1049.505n 3.3v 1059.495n 3.3v 1059.505n 3.3v 1069.495n 3.3v 1069.505n 3.3v 1079.495n 3.3v 1079.505n 3.3v 1089.495n 3.3v 1089.505n 0.0v 1099.495n 0.0v 1099.505n 0.0v 1109.495n 0.0v 1109.505n 0.0v 1119.495n 0.0v 1119.505n 0.0v 1129.495n 0.0v 1129.505n 0.0v 1139.495n 0.0v 1139.505n 0.0v 1149.495n 0.0v 1149.505n 0.0v 1159.495n 0.0v 1159.505n 0.0v 1169.495n 0.0v 1169.505n 0.0v 1179.495n 0.0v 1179.505n 0.0v 1189.495n 0.0v 1189.505n 0.0v 1199.495n 0.0v 1199.505n 0.0v 1209.495n 0.0v 1209.505n 0.0v 1219.495n 0.0v 1219.505n 0.0v 1229.495n 0.0v 1229.505n 0.0v 1239.495n 0.0v 1239.505n 0.0v 1249.495n 0.0v 1249.505n 0.0v 1259.495n 0.0v 1259.505n 0.0v 1269.495n 0.0v 1269.505n 0.0v 1279.495n 0.0v 1279.505n 0.0v 1289.495n 0.0v 1289.505n 0.0v 1299.495n 0.0v 1299.505n 0.0v 1309.495n 0.0v 1309.505n 0.0v 1319.495n 0.0v 1319.505n 0.0v 1329.495n 0.0v 1329.505n 0.0v 1339.495n 0.0v 1339.505n 3.3v 1349.495n 3.3v 1349.505n 3.3v 1359.495n 3.3v 1359.505n 0.0v 1369.495n 0.0v 1369.505n 0.0v 1379.495n 0.0v 1379.505n 0.0v 1389.495n 0.0v 1389.505n 0.0v 1399.495n 0.0v 1399.505n 0.0v 1409.495n 0.0v 1409.505n 0.0v 1419.495n 0.0v 1419.505n 0.0v 1429.495n 0.0v 1429.505n 0.0v 1439.495n 0.0v 1439.505n 3.3v 1449.495n 3.3v 1449.505n 3.3v 1459.495n 3.3v 1459.505n 3.3v 1469.495n 3.3v 1469.505n 3.3v 1479.495n 3.3v 1479.505n 0.0v 1489.495n 0.0v 1489.505n 0.0v 1499.495n 0.0v 1499.505n 0.0v 1509.495n 0.0v 1509.505n 0.0v 1519.495n 0.0v 1519.505n 0.0v 1529.495n 0.0v 1529.505n 0.0v 1539.495n 0.0v 1539.505n 0.0v 1549.495n 0.0v 1549.505n 3.3v 1559.495n 3.3v 1559.505n 3.3v 1569.495n 3.3v 1569.505n 0.0v 1579.495n 0.0v 1579.505n 0.0v 1589.495n 0.0v 1589.505n 0.0v 1599.495n 0.0v 1599.505n 0.0v 1609.495n 0.0v 1609.505n 3.3v 1619.495n 3.3v 1619.505n 3.3v 1629.495n 3.3v 1629.505n 0.0v 1639.495n 0.0v 1639.505n 0.0v 1649.495n 0.0v 1649.505n 0.0v 1659.495n 0.0v 1659.505n 0.0v 1669.495n 0.0v 1669.505n 0.0v 1679.495n 0.0v 1679.505n 3.3v 1689.495n 3.3v 1689.505n 3.3v 1699.495n 3.3v 1699.505n 3.3v 1709.495n 3.3v 1709.505n 3.3v 1719.495n 3.3v 1719.505n 3.3v 1729.495n 3.3v 1729.505n 3.3v 1739.495n 3.3v 1739.505n 3.3v 1749.495n 3.3v 1749.505n 3.3v 1759.495n 3.3v 1759.505n 3.3v 1769.495n 3.3v 1769.505n 3.3v 1779.495n 3.3v 1779.505n 3.3v 1789.495n 3.3v 1789.505n 3.3v 1799.495n 3.3v 1799.505n 3.3v 1809.495n 3.3v 1809.505n 3.3v 1819.495n 3.3v 1819.505n 3.3v 1829.495n 3.3v 1829.505n 3.3v 1839.495n 3.3v 1839.505n 3.3v 1849.495n 3.3v 1849.505n 3.3v 1859.495n 3.3v 1859.505n 3.3v 1869.495n 3.3v 1869.505n 3.3v 1879.495n 3.3v 1879.505n 3.3v 1889.495n 3.3v 1889.505n 3.3v 1899.495n 3.3v 1899.505n 3.3v 1909.495n 3.3v 1909.505n 3.3v 1919.495n 3.3v 1919.505n 3.3v 1929.495n 3.3v 1929.505n 3.3v 1939.495n 3.3v 1939.505n 3.3v 1949.495n 3.3v 1949.505n 0.0v 1959.495n 0.0v 1959.505n 0.0v 1969.495n 0.0v 1969.505n 0.0v 1979.495n 0.0v 1979.505n 0.0v 1989.495n 0.0v 1989.505n 0.0v 1999.495n 0.0v 1999.505n 0.0v 2009.495n 0.0v 2009.505n 0.0v 2019.495n 0.0v 2019.505n 3.3v 2029.495n 3.3v 2029.505n 0.0v 2039.495n 0.0v 2039.505n 0.0v 2049.495n 0.0v 2049.505n 0.0v )
* (time, data): [(0, 0), (10, 0), (20, 0), (30, 1), (40, 1), (50, 0), (60, 0), (70, 0), (80, 0), (90, 0), (100, 1), (110, 1), (120, 1), (130, 1), (140, 1), (150, 1), (160, 0), (170, 0), (180, 0), (190, 0), (200, 0), (210, 0), (220, 0), (230, 1), (240, 1), (250, 1), (260, 1), (270, 1), (280, 1), (290, 1), (300, 1), (310, 1), (320, 1), (330, 0), (340, 0), (350, 0), (360, 0), (370, 0), (380, 0), (390, 0), (400, 0), (410, 0), (420, 0), (430, 0), (440, 1), (450, 1), (460, 1), (470, 1), (480, 1), (490, 1), (500, 1), (510, 1), (520, 1), (530, 1), (540, 0), (550, 0), (560, 0), (570, 0), (580, 0), (590, 0), (600, 0), (610, 0), (620, 0), (630, 0), (640, 0), (650, 0), (660, 0), (670, 0), (680, 0), (690, 1), (700, 1), (710, 1), (720, 1), (730, 1), (740, 1), (750, 0), (760, 0), (770, 1), (780, 1), (790, 1), (800, 1), (810, 1), (820, 1), (830, 1), (840, 0), (850, 0), (860, 0), (870, 0), (880, 0), (890, 0), (900, 0), (910, 1), (920, 1), (930, 1), (940, 0), (950, 0), (960, 1), (970, 1), (980, 1), (990, 1), (1000, 1), (1010, 1), (1020, 1), (1030, 1), (1040, 1), (1050, 1), (1060, 1), (1070, 1), (1080, 1), (1090, 0), (1100, 0), (1110, 0), (1120, 0), (1130, 0), (1140, 0), (1150, 0), (1160, 0), (1170, 0), (1180, 0), (1190, 0), (1200, 0), (1210, 0), (1220, 0), (1230, 0), (1240, 1), (1250, 1), (1260, 1), (1270, 1), (1280, 1), (1290, 1), (1300, 1), (1310, 1), (1320, 1), (1330, 1), (1340, 0), (1350, 0), (1360, 1), (1370, 1), (1380, 1), (1390, 0), (1400, 0), (1410, 0), (1420, 0), (1430, 0), (1440, 0), (1450, 0), (1460, 0), (1470, 1), (1480, 0), (1490, 0), (1500, 0), (1510, 0), (1520, 0), (1530, 0), (1540, 0), (1550, 1), (1560, 1), (1570, 0), (1580, 0), (1590, 0), (1600, 0), (1610, 1), (1620, 1), (1630, 0), (1640, 0), (1650, 0), (1660, 1), (1670, 1), (1680, 0), (1690, 0), (1700, 0), (1710, 0), (1720, 0), (1730, 0), (1740, 0), (1750, 0), (1760, 0), (1770, 1), (1780, 1), (1790, 1), (1800, 1), (1810, 1), (1820, 1), (1830, 1), (1840, 1), (1850, 1), (1860, 1), (1870, 1), (1880, 1), (1890, 1), (1900, 1), (1910, 1), (1920, 1), (1930, 1), (1940, 1), (1950, 0), (1960, 0), (1970, 0), (1980, 1), (1990, 1), (2000, 1), (2010, 1), (2020, 1), (2030, 1), (2040, 1), (2050, 1)]
Vdin1_18  din1_18  0 PWL (0n 0.0v 9.495n 0.0v 9.505n 0.0v 19.495n 0.0v 19.505n 0.0v 29.495n 0.0v 29.505n 3.3v 39.495n 3.3v 39.505n 3.3v 49.495n 3.3v 49.505n 0.0v 59.495n 0.0v 59.505n 0.0v 69.495n 0.0v 69.505n 0.0v 79.495n 0.0v 79.505n 0.0v 89.495n 0.0v 89.505n 0.0v 99.495n 0.0v 99.505n 3.3v 109.495n 3.3v 109.505n 3.3v 119.495n 3.3v 119.505n 3.3v 129.495n 3.3v 129.505n 3.3v 139.495n 3.3v 139.505n 3.3v 149.495n 3.3v 149.505n 3.3v 159.495n 3.3v 159.505n 0.0v 169.495n 0.0v 169.505n 0.0v 179.495n 0.0v 179.505n 0.0v 189.495n 0.0v 189.505n 0.0v 199.495n 0.0v 199.505n 0.0v 209.495n 0.0v 209.505n 0.0v 219.495n 0.0v 219.505n 0.0v 229.495n 0.0v 229.505n 3.3v 239.495n 3.3v 239.505n 3.3v 249.495n 3.3v 249.505n 3.3v 259.495n 3.3v 259.505n 3.3v 269.495n 3.3v 269.505n 3.3v 279.495n 3.3v 279.505n 3.3v 289.495n 3.3v 289.505n 3.3v 299.495n 3.3v 299.505n 3.3v 309.495n 3.3v 309.505n 3.3v 319.495n 3.3v 319.505n 3.3v 329.495n 3.3v 329.505n 0.0v 339.495n 0.0v 339.505n 0.0v 349.495n 0.0v 349.505n 0.0v 359.495n 0.0v 359.505n 0.0v 369.495n 0.0v 369.505n 0.0v 379.495n 0.0v 379.505n 0.0v 389.495n 0.0v 389.505n 0.0v 399.495n 0.0v 399.505n 0.0v 409.495n 0.0v 409.505n 0.0v 419.495n 0.0v 419.505n 0.0v 429.495n 0.0v 429.505n 0.0v 439.495n 0.0v 439.505n 3.3v 449.495n 3.3v 449.505n 3.3v 459.495n 3.3v 459.505n 3.3v 469.495n 3.3v 469.505n 3.3v 479.495n 3.3v 479.505n 3.3v 489.495n 3.3v 489.505n 3.3v 499.495n 3.3v 499.505n 3.3v 509.495n 3.3v 509.505n 3.3v 519.495n 3.3v 519.505n 3.3v 529.495n 3.3v 529.505n 3.3v 539.495n 3.3v 539.505n 0.0v 549.495n 0.0v 549.505n 0.0v 559.495n 0.0v 559.505n 0.0v 569.495n 0.0v 569.505n 0.0v 579.495n 0.0v 579.505n 0.0v 589.495n 0.0v 589.505n 0.0v 599.495n 0.0v 599.505n 0.0v 609.495n 0.0v 609.505n 0.0v 619.495n 0.0v 619.505n 0.0v 629.495n 0.0v 629.505n 0.0v 639.495n 0.0v 639.505n 0.0v 649.495n 0.0v 649.505n 0.0v 659.495n 0.0v 659.505n 0.0v 669.495n 0.0v 669.505n 0.0v 679.495n 0.0v 679.505n 0.0v 689.495n 0.0v 689.505n 3.3v 699.495n 3.3v 699.505n 3.3v 709.495n 3.3v 709.505n 3.3v 719.495n 3.3v 719.505n 3.3v 729.495n 3.3v 729.505n 3.3v 739.495n 3.3v 739.505n 3.3v 749.495n 3.3v 749.505n 0.0v 759.495n 0.0v 759.505n 0.0v 769.495n 0.0v 769.505n 3.3v 779.495n 3.3v 779.505n 3.3v 789.495n 3.3v 789.505n 3.3v 799.495n 3.3v 799.505n 3.3v 809.495n 3.3v 809.505n 3.3v 819.495n 3.3v 819.505n 3.3v 829.495n 3.3v 829.505n 3.3v 839.495n 3.3v 839.505n 0.0v 849.495n 0.0v 849.505n 0.0v 859.495n 0.0v 859.505n 0.0v 869.495n 0.0v 869.505n 0.0v 879.495n 0.0v 879.505n 0.0v 889.495n 0.0v 889.505n 0.0v 899.495n 0.0v 899.505n 0.0v 909.495n 0.0v 909.505n 3.3v 919.495n 3.3v 919.505n 3.3v 929.495n 3.3v 929.505n 3.3v 939.495n 3.3v 939.505n 0.0v 949.495n 0.0v 949.505n 0.0v 959.495n 0.0v 959.505n 3.3v 969.495n 3.3v 969.505n 3.3v 979.495n 3.3v 979.505n 3.3v 989.495n 3.3v 989.505n 3.3v 999.495n 3.3v 999.505n 3.3v 1009.495n 3.3v 1009.505n 3.3v 1019.495n 3.3v 1019.505n 3.3v 1029.495n 3.3v 1029.505n 3.3v 1039.495n 3.3v 1039.505n 3.3v 1049.495n 3.3v 1049.505n 3.3v 1059.495n 3.3v 1059.505n 3.3v 1069.495n 3.3v 1069.505n 3.3v 1079.495n 3.3v 1079.505n 3.3v 1089.495n 3.3v 1089.505n 0.0v 1099.495n 0.0v 1099.505n 0.0v 1109.495n 0.0v 1109.505n 0.0v 1119.495n 0.0v 1119.505n 0.0v 1129.495n 0.0v 1129.505n 0.0v 1139.495n 0.0v 1139.505n 0.0v 1149.495n 0.0v 1149.505n 0.0v 1159.495n 0.0v 1159.505n 0.0v 1169.495n 0.0v 1169.505n 0.0v 1179.495n 0.0v 1179.505n 0.0v 1189.495n 0.0v 1189.505n 0.0v 1199.495n 0.0v 1199.505n 0.0v 1209.495n 0.0v 1209.505n 0.0v 1219.495n 0.0v 1219.505n 0.0v 1229.495n 0.0v 1229.505n 0.0v 1239.495n 0.0v 1239.505n 3.3v 1249.495n 3.3v 1249.505n 3.3v 1259.495n 3.3v 1259.505n 3.3v 1269.495n 3.3v 1269.505n 3.3v 1279.495n 3.3v 1279.505n 3.3v 1289.495n 3.3v 1289.505n 3.3v 1299.495n 3.3v 1299.505n 3.3v 1309.495n 3.3v 1309.505n 3.3v 1319.495n 3.3v 1319.505n 3.3v 1329.495n 3.3v 1329.505n 3.3v 1339.495n 3.3v 1339.505n 0.0v 1349.495n 0.0v 1349.505n 0.0v 1359.495n 0.0v 1359.505n 3.3v 1369.495n 3.3v 1369.505n 3.3v 1379.495n 3.3v 1379.505n 3.3v 1389.495n 3.3v 1389.505n 0.0v 1399.495n 0.0v 1399.505n 0.0v 1409.495n 0.0v 1409.505n 0.0v 1419.495n 0.0v 1419.505n 0.0v 1429.495n 0.0v 1429.505n 0.0v 1439.495n 0.0v 1439.505n 0.0v 1449.495n 0.0v 1449.505n 0.0v 1459.495n 0.0v 1459.505n 0.0v 1469.495n 0.0v 1469.505n 3.3v 1479.495n 3.3v 1479.505n 0.0v 1489.495n 0.0v 1489.505n 0.0v 1499.495n 0.0v 1499.505n 0.0v 1509.495n 0.0v 1509.505n 0.0v 1519.495n 0.0v 1519.505n 0.0v 1529.495n 0.0v 1529.505n 0.0v 1539.495n 0.0v 1539.505n 0.0v 1549.495n 0.0v 1549.505n 3.3v 1559.495n 3.3v 1559.505n 3.3v 1569.495n 3.3v 1569.505n 0.0v 1579.495n 0.0v 1579.505n 0.0v 1589.495n 0.0v 1589.505n 0.0v 1599.495n 0.0v 1599.505n 0.0v 1609.495n 0.0v 1609.505n 3.3v 1619.495n 3.3v 1619.505n 3.3v 1629.495n 3.3v 1629.505n 0.0v 1639.495n 0.0v 1639.505n 0.0v 1649.495n 0.0v 1649.505n 0.0v 1659.495n 0.0v 1659.505n 3.3v 1669.495n 3.3v 1669.505n 3.3v 1679.495n 3.3v 1679.505n 0.0v 1689.495n 0.0v 1689.505n 0.0v 1699.495n 0.0v 1699.505n 0.0v 1709.495n 0.0v 1709.505n 0.0v 1719.495n 0.0v 1719.505n 0.0v 1729.495n 0.0v 1729.505n 0.0v 1739.495n 0.0v 1739.505n 0.0v 1749.495n 0.0v 1749.505n 0.0v 1759.495n 0.0v 1759.505n 0.0v 1769.495n 0.0v 1769.505n 3.3v 1779.495n 3.3v 1779.505n 3.3v 1789.495n 3.3v 1789.505n 3.3v 1799.495n 3.3v 1799.505n 3.3v 1809.495n 3.3v 1809.505n 3.3v 1819.495n 3.3v 1819.505n 3.3v 1829.495n 3.3v 1829.505n 3.3v 1839.495n 3.3v 1839.505n 3.3v 1849.495n 3.3v 1849.505n 3.3v 1859.495n 3.3v 1859.505n 3.3v 1869.495n 3.3v 1869.505n 3.3v 1879.495n 3.3v 1879.505n 3.3v 1889.495n 3.3v 1889.505n 3.3v 1899.495n 3.3v 1899.505n 3.3v 1909.495n 3.3v 1909.505n 3.3v 1919.495n 3.3v 1919.505n 3.3v 1929.495n 3.3v 1929.505n 3.3v 1939.495n 3.3v 1939.505n 3.3v 1949.495n 3.3v 1949.505n 0.0v 1959.495n 0.0v 1959.505n 0.0v 1969.495n 0.0v 1969.505n 0.0v 1979.495n 0.0v 1979.505n 3.3v 1989.495n 3.3v 1989.505n 3.3v 1999.495n 3.3v 1999.505n 3.3v 2009.495n 3.3v 2009.505n 3.3v 2019.495n 3.3v 2019.505n 3.3v 2029.495n 3.3v 2029.505n 3.3v 2039.495n 3.3v 2039.505n 3.3v 2049.495n 3.3v 2049.505n 3.3v )
* (time, data): [(0, 0), (10, 1), (20, 0), (30, 1), (40, 1), (50, 1), (60, 1), (70, 0), (80, 0), (90, 0), (100, 1), (110, 1), (120, 1), (130, 1), (140, 1), (150, 1), (160, 0), (170, 0), (180, 0), (190, 0), (200, 0), (210, 0), (220, 0), (230, 1), (240, 1), (250, 1), (260, 1), (270, 1), (280, 1), (290, 1), (300, 1), (310, 1), (320, 1), (330, 1), (340, 1), (350, 1), (360, 0), (370, 0), (380, 0), (390, 0), (400, 0), (410, 0), (420, 0), (430, 0), (440, 0), (450, 0), (460, 0), (470, 0), (480, 0), (490, 0), (500, 0), (510, 0), (520, 0), (530, 0), (540, 0), (550, 0), (560, 0), (570, 0), (580, 0), (590, 0), (600, 0), (610, 1), (620, 1), (630, 1), (640, 1), (650, 1), (660, 1), (670, 1), (680, 1), (690, 0), (700, 0), (710, 0), (720, 0), (730, 0), (740, 1), (750, 0), (760, 0), (770, 1), (780, 1), (790, 1), (800, 1), (810, 1), (820, 1), (830, 1), (840, 1), (850, 1), (860, 1), (870, 1), (880, 1), (890, 1), (900, 1), (910, 1), (920, 1), (930, 1), (940, 0), (950, 0), (960, 1), (970, 1), (980, 1), (990, 1), (1000, 1), (1010, 1), (1020, 1), (1030, 1), (1040, 1), (1050, 1), (1060, 1), (1070, 1), (1080, 0), (1090, 1), (1100, 1), (1110, 1), (1120, 1), (1130, 1), (1140, 1), (1150, 1), (1160, 1), (1170, 1), (1180, 1), (1190, 1), (1200, 1), (1210, 1), (1220, 1), (1230, 1), (1240, 1), (1250, 0), (1260, 0), (1270, 0), (1280, 1), (1290, 1), (1300, 1), (1310, 1), (1320, 1), (1330, 1), (1340, 0), (1350, 0), (1360, 0), (1370, 0), (1380, 0), (1390, 0), (1400, 0), (1410, 0), (1420, 0), (1430, 1), (1440, 1), (1450, 1), (1460, 1), (1470, 1), (1480, 0), (1490, 0), (1500, 0), (1510, 0), (1520, 0), (1530, 0), (1540, 0), (1550, 1), (1560, 1), (1570, 0), (1580, 0), (1590, 0), (1600, 0), (1610, 0), (1620, 0), (1630, 0), (1640, 0), (1650, 0), (1660, 1), (1670, 1), (1680, 0), (1690, 0), (1700, 0), (1710, 0), (1720, 0), (1730, 0), (1740, 0), (1750, 0), (1760, 0), (1770, 1), (1780, 1), (1790, 0), (1800, 0), (1810, 0), (1820, 0), (1830, 0), (1840, 0), (1850, 0), (1860, 0), (1870, 0), (1880, 0), (1890, 0), (1900, 0), (1910, 0), (1920, 0), (1930, 0), (1940, 0), (1950, 1), (1960, 1), (1970, 1), (1980, 1), (1990, 1), (2000, 1), (2010, 1), (2020, 1), (2030, 1), (2040, 1), (2050, 1)]
Vdin1_19  din1_19  0 PWL (0n 0.0v 9.495n 0.0v 9.505n 3.3v 19.495n 3.3v 19.505n 0.0v 29.495n 0.0v 29.505n 3.3v 39.495n 3.3v 39.505n 3.3v 49.495n 3.3v 49.505n 3.3v 59.495n 3.3v 59.505n 3.3v 69.495n 3.3v 69.505n 0.0v 79.495n 0.0v 79.505n 0.0v 89.495n 0.0v 89.505n 0.0v 99.495n 0.0v 99.505n 3.3v 109.495n 3.3v 109.505n 3.3v 119.495n 3.3v 119.505n 3.3v 129.495n 3.3v 129.505n 3.3v 139.495n 3.3v 139.505n 3.3v 149.495n 3.3v 149.505n 3.3v 159.495n 3.3v 159.505n 0.0v 169.495n 0.0v 169.505n 0.0v 179.495n 0.0v 179.505n 0.0v 189.495n 0.0v 189.505n 0.0v 199.495n 0.0v 199.505n 0.0v 209.495n 0.0v 209.505n 0.0v 219.495n 0.0v 219.505n 0.0v 229.495n 0.0v 229.505n 3.3v 239.495n 3.3v 239.505n 3.3v 249.495n 3.3v 249.505n 3.3v 259.495n 3.3v 259.505n 3.3v 269.495n 3.3v 269.505n 3.3v 279.495n 3.3v 279.505n 3.3v 289.495n 3.3v 289.505n 3.3v 299.495n 3.3v 299.505n 3.3v 309.495n 3.3v 309.505n 3.3v 319.495n 3.3v 319.505n 3.3v 329.495n 3.3v 329.505n 3.3v 339.495n 3.3v 339.505n 3.3v 349.495n 3.3v 349.505n 3.3v 359.495n 3.3v 359.505n 0.0v 369.495n 0.0v 369.505n 0.0v 379.495n 0.0v 379.505n 0.0v 389.495n 0.0v 389.505n 0.0v 399.495n 0.0v 399.505n 0.0v 409.495n 0.0v 409.505n 0.0v 419.495n 0.0v 419.505n 0.0v 429.495n 0.0v 429.505n 0.0v 439.495n 0.0v 439.505n 0.0v 449.495n 0.0v 449.505n 0.0v 459.495n 0.0v 459.505n 0.0v 469.495n 0.0v 469.505n 0.0v 479.495n 0.0v 479.505n 0.0v 489.495n 0.0v 489.505n 0.0v 499.495n 0.0v 499.505n 0.0v 509.495n 0.0v 509.505n 0.0v 519.495n 0.0v 519.505n 0.0v 529.495n 0.0v 529.505n 0.0v 539.495n 0.0v 539.505n 0.0v 549.495n 0.0v 549.505n 0.0v 559.495n 0.0v 559.505n 0.0v 569.495n 0.0v 569.505n 0.0v 579.495n 0.0v 579.505n 0.0v 589.495n 0.0v 589.505n 0.0v 599.495n 0.0v 599.505n 0.0v 609.495n 0.0v 609.505n 3.3v 619.495n 3.3v 619.505n 3.3v 629.495n 3.3v 629.505n 3.3v 639.495n 3.3v 639.505n 3.3v 649.495n 3.3v 649.505n 3.3v 659.495n 3.3v 659.505n 3.3v 669.495n 3.3v 669.505n 3.3v 679.495n 3.3v 679.505n 3.3v 689.495n 3.3v 689.505n 0.0v 699.495n 0.0v 699.505n 0.0v 709.495n 0.0v 709.505n 0.0v 719.495n 0.0v 719.505n 0.0v 729.495n 0.0v 729.505n 0.0v 739.495n 0.0v 739.505n 3.3v 749.495n 3.3v 749.505n 0.0v 759.495n 0.0v 759.505n 0.0v 769.495n 0.0v 769.505n 3.3v 779.495n 3.3v 779.505n 3.3v 789.495n 3.3v 789.505n 3.3v 799.495n 3.3v 799.505n 3.3v 809.495n 3.3v 809.505n 3.3v 819.495n 3.3v 819.505n 3.3v 829.495n 3.3v 829.505n 3.3v 839.495n 3.3v 839.505n 3.3v 849.495n 3.3v 849.505n 3.3v 859.495n 3.3v 859.505n 3.3v 869.495n 3.3v 869.505n 3.3v 879.495n 3.3v 879.505n 3.3v 889.495n 3.3v 889.505n 3.3v 899.495n 3.3v 899.505n 3.3v 909.495n 3.3v 909.505n 3.3v 919.495n 3.3v 919.505n 3.3v 929.495n 3.3v 929.505n 3.3v 939.495n 3.3v 939.505n 0.0v 949.495n 0.0v 949.505n 0.0v 959.495n 0.0v 959.505n 3.3v 969.495n 3.3v 969.505n 3.3v 979.495n 3.3v 979.505n 3.3v 989.495n 3.3v 989.505n 3.3v 999.495n 3.3v 999.505n 3.3v 1009.495n 3.3v 1009.505n 3.3v 1019.495n 3.3v 1019.505n 3.3v 1029.495n 3.3v 1029.505n 3.3v 1039.495n 3.3v 1039.505n 3.3v 1049.495n 3.3v 1049.505n 3.3v 1059.495n 3.3v 1059.505n 3.3v 1069.495n 3.3v 1069.505n 3.3v 1079.495n 3.3v 1079.505n 0.0v 1089.495n 0.0v 1089.505n 3.3v 1099.495n 3.3v 1099.505n 3.3v 1109.495n 3.3v 1109.505n 3.3v 1119.495n 3.3v 1119.505n 3.3v 1129.495n 3.3v 1129.505n 3.3v 1139.495n 3.3v 1139.505n 3.3v 1149.495n 3.3v 1149.505n 3.3v 1159.495n 3.3v 1159.505n 3.3v 1169.495n 3.3v 1169.505n 3.3v 1179.495n 3.3v 1179.505n 3.3v 1189.495n 3.3v 1189.505n 3.3v 1199.495n 3.3v 1199.505n 3.3v 1209.495n 3.3v 1209.505n 3.3v 1219.495n 3.3v 1219.505n 3.3v 1229.495n 3.3v 1229.505n 3.3v 1239.495n 3.3v 1239.505n 3.3v 1249.495n 3.3v 1249.505n 0.0v 1259.495n 0.0v 1259.505n 0.0v 1269.495n 0.0v 1269.505n 0.0v 1279.495n 0.0v 1279.505n 3.3v 1289.495n 3.3v 1289.505n 3.3v 1299.495n 3.3v 1299.505n 3.3v 1309.495n 3.3v 1309.505n 3.3v 1319.495n 3.3v 1319.505n 3.3v 1329.495n 3.3v 1329.505n 3.3v 1339.495n 3.3v 1339.505n 0.0v 1349.495n 0.0v 1349.505n 0.0v 1359.495n 0.0v 1359.505n 0.0v 1369.495n 0.0v 1369.505n 0.0v 1379.495n 0.0v 1379.505n 0.0v 1389.495n 0.0v 1389.505n 0.0v 1399.495n 0.0v 1399.505n 0.0v 1409.495n 0.0v 1409.505n 0.0v 1419.495n 0.0v 1419.505n 0.0v 1429.495n 0.0v 1429.505n 3.3v 1439.495n 3.3v 1439.505n 3.3v 1449.495n 3.3v 1449.505n 3.3v 1459.495n 3.3v 1459.505n 3.3v 1469.495n 3.3v 1469.505n 3.3v 1479.495n 3.3v 1479.505n 0.0v 1489.495n 0.0v 1489.505n 0.0v 1499.495n 0.0v 1499.505n 0.0v 1509.495n 0.0v 1509.505n 0.0v 1519.495n 0.0v 1519.505n 0.0v 1529.495n 0.0v 1529.505n 0.0v 1539.495n 0.0v 1539.505n 0.0v 1549.495n 0.0v 1549.505n 3.3v 1559.495n 3.3v 1559.505n 3.3v 1569.495n 3.3v 1569.505n 0.0v 1579.495n 0.0v 1579.505n 0.0v 1589.495n 0.0v 1589.505n 0.0v 1599.495n 0.0v 1599.505n 0.0v 1609.495n 0.0v 1609.505n 0.0v 1619.495n 0.0v 1619.505n 0.0v 1629.495n 0.0v 1629.505n 0.0v 1639.495n 0.0v 1639.505n 0.0v 1649.495n 0.0v 1649.505n 0.0v 1659.495n 0.0v 1659.505n 3.3v 1669.495n 3.3v 1669.505n 3.3v 1679.495n 3.3v 1679.505n 0.0v 1689.495n 0.0v 1689.505n 0.0v 1699.495n 0.0v 1699.505n 0.0v 1709.495n 0.0v 1709.505n 0.0v 1719.495n 0.0v 1719.505n 0.0v 1729.495n 0.0v 1729.505n 0.0v 1739.495n 0.0v 1739.505n 0.0v 1749.495n 0.0v 1749.505n 0.0v 1759.495n 0.0v 1759.505n 0.0v 1769.495n 0.0v 1769.505n 3.3v 1779.495n 3.3v 1779.505n 3.3v 1789.495n 3.3v 1789.505n 0.0v 1799.495n 0.0v 1799.505n 0.0v 1809.495n 0.0v 1809.505n 0.0v 1819.495n 0.0v 1819.505n 0.0v 1829.495n 0.0v 1829.505n 0.0v 1839.495n 0.0v 1839.505n 0.0v 1849.495n 0.0v 1849.505n 0.0v 1859.495n 0.0v 1859.505n 0.0v 1869.495n 0.0v 1869.505n 0.0v 1879.495n 0.0v 1879.505n 0.0v 1889.495n 0.0v 1889.505n 0.0v 1899.495n 0.0v 1899.505n 0.0v 1909.495n 0.0v 1909.505n 0.0v 1919.495n 0.0v 1919.505n 0.0v 1929.495n 0.0v 1929.505n 0.0v 1939.495n 0.0v 1939.505n 0.0v 1949.495n 0.0v 1949.505n 3.3v 1959.495n 3.3v 1959.505n 3.3v 1969.495n 3.3v 1969.505n 3.3v 1979.495n 3.3v 1979.505n 3.3v 1989.495n 3.3v 1989.505n 3.3v 1999.495n 3.3v 1999.505n 3.3v 2009.495n 3.3v 2009.505n 3.3v 2019.495n 3.3v 2019.505n 3.3v 2029.495n 3.3v 2029.505n 3.3v 2039.495n 3.3v 2039.505n 3.3v 2049.495n 3.3v 2049.505n 3.3v )
* (time, data): [(0, 0), (10, 0), (20, 0), (30, 1), (40, 1), (50, 1), (60, 1), (70, 1), (80, 1), (90, 1), (100, 0), (110, 0), (120, 0), (130, 0), (140, 0), (150, 0), (160, 1), (170, 1), (180, 1), (190, 1), (200, 1), (210, 1), (220, 1), (230, 1), (240, 1), (250, 1), (260, 1), (270, 1), (280, 1), (290, 1), (300, 1), (310, 1), (320, 1), (330, 0), (340, 0), (350, 0), (360, 0), (370, 0), (380, 0), (390, 0), (400, 0), (410, 0), (420, 0), (430, 0), (440, 1), (450, 1), (460, 1), (470, 1), (480, 1), (490, 1), (500, 1), (510, 1), (520, 1), (530, 1), (540, 1), (550, 1), (560, 1), (570, 1), (580, 1), (590, 1), (600, 1), (610, 0), (620, 0), (630, 0), (640, 0), (650, 0), (660, 0), (670, 0), (680, 0), (690, 1), (700, 1), (710, 1), (720, 1), (730, 1), (740, 0), (750, 1), (760, 1), (770, 1), (780, 1), (790, 1), (800, 1), (810, 1), (820, 1), (830, 1), (840, 0), (850, 0), (860, 0), (870, 0), (880, 0), (890, 0), (900, 0), (910, 1), (920, 1), (930, 1), (940, 0), (950, 0), (960, 1), (970, 1), (980, 1), (990, 1), (1000, 0), (1010, 0), (1020, 0), (1030, 0), (1040, 0), (1050, 0), (1060, 0), (1070, 0), (1080, 1), (1090, 1), (1100, 1), (1110, 1), (1120, 1), (1130, 1), (1140, 1), (1150, 1), (1160, 1), (1170, 1), (1180, 1), (1190, 1), (1200, 1), (1210, 1), (1220, 1), (1230, 1), (1240, 0), (1250, 0), (1260, 0), (1270, 0), (1280, 1), (1290, 1), (1300, 1), (1310, 1), (1320, 0), (1330, 0), (1340, 0), (1350, 0), (1360, 1), (1370, 1), (1380, 1), (1390, 1), (1400, 1), (1410, 1), (1420, 1), (1430, 0), (1440, 0), (1450, 0), (1460, 0), (1470, 1), (1480, 0), (1490, 0), (1500, 0), (1510, 0), (1520, 0), (1530, 0), (1540, 0), (1550, 1), (1560, 1), (1570, 1), (1580, 1), (1590, 1), (1600, 1), (1610, 0), (1620, 0), (1630, 0), (1640, 0), (1650, 0), (1660, 0), (1670, 0), (1680, 1), (1690, 1), (1700, 1), (1710, 1), (1720, 1), (1730, 1), (1740, 1), (1750, 1), (1760, 1), (1770, 1), (1780, 1), (1790, 0), (1800, 0), (1810, 0), (1820, 0), (1830, 0), (1840, 0), (1850, 0), (1860, 0), (1870, 0), (1880, 0), (1890, 0), (1900, 0), (1910, 0), (1920, 0), (1930, 0), (1940, 0), (1950, 1), (1960, 1), (1970, 1), (1980, 0), (1990, 0), (2000, 0), (2010, 0), (2020, 0), (2030, 0), (2040, 0), (2050, 0)]
Vdin1_20  din1_20  0 PWL (0n 0.0v 9.495n 0.0v 9.505n 0.0v 19.495n 0.0v 19.505n 0.0v 29.495n 0.0v 29.505n 3.3v 39.495n 3.3v 39.505n 3.3v 49.495n 3.3v 49.505n 3.3v 59.495n 3.3v 59.505n 3.3v 69.495n 3.3v 69.505n 3.3v 79.495n 3.3v 79.505n 3.3v 89.495n 3.3v 89.505n 3.3v 99.495n 3.3v 99.505n 0.0v 109.495n 0.0v 109.505n 0.0v 119.495n 0.0v 119.505n 0.0v 129.495n 0.0v 129.505n 0.0v 139.495n 0.0v 139.505n 0.0v 149.495n 0.0v 149.505n 0.0v 159.495n 0.0v 159.505n 3.3v 169.495n 3.3v 169.505n 3.3v 179.495n 3.3v 179.505n 3.3v 189.495n 3.3v 189.505n 3.3v 199.495n 3.3v 199.505n 3.3v 209.495n 3.3v 209.505n 3.3v 219.495n 3.3v 219.505n 3.3v 229.495n 3.3v 229.505n 3.3v 239.495n 3.3v 239.505n 3.3v 249.495n 3.3v 249.505n 3.3v 259.495n 3.3v 259.505n 3.3v 269.495n 3.3v 269.505n 3.3v 279.495n 3.3v 279.505n 3.3v 289.495n 3.3v 289.505n 3.3v 299.495n 3.3v 299.505n 3.3v 309.495n 3.3v 309.505n 3.3v 319.495n 3.3v 319.505n 3.3v 329.495n 3.3v 329.505n 0.0v 339.495n 0.0v 339.505n 0.0v 349.495n 0.0v 349.505n 0.0v 359.495n 0.0v 359.505n 0.0v 369.495n 0.0v 369.505n 0.0v 379.495n 0.0v 379.505n 0.0v 389.495n 0.0v 389.505n 0.0v 399.495n 0.0v 399.505n 0.0v 409.495n 0.0v 409.505n 0.0v 419.495n 0.0v 419.505n 0.0v 429.495n 0.0v 429.505n 0.0v 439.495n 0.0v 439.505n 3.3v 449.495n 3.3v 449.505n 3.3v 459.495n 3.3v 459.505n 3.3v 469.495n 3.3v 469.505n 3.3v 479.495n 3.3v 479.505n 3.3v 489.495n 3.3v 489.505n 3.3v 499.495n 3.3v 499.505n 3.3v 509.495n 3.3v 509.505n 3.3v 519.495n 3.3v 519.505n 3.3v 529.495n 3.3v 529.505n 3.3v 539.495n 3.3v 539.505n 3.3v 549.495n 3.3v 549.505n 3.3v 559.495n 3.3v 559.505n 3.3v 569.495n 3.3v 569.505n 3.3v 579.495n 3.3v 579.505n 3.3v 589.495n 3.3v 589.505n 3.3v 599.495n 3.3v 599.505n 3.3v 609.495n 3.3v 609.505n 0.0v 619.495n 0.0v 619.505n 0.0v 629.495n 0.0v 629.505n 0.0v 639.495n 0.0v 639.505n 0.0v 649.495n 0.0v 649.505n 0.0v 659.495n 0.0v 659.505n 0.0v 669.495n 0.0v 669.505n 0.0v 679.495n 0.0v 679.505n 0.0v 689.495n 0.0v 689.505n 3.3v 699.495n 3.3v 699.505n 3.3v 709.495n 3.3v 709.505n 3.3v 719.495n 3.3v 719.505n 3.3v 729.495n 3.3v 729.505n 3.3v 739.495n 3.3v 739.505n 0.0v 749.495n 0.0v 749.505n 3.3v 759.495n 3.3v 759.505n 3.3v 769.495n 3.3v 769.505n 3.3v 779.495n 3.3v 779.505n 3.3v 789.495n 3.3v 789.505n 3.3v 799.495n 3.3v 799.505n 3.3v 809.495n 3.3v 809.505n 3.3v 819.495n 3.3v 819.505n 3.3v 829.495n 3.3v 829.505n 3.3v 839.495n 3.3v 839.505n 0.0v 849.495n 0.0v 849.505n 0.0v 859.495n 0.0v 859.505n 0.0v 869.495n 0.0v 869.505n 0.0v 879.495n 0.0v 879.505n 0.0v 889.495n 0.0v 889.505n 0.0v 899.495n 0.0v 899.505n 0.0v 909.495n 0.0v 909.505n 3.3v 919.495n 3.3v 919.505n 3.3v 929.495n 3.3v 929.505n 3.3v 939.495n 3.3v 939.505n 0.0v 949.495n 0.0v 949.505n 0.0v 959.495n 0.0v 959.505n 3.3v 969.495n 3.3v 969.505n 3.3v 979.495n 3.3v 979.505n 3.3v 989.495n 3.3v 989.505n 3.3v 999.495n 3.3v 999.505n 0.0v 1009.495n 0.0v 1009.505n 0.0v 1019.495n 0.0v 1019.505n 0.0v 1029.495n 0.0v 1029.505n 0.0v 1039.495n 0.0v 1039.505n 0.0v 1049.495n 0.0v 1049.505n 0.0v 1059.495n 0.0v 1059.505n 0.0v 1069.495n 0.0v 1069.505n 0.0v 1079.495n 0.0v 1079.505n 3.3v 1089.495n 3.3v 1089.505n 3.3v 1099.495n 3.3v 1099.505n 3.3v 1109.495n 3.3v 1109.505n 3.3v 1119.495n 3.3v 1119.505n 3.3v 1129.495n 3.3v 1129.505n 3.3v 1139.495n 3.3v 1139.505n 3.3v 1149.495n 3.3v 1149.505n 3.3v 1159.495n 3.3v 1159.505n 3.3v 1169.495n 3.3v 1169.505n 3.3v 1179.495n 3.3v 1179.505n 3.3v 1189.495n 3.3v 1189.505n 3.3v 1199.495n 3.3v 1199.505n 3.3v 1209.495n 3.3v 1209.505n 3.3v 1219.495n 3.3v 1219.505n 3.3v 1229.495n 3.3v 1229.505n 3.3v 1239.495n 3.3v 1239.505n 0.0v 1249.495n 0.0v 1249.505n 0.0v 1259.495n 0.0v 1259.505n 0.0v 1269.495n 0.0v 1269.505n 0.0v 1279.495n 0.0v 1279.505n 3.3v 1289.495n 3.3v 1289.505n 3.3v 1299.495n 3.3v 1299.505n 3.3v 1309.495n 3.3v 1309.505n 3.3v 1319.495n 3.3v 1319.505n 0.0v 1329.495n 0.0v 1329.505n 0.0v 1339.495n 0.0v 1339.505n 0.0v 1349.495n 0.0v 1349.505n 0.0v 1359.495n 0.0v 1359.505n 3.3v 1369.495n 3.3v 1369.505n 3.3v 1379.495n 3.3v 1379.505n 3.3v 1389.495n 3.3v 1389.505n 3.3v 1399.495n 3.3v 1399.505n 3.3v 1409.495n 3.3v 1409.505n 3.3v 1419.495n 3.3v 1419.505n 3.3v 1429.495n 3.3v 1429.505n 0.0v 1439.495n 0.0v 1439.505n 0.0v 1449.495n 0.0v 1449.505n 0.0v 1459.495n 0.0v 1459.505n 0.0v 1469.495n 0.0v 1469.505n 3.3v 1479.495n 3.3v 1479.505n 0.0v 1489.495n 0.0v 1489.505n 0.0v 1499.495n 0.0v 1499.505n 0.0v 1509.495n 0.0v 1509.505n 0.0v 1519.495n 0.0v 1519.505n 0.0v 1529.495n 0.0v 1529.505n 0.0v 1539.495n 0.0v 1539.505n 0.0v 1549.495n 0.0v 1549.505n 3.3v 1559.495n 3.3v 1559.505n 3.3v 1569.495n 3.3v 1569.505n 3.3v 1579.495n 3.3v 1579.505n 3.3v 1589.495n 3.3v 1589.505n 3.3v 1599.495n 3.3v 1599.505n 3.3v 1609.495n 3.3v 1609.505n 0.0v 1619.495n 0.0v 1619.505n 0.0v 1629.495n 0.0v 1629.505n 0.0v 1639.495n 0.0v 1639.505n 0.0v 1649.495n 0.0v 1649.505n 0.0v 1659.495n 0.0v 1659.505n 0.0v 1669.495n 0.0v 1669.505n 0.0v 1679.495n 0.0v 1679.505n 3.3v 1689.495n 3.3v 1689.505n 3.3v 1699.495n 3.3v 1699.505n 3.3v 1709.495n 3.3v 1709.505n 3.3v 1719.495n 3.3v 1719.505n 3.3v 1729.495n 3.3v 1729.505n 3.3v 1739.495n 3.3v 1739.505n 3.3v 1749.495n 3.3v 1749.505n 3.3v 1759.495n 3.3v 1759.505n 3.3v 1769.495n 3.3v 1769.505n 3.3v 1779.495n 3.3v 1779.505n 3.3v 1789.495n 3.3v 1789.505n 0.0v 1799.495n 0.0v 1799.505n 0.0v 1809.495n 0.0v 1809.505n 0.0v 1819.495n 0.0v 1819.505n 0.0v 1829.495n 0.0v 1829.505n 0.0v 1839.495n 0.0v 1839.505n 0.0v 1849.495n 0.0v 1849.505n 0.0v 1859.495n 0.0v 1859.505n 0.0v 1869.495n 0.0v 1869.505n 0.0v 1879.495n 0.0v 1879.505n 0.0v 1889.495n 0.0v 1889.505n 0.0v 1899.495n 0.0v 1899.505n 0.0v 1909.495n 0.0v 1909.505n 0.0v 1919.495n 0.0v 1919.505n 0.0v 1929.495n 0.0v 1929.505n 0.0v 1939.495n 0.0v 1939.505n 0.0v 1949.495n 0.0v 1949.505n 3.3v 1959.495n 3.3v 1959.505n 3.3v 1969.495n 3.3v 1969.505n 3.3v 1979.495n 3.3v 1979.505n 0.0v 1989.495n 0.0v 1989.505n 0.0v 1999.495n 0.0v 1999.505n 0.0v 2009.495n 0.0v 2009.505n 0.0v 2019.495n 0.0v 2019.505n 0.0v 2029.495n 0.0v 2029.505n 0.0v 2039.495n 0.0v 2039.505n 0.0v 2049.495n 0.0v 2049.505n 0.0v )
* (time, data): [(0, 0), (10, 0), (20, 1), (30, 1), (40, 1), (50, 1), (60, 0), (70, 0), (80, 0), (90, 0), (100, 0), (110, 0), (120, 0), (130, 0), (140, 0), (150, 1), (160, 1), (170, 1), (180, 0), (190, 0), (200, 0), (210, 0), (220, 0), (230, 0), (240, 0), (250, 0), (260, 0), (270, 0), (280, 0), (290, 0), (300, 0), (310, 0), (320, 0), (330, 1), (340, 1), (350, 1), (360, 0), (370, 0), (380, 0), (390, 0), (400, 0), (410, 0), (420, 0), (430, 0), (440, 1), (450, 1), (460, 1), (470, 1), (480, 1), (490, 1), (500, 1), (510, 1), (520, 1), (530, 1), (540, 1), (550, 1), (560, 1), (570, 1), (580, 1), (590, 1), (600, 1), (610, 1), (620, 1), (630, 1), (640, 1), (650, 1), (660, 1), (670, 1), (680, 1), (690, 1), (700, 1), (710, 1), (720, 1), (730, 1), (740, 1), (750, 0), (760, 0), (770, 0), (780, 0), (790, 0), (800, 1), (810, 1), (820, 1), (830, 1), (840, 1), (850, 1), (860, 1), (870, 1), (880, 1), (890, 1), (900, 1), (910, 0), (920, 0), (930, 0), (940, 1), (950, 1), (960, 0), (970, 0), (980, 0), (990, 0), (1000, 1), (1010, 1), (1020, 1), (1030, 1), (1040, 1), (1050, 1), (1060, 1), (1070, 1), (1080, 1), (1090, 1), (1100, 1), (1110, 1), (1120, 1), (1130, 1), (1140, 1), (1150, 1), (1160, 1), (1170, 1), (1180, 1), (1190, 1), (1200, 1), (1210, 1), (1220, 1), (1230, 1), (1240, 0), (1250, 0), (1260, 0), (1270, 0), (1280, 0), (1290, 0), (1300, 0), (1310, 0), (1320, 1), (1330, 1), (1340, 1), (1350, 1), (1360, 1), (1370, 1), (1380, 1), (1390, 1), (1400, 1), (1410, 1), (1420, 1), (1430, 0), (1440, 1), (1450, 1), (1460, 1), (1470, 0), (1480, 0), (1490, 0), (1500, 0), (1510, 0), (1520, 0), (1530, 0), (1540, 0), (1550, 1), (1560, 1), (1570, 1), (1580, 1), (1590, 1), (1600, 1), (1610, 0), (1620, 0), (1630, 0), (1640, 0), (1650, 0), (1660, 0), (1670, 0), (1680, 1), (1690, 1), (1700, 1), (1710, 1), (1720, 1), (1730, 1), (1740, 1), (1750, 1), (1760, 1), (1770, 1), (1780, 1), (1790, 1), (1800, 1), (1810, 1), (1820, 1), (1830, 1), (1840, 1), (1850, 1), (1860, 1), (1870, 1), (1880, 1), (1890, 1), (1900, 1), (1910, 1), (1920, 1), (1930, 1), (1940, 1), (1950, 1), (1960, 1), (1970, 1), (1980, 1), (1990, 1), (2000, 1), (2010, 1), (2020, 0), (2030, 1), (2040, 1), (2050, 1)]
Vdin1_21  din1_21  0 PWL (0n 0.0v 9.495n 0.0v 9.505n 0.0v 19.495n 0.0v 19.505n 3.3v 29.495n 3.3v 29.505n 3.3v 39.495n 3.3v 39.505n 3.3v 49.495n 3.3v 49.505n 3.3v 59.495n 3.3v 59.505n 0.0v 69.495n 0.0v 69.505n 0.0v 79.495n 0.0v 79.505n 0.0v 89.495n 0.0v 89.505n 0.0v 99.495n 0.0v 99.505n 0.0v 109.495n 0.0v 109.505n 0.0v 119.495n 0.0v 119.505n 0.0v 129.495n 0.0v 129.505n 0.0v 139.495n 0.0v 139.505n 0.0v 149.495n 0.0v 149.505n 3.3v 159.495n 3.3v 159.505n 3.3v 169.495n 3.3v 169.505n 3.3v 179.495n 3.3v 179.505n 0.0v 189.495n 0.0v 189.505n 0.0v 199.495n 0.0v 199.505n 0.0v 209.495n 0.0v 209.505n 0.0v 219.495n 0.0v 219.505n 0.0v 229.495n 0.0v 229.505n 0.0v 239.495n 0.0v 239.505n 0.0v 249.495n 0.0v 249.505n 0.0v 259.495n 0.0v 259.505n 0.0v 269.495n 0.0v 269.505n 0.0v 279.495n 0.0v 279.505n 0.0v 289.495n 0.0v 289.505n 0.0v 299.495n 0.0v 299.505n 0.0v 309.495n 0.0v 309.505n 0.0v 319.495n 0.0v 319.505n 0.0v 329.495n 0.0v 329.505n 3.3v 339.495n 3.3v 339.505n 3.3v 349.495n 3.3v 349.505n 3.3v 359.495n 3.3v 359.505n 0.0v 369.495n 0.0v 369.505n 0.0v 379.495n 0.0v 379.505n 0.0v 389.495n 0.0v 389.505n 0.0v 399.495n 0.0v 399.505n 0.0v 409.495n 0.0v 409.505n 0.0v 419.495n 0.0v 419.505n 0.0v 429.495n 0.0v 429.505n 0.0v 439.495n 0.0v 439.505n 3.3v 449.495n 3.3v 449.505n 3.3v 459.495n 3.3v 459.505n 3.3v 469.495n 3.3v 469.505n 3.3v 479.495n 3.3v 479.505n 3.3v 489.495n 3.3v 489.505n 3.3v 499.495n 3.3v 499.505n 3.3v 509.495n 3.3v 509.505n 3.3v 519.495n 3.3v 519.505n 3.3v 529.495n 3.3v 529.505n 3.3v 539.495n 3.3v 539.505n 3.3v 549.495n 3.3v 549.505n 3.3v 559.495n 3.3v 559.505n 3.3v 569.495n 3.3v 569.505n 3.3v 579.495n 3.3v 579.505n 3.3v 589.495n 3.3v 589.505n 3.3v 599.495n 3.3v 599.505n 3.3v 609.495n 3.3v 609.505n 3.3v 619.495n 3.3v 619.505n 3.3v 629.495n 3.3v 629.505n 3.3v 639.495n 3.3v 639.505n 3.3v 649.495n 3.3v 649.505n 3.3v 659.495n 3.3v 659.505n 3.3v 669.495n 3.3v 669.505n 3.3v 679.495n 3.3v 679.505n 3.3v 689.495n 3.3v 689.505n 3.3v 699.495n 3.3v 699.505n 3.3v 709.495n 3.3v 709.505n 3.3v 719.495n 3.3v 719.505n 3.3v 729.495n 3.3v 729.505n 3.3v 739.495n 3.3v 739.505n 3.3v 749.495n 3.3v 749.505n 0.0v 759.495n 0.0v 759.505n 0.0v 769.495n 0.0v 769.505n 0.0v 779.495n 0.0v 779.505n 0.0v 789.495n 0.0v 789.505n 0.0v 799.495n 0.0v 799.505n 3.3v 809.495n 3.3v 809.505n 3.3v 819.495n 3.3v 819.505n 3.3v 829.495n 3.3v 829.505n 3.3v 839.495n 3.3v 839.505n 3.3v 849.495n 3.3v 849.505n 3.3v 859.495n 3.3v 859.505n 3.3v 869.495n 3.3v 869.505n 3.3v 879.495n 3.3v 879.505n 3.3v 889.495n 3.3v 889.505n 3.3v 899.495n 3.3v 899.505n 3.3v 909.495n 3.3v 909.505n 0.0v 919.495n 0.0v 919.505n 0.0v 929.495n 0.0v 929.505n 0.0v 939.495n 0.0v 939.505n 3.3v 949.495n 3.3v 949.505n 3.3v 959.495n 3.3v 959.505n 0.0v 969.495n 0.0v 969.505n 0.0v 979.495n 0.0v 979.505n 0.0v 989.495n 0.0v 989.505n 0.0v 999.495n 0.0v 999.505n 3.3v 1009.495n 3.3v 1009.505n 3.3v 1019.495n 3.3v 1019.505n 3.3v 1029.495n 3.3v 1029.505n 3.3v 1039.495n 3.3v 1039.505n 3.3v 1049.495n 3.3v 1049.505n 3.3v 1059.495n 3.3v 1059.505n 3.3v 1069.495n 3.3v 1069.505n 3.3v 1079.495n 3.3v 1079.505n 3.3v 1089.495n 3.3v 1089.505n 3.3v 1099.495n 3.3v 1099.505n 3.3v 1109.495n 3.3v 1109.505n 3.3v 1119.495n 3.3v 1119.505n 3.3v 1129.495n 3.3v 1129.505n 3.3v 1139.495n 3.3v 1139.505n 3.3v 1149.495n 3.3v 1149.505n 3.3v 1159.495n 3.3v 1159.505n 3.3v 1169.495n 3.3v 1169.505n 3.3v 1179.495n 3.3v 1179.505n 3.3v 1189.495n 3.3v 1189.505n 3.3v 1199.495n 3.3v 1199.505n 3.3v 1209.495n 3.3v 1209.505n 3.3v 1219.495n 3.3v 1219.505n 3.3v 1229.495n 3.3v 1229.505n 3.3v 1239.495n 3.3v 1239.505n 0.0v 1249.495n 0.0v 1249.505n 0.0v 1259.495n 0.0v 1259.505n 0.0v 1269.495n 0.0v 1269.505n 0.0v 1279.495n 0.0v 1279.505n 0.0v 1289.495n 0.0v 1289.505n 0.0v 1299.495n 0.0v 1299.505n 0.0v 1309.495n 0.0v 1309.505n 0.0v 1319.495n 0.0v 1319.505n 3.3v 1329.495n 3.3v 1329.505n 3.3v 1339.495n 3.3v 1339.505n 3.3v 1349.495n 3.3v 1349.505n 3.3v 1359.495n 3.3v 1359.505n 3.3v 1369.495n 3.3v 1369.505n 3.3v 1379.495n 3.3v 1379.505n 3.3v 1389.495n 3.3v 1389.505n 3.3v 1399.495n 3.3v 1399.505n 3.3v 1409.495n 3.3v 1409.505n 3.3v 1419.495n 3.3v 1419.505n 3.3v 1429.495n 3.3v 1429.505n 0.0v 1439.495n 0.0v 1439.505n 3.3v 1449.495n 3.3v 1449.505n 3.3v 1459.495n 3.3v 1459.505n 3.3v 1469.495n 3.3v 1469.505n 0.0v 1479.495n 0.0v 1479.505n 0.0v 1489.495n 0.0v 1489.505n 0.0v 1499.495n 0.0v 1499.505n 0.0v 1509.495n 0.0v 1509.505n 0.0v 1519.495n 0.0v 1519.505n 0.0v 1529.495n 0.0v 1529.505n 0.0v 1539.495n 0.0v 1539.505n 0.0v 1549.495n 0.0v 1549.505n 3.3v 1559.495n 3.3v 1559.505n 3.3v 1569.495n 3.3v 1569.505n 3.3v 1579.495n 3.3v 1579.505n 3.3v 1589.495n 3.3v 1589.505n 3.3v 1599.495n 3.3v 1599.505n 3.3v 1609.495n 3.3v 1609.505n 0.0v 1619.495n 0.0v 1619.505n 0.0v 1629.495n 0.0v 1629.505n 0.0v 1639.495n 0.0v 1639.505n 0.0v 1649.495n 0.0v 1649.505n 0.0v 1659.495n 0.0v 1659.505n 0.0v 1669.495n 0.0v 1669.505n 0.0v 1679.495n 0.0v 1679.505n 3.3v 1689.495n 3.3v 1689.505n 3.3v 1699.495n 3.3v 1699.505n 3.3v 1709.495n 3.3v 1709.505n 3.3v 1719.495n 3.3v 1719.505n 3.3v 1729.495n 3.3v 1729.505n 3.3v 1739.495n 3.3v 1739.505n 3.3v 1749.495n 3.3v 1749.505n 3.3v 1759.495n 3.3v 1759.505n 3.3v 1769.495n 3.3v 1769.505n 3.3v 1779.495n 3.3v 1779.505n 3.3v 1789.495n 3.3v 1789.505n 3.3v 1799.495n 3.3v 1799.505n 3.3v 1809.495n 3.3v 1809.505n 3.3v 1819.495n 3.3v 1819.505n 3.3v 1829.495n 3.3v 1829.505n 3.3v 1839.495n 3.3v 1839.505n 3.3v 1849.495n 3.3v 1849.505n 3.3v 1859.495n 3.3v 1859.505n 3.3v 1869.495n 3.3v 1869.505n 3.3v 1879.495n 3.3v 1879.505n 3.3v 1889.495n 3.3v 1889.505n 3.3v 1899.495n 3.3v 1899.505n 3.3v 1909.495n 3.3v 1909.505n 3.3v 1919.495n 3.3v 1919.505n 3.3v 1929.495n 3.3v 1929.505n 3.3v 1939.495n 3.3v 1939.505n 3.3v 1949.495n 3.3v 1949.505n 3.3v 1959.495n 3.3v 1959.505n 3.3v 1969.495n 3.3v 1969.505n 3.3v 1979.495n 3.3v 1979.505n 3.3v 1989.495n 3.3v 1989.505n 3.3v 1999.495n 3.3v 1999.505n 3.3v 2009.495n 3.3v 2009.505n 3.3v 2019.495n 3.3v 2019.505n 0.0v 2029.495n 0.0v 2029.505n 3.3v 2039.495n 3.3v 2039.505n 3.3v 2049.495n 3.3v 2049.505n 3.3v )
* (time, data): [(0, 0), (10, 0), (20, 1), (30, 1), (40, 1), (50, 0), (60, 1), (70, 1), (80, 1), (90, 1), (100, 0), (110, 0), (120, 0), (130, 0), (140, 0), (150, 0), (160, 1), (170, 1), (180, 0), (190, 0), (200, 0), (210, 0), (220, 0), (230, 1), (240, 1), (250, 1), (260, 1), (270, 1), (280, 1), (290, 1), (300, 1), (310, 1), (320, 1), (330, 1), (340, 1), (350, 1), (360, 0), (370, 0), (380, 0), (390, 0), (400, 0), (410, 0), (420, 0), (430, 0), (440, 0), (450, 0), (460, 0), (470, 0), (480, 0), (490, 0), (500, 0), (510, 0), (520, 0), (530, 0), (540, 0), (550, 0), (560, 0), (570, 0), (580, 0), (590, 0), (600, 0), (610, 1), (620, 1), (630, 0), (640, 0), (650, 0), (660, 0), (670, 0), (680, 0), (690, 0), (700, 0), (710, 0), (720, 0), (730, 0), (740, 0), (750, 1), (760, 1), (770, 0), (780, 0), (790, 0), (800, 0), (810, 0), (820, 0), (830, 0), (840, 0), (850, 0), (860, 0), (870, 0), (880, 0), (890, 0), (900, 0), (910, 0), (920, 0), (930, 0), (940, 0), (950, 0), (960, 0), (970, 0), (980, 0), (990, 0), (1000, 0), (1010, 0), (1020, 0), (1030, 0), (1040, 0), (1050, 0), (1060, 0), (1070, 0), (1080, 0), (1090, 0), (1100, 0), (1110, 0), (1120, 0), (1130, 0), (1140, 0), (1150, 0), (1160, 0), (1170, 0), (1180, 0), (1190, 0), (1200, 0), (1210, 0), (1220, 0), (1230, 0), (1240, 0), (1250, 1), (1260, 1), (1270, 1), (1280, 1), (1290, 1), (1300, 1), (1310, 1), (1320, 0), (1330, 0), (1340, 1), (1350, 1), (1360, 0), (1370, 0), (1380, 0), (1390, 0), (1400, 0), (1410, 0), (1420, 0), (1430, 0), (1440, 0), (1450, 0), (1460, 0), (1470, 1), (1480, 1), (1490, 1), (1500, 1), (1510, 1), (1520, 1), (1530, 1), (1540, 1), (1550, 0), (1560, 0), (1570, 0), (1580, 0), (1590, 0), (1600, 0), (1610, 0), (1620, 0), (1630, 0), (1640, 0), (1650, 0), (1660, 0), (1670, 0), (1680, 0), (1690, 0), (1700, 0), (1710, 0), (1720, 0), (1730, 0), (1740, 0), (1750, 0), (1760, 0), (1770, 0), (1780, 0), (1790, 0), (1800, 0), (1810, 0), (1820, 0), (1830, 0), (1840, 0), (1850, 0), (1860, 0), (1870, 0), (1880, 0), (1890, 0), (1900, 0), (1910, 0), (1920, 0), (1930, 0), (1940, 0), (1950, 1), (1960, 1), (1970, 1), (1980, 0), (1990, 0), (2000, 0), (2010, 0), (2020, 0), (2030, 0), (2040, 0), (2050, 0)]
Vdin1_22  din1_22  0 PWL (0n 0.0v 9.495n 0.0v 9.505n 0.0v 19.495n 0.0v 19.505n 3.3v 29.495n 3.3v 29.505n 3.3v 39.495n 3.3v 39.505n 3.3v 49.495n 3.3v 49.505n 0.0v 59.495n 0.0v 59.505n 3.3v 69.495n 3.3v 69.505n 3.3v 79.495n 3.3v 79.505n 3.3v 89.495n 3.3v 89.505n 3.3v 99.495n 3.3v 99.505n 0.0v 109.495n 0.0v 109.505n 0.0v 119.495n 0.0v 119.505n 0.0v 129.495n 0.0v 129.505n 0.0v 139.495n 0.0v 139.505n 0.0v 149.495n 0.0v 149.505n 0.0v 159.495n 0.0v 159.505n 3.3v 169.495n 3.3v 169.505n 3.3v 179.495n 3.3v 179.505n 0.0v 189.495n 0.0v 189.505n 0.0v 199.495n 0.0v 199.505n 0.0v 209.495n 0.0v 209.505n 0.0v 219.495n 0.0v 219.505n 0.0v 229.495n 0.0v 229.505n 3.3v 239.495n 3.3v 239.505n 3.3v 249.495n 3.3v 249.505n 3.3v 259.495n 3.3v 259.505n 3.3v 269.495n 3.3v 269.505n 3.3v 279.495n 3.3v 279.505n 3.3v 289.495n 3.3v 289.505n 3.3v 299.495n 3.3v 299.505n 3.3v 309.495n 3.3v 309.505n 3.3v 319.495n 3.3v 319.505n 3.3v 329.495n 3.3v 329.505n 3.3v 339.495n 3.3v 339.505n 3.3v 349.495n 3.3v 349.505n 3.3v 359.495n 3.3v 359.505n 0.0v 369.495n 0.0v 369.505n 0.0v 379.495n 0.0v 379.505n 0.0v 389.495n 0.0v 389.505n 0.0v 399.495n 0.0v 399.505n 0.0v 409.495n 0.0v 409.505n 0.0v 419.495n 0.0v 419.505n 0.0v 429.495n 0.0v 429.505n 0.0v 439.495n 0.0v 439.505n 0.0v 449.495n 0.0v 449.505n 0.0v 459.495n 0.0v 459.505n 0.0v 469.495n 0.0v 469.505n 0.0v 479.495n 0.0v 479.505n 0.0v 489.495n 0.0v 489.505n 0.0v 499.495n 0.0v 499.505n 0.0v 509.495n 0.0v 509.505n 0.0v 519.495n 0.0v 519.505n 0.0v 529.495n 0.0v 529.505n 0.0v 539.495n 0.0v 539.505n 0.0v 549.495n 0.0v 549.505n 0.0v 559.495n 0.0v 559.505n 0.0v 569.495n 0.0v 569.505n 0.0v 579.495n 0.0v 579.505n 0.0v 589.495n 0.0v 589.505n 0.0v 599.495n 0.0v 599.505n 0.0v 609.495n 0.0v 609.505n 3.3v 619.495n 3.3v 619.505n 3.3v 629.495n 3.3v 629.505n 0.0v 639.495n 0.0v 639.505n 0.0v 649.495n 0.0v 649.505n 0.0v 659.495n 0.0v 659.505n 0.0v 669.495n 0.0v 669.505n 0.0v 679.495n 0.0v 679.505n 0.0v 689.495n 0.0v 689.505n 0.0v 699.495n 0.0v 699.505n 0.0v 709.495n 0.0v 709.505n 0.0v 719.495n 0.0v 719.505n 0.0v 729.495n 0.0v 729.505n 0.0v 739.495n 0.0v 739.505n 0.0v 749.495n 0.0v 749.505n 3.3v 759.495n 3.3v 759.505n 3.3v 769.495n 3.3v 769.505n 0.0v 779.495n 0.0v 779.505n 0.0v 789.495n 0.0v 789.505n 0.0v 799.495n 0.0v 799.505n 0.0v 809.495n 0.0v 809.505n 0.0v 819.495n 0.0v 819.505n 0.0v 829.495n 0.0v 829.505n 0.0v 839.495n 0.0v 839.505n 0.0v 849.495n 0.0v 849.505n 0.0v 859.495n 0.0v 859.505n 0.0v 869.495n 0.0v 869.505n 0.0v 879.495n 0.0v 879.505n 0.0v 889.495n 0.0v 889.505n 0.0v 899.495n 0.0v 899.505n 0.0v 909.495n 0.0v 909.505n 0.0v 919.495n 0.0v 919.505n 0.0v 929.495n 0.0v 929.505n 0.0v 939.495n 0.0v 939.505n 0.0v 949.495n 0.0v 949.505n 0.0v 959.495n 0.0v 959.505n 0.0v 969.495n 0.0v 969.505n 0.0v 979.495n 0.0v 979.505n 0.0v 989.495n 0.0v 989.505n 0.0v 999.495n 0.0v 999.505n 0.0v 1009.495n 0.0v 1009.505n 0.0v 1019.495n 0.0v 1019.505n 0.0v 1029.495n 0.0v 1029.505n 0.0v 1039.495n 0.0v 1039.505n 0.0v 1049.495n 0.0v 1049.505n 0.0v 1059.495n 0.0v 1059.505n 0.0v 1069.495n 0.0v 1069.505n 0.0v 1079.495n 0.0v 1079.505n 0.0v 1089.495n 0.0v 1089.505n 0.0v 1099.495n 0.0v 1099.505n 0.0v 1109.495n 0.0v 1109.505n 0.0v 1119.495n 0.0v 1119.505n 0.0v 1129.495n 0.0v 1129.505n 0.0v 1139.495n 0.0v 1139.505n 0.0v 1149.495n 0.0v 1149.505n 0.0v 1159.495n 0.0v 1159.505n 0.0v 1169.495n 0.0v 1169.505n 0.0v 1179.495n 0.0v 1179.505n 0.0v 1189.495n 0.0v 1189.505n 0.0v 1199.495n 0.0v 1199.505n 0.0v 1209.495n 0.0v 1209.505n 0.0v 1219.495n 0.0v 1219.505n 0.0v 1229.495n 0.0v 1229.505n 0.0v 1239.495n 0.0v 1239.505n 0.0v 1249.495n 0.0v 1249.505n 3.3v 1259.495n 3.3v 1259.505n 3.3v 1269.495n 3.3v 1269.505n 3.3v 1279.495n 3.3v 1279.505n 3.3v 1289.495n 3.3v 1289.505n 3.3v 1299.495n 3.3v 1299.505n 3.3v 1309.495n 3.3v 1309.505n 3.3v 1319.495n 3.3v 1319.505n 0.0v 1329.495n 0.0v 1329.505n 0.0v 1339.495n 0.0v 1339.505n 3.3v 1349.495n 3.3v 1349.505n 3.3v 1359.495n 3.3v 1359.505n 0.0v 1369.495n 0.0v 1369.505n 0.0v 1379.495n 0.0v 1379.505n 0.0v 1389.495n 0.0v 1389.505n 0.0v 1399.495n 0.0v 1399.505n 0.0v 1409.495n 0.0v 1409.505n 0.0v 1419.495n 0.0v 1419.505n 0.0v 1429.495n 0.0v 1429.505n 0.0v 1439.495n 0.0v 1439.505n 0.0v 1449.495n 0.0v 1449.505n 0.0v 1459.495n 0.0v 1459.505n 0.0v 1469.495n 0.0v 1469.505n 3.3v 1479.495n 3.3v 1479.505n 3.3v 1489.495n 3.3v 1489.505n 3.3v 1499.495n 3.3v 1499.505n 3.3v 1509.495n 3.3v 1509.505n 3.3v 1519.495n 3.3v 1519.505n 3.3v 1529.495n 3.3v 1529.505n 3.3v 1539.495n 3.3v 1539.505n 3.3v 1549.495n 3.3v 1549.505n 0.0v 1559.495n 0.0v 1559.505n 0.0v 1569.495n 0.0v 1569.505n 0.0v 1579.495n 0.0v 1579.505n 0.0v 1589.495n 0.0v 1589.505n 0.0v 1599.495n 0.0v 1599.505n 0.0v 1609.495n 0.0v 1609.505n 0.0v 1619.495n 0.0v 1619.505n 0.0v 1629.495n 0.0v 1629.505n 0.0v 1639.495n 0.0v 1639.505n 0.0v 1649.495n 0.0v 1649.505n 0.0v 1659.495n 0.0v 1659.505n 0.0v 1669.495n 0.0v 1669.505n 0.0v 1679.495n 0.0v 1679.505n 0.0v 1689.495n 0.0v 1689.505n 0.0v 1699.495n 0.0v 1699.505n 0.0v 1709.495n 0.0v 1709.505n 0.0v 1719.495n 0.0v 1719.505n 0.0v 1729.495n 0.0v 1729.505n 0.0v 1739.495n 0.0v 1739.505n 0.0v 1749.495n 0.0v 1749.505n 0.0v 1759.495n 0.0v 1759.505n 0.0v 1769.495n 0.0v 1769.505n 0.0v 1779.495n 0.0v 1779.505n 0.0v 1789.495n 0.0v 1789.505n 0.0v 1799.495n 0.0v 1799.505n 0.0v 1809.495n 0.0v 1809.505n 0.0v 1819.495n 0.0v 1819.505n 0.0v 1829.495n 0.0v 1829.505n 0.0v 1839.495n 0.0v 1839.505n 0.0v 1849.495n 0.0v 1849.505n 0.0v 1859.495n 0.0v 1859.505n 0.0v 1869.495n 0.0v 1869.505n 0.0v 1879.495n 0.0v 1879.505n 0.0v 1889.495n 0.0v 1889.505n 0.0v 1899.495n 0.0v 1899.505n 0.0v 1909.495n 0.0v 1909.505n 0.0v 1919.495n 0.0v 1919.505n 0.0v 1929.495n 0.0v 1929.505n 0.0v 1939.495n 0.0v 1939.505n 0.0v 1949.495n 0.0v 1949.505n 3.3v 1959.495n 3.3v 1959.505n 3.3v 1969.495n 3.3v 1969.505n 3.3v 1979.495n 3.3v 1979.505n 0.0v 1989.495n 0.0v 1989.505n 0.0v 1999.495n 0.0v 1999.505n 0.0v 2009.495n 0.0v 2009.505n 0.0v 2019.495n 0.0v 2019.505n 0.0v 2029.495n 0.0v 2029.505n 0.0v 2039.495n 0.0v 2039.505n 0.0v 2049.495n 0.0v 2049.505n 0.0v )
* (time, data): [(0, 0), (10, 1), (20, 1), (30, 1), (40, 1), (50, 0), (60, 1), (70, 0), (80, 0), (90, 0), (100, 0), (110, 0), (120, 0), (130, 0), (140, 0), (150, 0), (160, 1), (170, 1), (180, 1), (190, 1), (200, 1), (210, 1), (220, 1), (230, 1), (240, 1), (250, 1), (260, 1), (270, 1), (280, 1), (290, 1), (300, 1), (310, 1), (320, 1), (330, 0), (340, 0), (350, 0), (360, 1), (370, 1), (380, 1), (390, 1), (400, 1), (410, 1), (420, 1), (430, 1), (440, 0), (450, 0), (460, 0), (470, 0), (480, 0), (490, 0), (500, 0), (510, 0), (520, 0), (530, 0), (540, 1), (550, 1), (560, 1), (570, 1), (580, 1), (590, 1), (600, 1), (610, 0), (620, 0), (630, 0), (640, 0), (650, 0), (660, 0), (670, 0), (680, 0), (690, 1), (700, 1), (710, 1), (720, 1), (730, 1), (740, 1), (750, 0), (760, 0), (770, 0), (780, 0), (790, 0), (800, 0), (810, 0), (820, 0), (830, 0), (840, 0), (850, 0), (860, 0), (870, 0), (880, 0), (890, 0), (900, 0), (910, 0), (920, 0), (930, 0), (940, 0), (950, 0), (960, 0), (970, 0), (980, 0), (990, 0), (1000, 0), (1010, 0), (1020, 0), (1030, 0), (1040, 0), (1050, 0), (1060, 0), (1070, 0), (1080, 1), (1090, 1), (1100, 1), (1110, 1), (1120, 1), (1130, 1), (1140, 1), (1150, 1), (1160, 1), (1170, 1), (1180, 1), (1190, 1), (1200, 1), (1210, 1), (1220, 1), (1230, 1), (1240, 1), (1250, 0), (1260, 0), (1270, 0), (1280, 1), (1290, 1), (1300, 1), (1310, 1), (1320, 1), (1330, 1), (1340, 0), (1350, 0), (1360, 0), (1370, 0), (1380, 0), (1390, 0), (1400, 0), (1410, 0), (1420, 0), (1430, 0), (1440, 0), (1450, 0), (1460, 0), (1470, 0), (1480, 0), (1490, 0), (1500, 0), (1510, 0), (1520, 0), (1530, 0), (1540, 0), (1550, 0), (1560, 0), (1570, 0), (1580, 0), (1590, 0), (1600, 0), (1610, 0), (1620, 0), (1630, 0), (1640, 0), (1650, 0), (1660, 1), (1670, 1), (1680, 0), (1690, 0), (1700, 0), (1710, 0), (1720, 0), (1730, 0), (1740, 0), (1750, 0), (1760, 0), (1770, 1), (1780, 1), (1790, 0), (1800, 0), (1810, 0), (1820, 0), (1830, 0), (1840, 0), (1850, 0), (1860, 0), (1870, 0), (1880, 0), (1890, 0), (1900, 0), (1910, 0), (1920, 0), (1930, 0), (1940, 0), (1950, 0), (1960, 0), (1970, 0), (1980, 0), (1990, 0), (2000, 0), (2010, 0), (2020, 1), (2030, 0), (2040, 0), (2050, 0)]
Vdin1_23  din1_23  0 PWL (0n 0.0v 9.495n 0.0v 9.505n 3.3v 19.495n 3.3v 19.505n 3.3v 29.495n 3.3v 29.505n 3.3v 39.495n 3.3v 39.505n 3.3v 49.495n 3.3v 49.505n 0.0v 59.495n 0.0v 59.505n 3.3v 69.495n 3.3v 69.505n 0.0v 79.495n 0.0v 79.505n 0.0v 89.495n 0.0v 89.505n 0.0v 99.495n 0.0v 99.505n 0.0v 109.495n 0.0v 109.505n 0.0v 119.495n 0.0v 119.505n 0.0v 129.495n 0.0v 129.505n 0.0v 139.495n 0.0v 139.505n 0.0v 149.495n 0.0v 149.505n 0.0v 159.495n 0.0v 159.505n 3.3v 169.495n 3.3v 169.505n 3.3v 179.495n 3.3v 179.505n 3.3v 189.495n 3.3v 189.505n 3.3v 199.495n 3.3v 199.505n 3.3v 209.495n 3.3v 209.505n 3.3v 219.495n 3.3v 219.505n 3.3v 229.495n 3.3v 229.505n 3.3v 239.495n 3.3v 239.505n 3.3v 249.495n 3.3v 249.505n 3.3v 259.495n 3.3v 259.505n 3.3v 269.495n 3.3v 269.505n 3.3v 279.495n 3.3v 279.505n 3.3v 289.495n 3.3v 289.505n 3.3v 299.495n 3.3v 299.505n 3.3v 309.495n 3.3v 309.505n 3.3v 319.495n 3.3v 319.505n 3.3v 329.495n 3.3v 329.505n 0.0v 339.495n 0.0v 339.505n 0.0v 349.495n 0.0v 349.505n 0.0v 359.495n 0.0v 359.505n 3.3v 369.495n 3.3v 369.505n 3.3v 379.495n 3.3v 379.505n 3.3v 389.495n 3.3v 389.505n 3.3v 399.495n 3.3v 399.505n 3.3v 409.495n 3.3v 409.505n 3.3v 419.495n 3.3v 419.505n 3.3v 429.495n 3.3v 429.505n 3.3v 439.495n 3.3v 439.505n 0.0v 449.495n 0.0v 449.505n 0.0v 459.495n 0.0v 459.505n 0.0v 469.495n 0.0v 469.505n 0.0v 479.495n 0.0v 479.505n 0.0v 489.495n 0.0v 489.505n 0.0v 499.495n 0.0v 499.505n 0.0v 509.495n 0.0v 509.505n 0.0v 519.495n 0.0v 519.505n 0.0v 529.495n 0.0v 529.505n 0.0v 539.495n 0.0v 539.505n 3.3v 549.495n 3.3v 549.505n 3.3v 559.495n 3.3v 559.505n 3.3v 569.495n 3.3v 569.505n 3.3v 579.495n 3.3v 579.505n 3.3v 589.495n 3.3v 589.505n 3.3v 599.495n 3.3v 599.505n 3.3v 609.495n 3.3v 609.505n 0.0v 619.495n 0.0v 619.505n 0.0v 629.495n 0.0v 629.505n 0.0v 639.495n 0.0v 639.505n 0.0v 649.495n 0.0v 649.505n 0.0v 659.495n 0.0v 659.505n 0.0v 669.495n 0.0v 669.505n 0.0v 679.495n 0.0v 679.505n 0.0v 689.495n 0.0v 689.505n 3.3v 699.495n 3.3v 699.505n 3.3v 709.495n 3.3v 709.505n 3.3v 719.495n 3.3v 719.505n 3.3v 729.495n 3.3v 729.505n 3.3v 739.495n 3.3v 739.505n 3.3v 749.495n 3.3v 749.505n 0.0v 759.495n 0.0v 759.505n 0.0v 769.495n 0.0v 769.505n 0.0v 779.495n 0.0v 779.505n 0.0v 789.495n 0.0v 789.505n 0.0v 799.495n 0.0v 799.505n 0.0v 809.495n 0.0v 809.505n 0.0v 819.495n 0.0v 819.505n 0.0v 829.495n 0.0v 829.505n 0.0v 839.495n 0.0v 839.505n 0.0v 849.495n 0.0v 849.505n 0.0v 859.495n 0.0v 859.505n 0.0v 869.495n 0.0v 869.505n 0.0v 879.495n 0.0v 879.505n 0.0v 889.495n 0.0v 889.505n 0.0v 899.495n 0.0v 899.505n 0.0v 909.495n 0.0v 909.505n 0.0v 919.495n 0.0v 919.505n 0.0v 929.495n 0.0v 929.505n 0.0v 939.495n 0.0v 939.505n 0.0v 949.495n 0.0v 949.505n 0.0v 959.495n 0.0v 959.505n 0.0v 969.495n 0.0v 969.505n 0.0v 979.495n 0.0v 979.505n 0.0v 989.495n 0.0v 989.505n 0.0v 999.495n 0.0v 999.505n 0.0v 1009.495n 0.0v 1009.505n 0.0v 1019.495n 0.0v 1019.505n 0.0v 1029.495n 0.0v 1029.505n 0.0v 1039.495n 0.0v 1039.505n 0.0v 1049.495n 0.0v 1049.505n 0.0v 1059.495n 0.0v 1059.505n 0.0v 1069.495n 0.0v 1069.505n 0.0v 1079.495n 0.0v 1079.505n 3.3v 1089.495n 3.3v 1089.505n 3.3v 1099.495n 3.3v 1099.505n 3.3v 1109.495n 3.3v 1109.505n 3.3v 1119.495n 3.3v 1119.505n 3.3v 1129.495n 3.3v 1129.505n 3.3v 1139.495n 3.3v 1139.505n 3.3v 1149.495n 3.3v 1149.505n 3.3v 1159.495n 3.3v 1159.505n 3.3v 1169.495n 3.3v 1169.505n 3.3v 1179.495n 3.3v 1179.505n 3.3v 1189.495n 3.3v 1189.505n 3.3v 1199.495n 3.3v 1199.505n 3.3v 1209.495n 3.3v 1209.505n 3.3v 1219.495n 3.3v 1219.505n 3.3v 1229.495n 3.3v 1229.505n 3.3v 1239.495n 3.3v 1239.505n 3.3v 1249.495n 3.3v 1249.505n 0.0v 1259.495n 0.0v 1259.505n 0.0v 1269.495n 0.0v 1269.505n 0.0v 1279.495n 0.0v 1279.505n 3.3v 1289.495n 3.3v 1289.505n 3.3v 1299.495n 3.3v 1299.505n 3.3v 1309.495n 3.3v 1309.505n 3.3v 1319.495n 3.3v 1319.505n 3.3v 1329.495n 3.3v 1329.505n 3.3v 1339.495n 3.3v 1339.505n 0.0v 1349.495n 0.0v 1349.505n 0.0v 1359.495n 0.0v 1359.505n 0.0v 1369.495n 0.0v 1369.505n 0.0v 1379.495n 0.0v 1379.505n 0.0v 1389.495n 0.0v 1389.505n 0.0v 1399.495n 0.0v 1399.505n 0.0v 1409.495n 0.0v 1409.505n 0.0v 1419.495n 0.0v 1419.505n 0.0v 1429.495n 0.0v 1429.505n 0.0v 1439.495n 0.0v 1439.505n 0.0v 1449.495n 0.0v 1449.505n 0.0v 1459.495n 0.0v 1459.505n 0.0v 1469.495n 0.0v 1469.505n 0.0v 1479.495n 0.0v 1479.505n 0.0v 1489.495n 0.0v 1489.505n 0.0v 1499.495n 0.0v 1499.505n 0.0v 1509.495n 0.0v 1509.505n 0.0v 1519.495n 0.0v 1519.505n 0.0v 1529.495n 0.0v 1529.505n 0.0v 1539.495n 0.0v 1539.505n 0.0v 1549.495n 0.0v 1549.505n 0.0v 1559.495n 0.0v 1559.505n 0.0v 1569.495n 0.0v 1569.505n 0.0v 1579.495n 0.0v 1579.505n 0.0v 1589.495n 0.0v 1589.505n 0.0v 1599.495n 0.0v 1599.505n 0.0v 1609.495n 0.0v 1609.505n 0.0v 1619.495n 0.0v 1619.505n 0.0v 1629.495n 0.0v 1629.505n 0.0v 1639.495n 0.0v 1639.505n 0.0v 1649.495n 0.0v 1649.505n 0.0v 1659.495n 0.0v 1659.505n 3.3v 1669.495n 3.3v 1669.505n 3.3v 1679.495n 3.3v 1679.505n 0.0v 1689.495n 0.0v 1689.505n 0.0v 1699.495n 0.0v 1699.505n 0.0v 1709.495n 0.0v 1709.505n 0.0v 1719.495n 0.0v 1719.505n 0.0v 1729.495n 0.0v 1729.505n 0.0v 1739.495n 0.0v 1739.505n 0.0v 1749.495n 0.0v 1749.505n 0.0v 1759.495n 0.0v 1759.505n 0.0v 1769.495n 0.0v 1769.505n 3.3v 1779.495n 3.3v 1779.505n 3.3v 1789.495n 3.3v 1789.505n 0.0v 1799.495n 0.0v 1799.505n 0.0v 1809.495n 0.0v 1809.505n 0.0v 1819.495n 0.0v 1819.505n 0.0v 1829.495n 0.0v 1829.505n 0.0v 1839.495n 0.0v 1839.505n 0.0v 1849.495n 0.0v 1849.505n 0.0v 1859.495n 0.0v 1859.505n 0.0v 1869.495n 0.0v 1869.505n 0.0v 1879.495n 0.0v 1879.505n 0.0v 1889.495n 0.0v 1889.505n 0.0v 1899.495n 0.0v 1899.505n 0.0v 1909.495n 0.0v 1909.505n 0.0v 1919.495n 0.0v 1919.505n 0.0v 1929.495n 0.0v 1929.505n 0.0v 1939.495n 0.0v 1939.505n 0.0v 1949.495n 0.0v 1949.505n 0.0v 1959.495n 0.0v 1959.505n 0.0v 1969.495n 0.0v 1969.505n 0.0v 1979.495n 0.0v 1979.505n 0.0v 1989.495n 0.0v 1989.505n 0.0v 1999.495n 0.0v 1999.505n 0.0v 2009.495n 0.0v 2009.505n 0.0v 2019.495n 0.0v 2019.505n 3.3v 2029.495n 3.3v 2029.505n 0.0v 2039.495n 0.0v 2039.505n 0.0v 2049.495n 0.0v 2049.505n 0.0v )
* (time, data): [(0, 0), (10, 0), (20, 0), (30, 0), (40, 0), (50, 1), (60, 1), (70, 0), (80, 0), (90, 0), (100, 0), (110, 0), (120, 0), (130, 0), (140, 0), (150, 1), (160, 1), (170, 1), (180, 1), (190, 1), (200, 1), (210, 1), (220, 1), (230, 1), (240, 1), (250, 1), (260, 1), (270, 1), (280, 1), (290, 1), (300, 1), (310, 1), (320, 1), (330, 1), (340, 1), (350, 1), (360, 1), (370, 1), (380, 1), (390, 1), (400, 1), (410, 1), (420, 1), (430, 1), (440, 1), (450, 1), (460, 1), (470, 1), (480, 1), (490, 1), (500, 1), (510, 1), (520, 1), (530, 1), (540, 1), (550, 1), (560, 1), (570, 1), (580, 1), (590, 1), (600, 1), (610, 0), (620, 0), (630, 0), (640, 0), (650, 0), (660, 0), (670, 0), (680, 0), (690, 1), (700, 1), (710, 1), (720, 1), (730, 1), (740, 0), (750, 0), (760, 0), (770, 1), (780, 1), (790, 1), (800, 1), (810, 1), (820, 1), (830, 1), (840, 1), (850, 1), (860, 1), (870, 1), (880, 1), (890, 1), (900, 1), (910, 1), (920, 1), (930, 1), (940, 1), (950, 1), (960, 0), (970, 0), (980, 0), (990, 0), (1000, 0), (1010, 0), (1020, 0), (1030, 0), (1040, 0), (1050, 0), (1060, 0), (1070, 0), (1080, 0), (1090, 0), (1100, 0), (1110, 0), (1120, 0), (1130, 0), (1140, 0), (1150, 0), (1160, 0), (1170, 0), (1180, 0), (1190, 0), (1200, 0), (1210, 0), (1220, 0), (1230, 0), (1240, 0), (1250, 0), (1260, 0), (1270, 0), (1280, 1), (1290, 1), (1300, 1), (1310, 1), (1320, 0), (1330, 0), (1340, 0), (1350, 0), (1360, 1), (1370, 1), (1380, 1), (1390, 0), (1400, 0), (1410, 0), (1420, 0), (1430, 0), (1440, 1), (1450, 1), (1460, 1), (1470, 0), (1480, 1), (1490, 1), (1500, 1), (1510, 1), (1520, 1), (1530, 1), (1540, 1), (1550, 1), (1560, 1), (1570, 1), (1580, 1), (1590, 1), (1600, 1), (1610, 0), (1620, 0), (1630, 0), (1640, 0), (1650, 0), (1660, 0), (1670, 0), (1680, 1), (1690, 1), (1700, 1), (1710, 1), (1720, 1), (1730, 1), (1740, 1), (1750, 1), (1760, 1), (1770, 0), (1780, 0), (1790, 0), (1800, 0), (1810, 0), (1820, 0), (1830, 0), (1840, 0), (1850, 0), (1860, 0), (1870, 0), (1880, 0), (1890, 0), (1900, 0), (1910, 0), (1920, 0), (1930, 0), (1940, 0), (1950, 0), (1960, 0), (1970, 0), (1980, 0), (1990, 0), (2000, 0), (2010, 0), (2020, 1), (2030, 1), (2040, 1), (2050, 1)]
Vdin1_24  din1_24  0 PWL (0n 0.0v 9.495n 0.0v 9.505n 0.0v 19.495n 0.0v 19.505n 0.0v 29.495n 0.0v 29.505n 0.0v 39.495n 0.0v 39.505n 0.0v 49.495n 0.0v 49.505n 3.3v 59.495n 3.3v 59.505n 3.3v 69.495n 3.3v 69.505n 0.0v 79.495n 0.0v 79.505n 0.0v 89.495n 0.0v 89.505n 0.0v 99.495n 0.0v 99.505n 0.0v 109.495n 0.0v 109.505n 0.0v 119.495n 0.0v 119.505n 0.0v 129.495n 0.0v 129.505n 0.0v 139.495n 0.0v 139.505n 0.0v 149.495n 0.0v 149.505n 3.3v 159.495n 3.3v 159.505n 3.3v 169.495n 3.3v 169.505n 3.3v 179.495n 3.3v 179.505n 3.3v 189.495n 3.3v 189.505n 3.3v 199.495n 3.3v 199.505n 3.3v 209.495n 3.3v 209.505n 3.3v 219.495n 3.3v 219.505n 3.3v 229.495n 3.3v 229.505n 3.3v 239.495n 3.3v 239.505n 3.3v 249.495n 3.3v 249.505n 3.3v 259.495n 3.3v 259.505n 3.3v 269.495n 3.3v 269.505n 3.3v 279.495n 3.3v 279.505n 3.3v 289.495n 3.3v 289.505n 3.3v 299.495n 3.3v 299.505n 3.3v 309.495n 3.3v 309.505n 3.3v 319.495n 3.3v 319.505n 3.3v 329.495n 3.3v 329.505n 3.3v 339.495n 3.3v 339.505n 3.3v 349.495n 3.3v 349.505n 3.3v 359.495n 3.3v 359.505n 3.3v 369.495n 3.3v 369.505n 3.3v 379.495n 3.3v 379.505n 3.3v 389.495n 3.3v 389.505n 3.3v 399.495n 3.3v 399.505n 3.3v 409.495n 3.3v 409.505n 3.3v 419.495n 3.3v 419.505n 3.3v 429.495n 3.3v 429.505n 3.3v 439.495n 3.3v 439.505n 3.3v 449.495n 3.3v 449.505n 3.3v 459.495n 3.3v 459.505n 3.3v 469.495n 3.3v 469.505n 3.3v 479.495n 3.3v 479.505n 3.3v 489.495n 3.3v 489.505n 3.3v 499.495n 3.3v 499.505n 3.3v 509.495n 3.3v 509.505n 3.3v 519.495n 3.3v 519.505n 3.3v 529.495n 3.3v 529.505n 3.3v 539.495n 3.3v 539.505n 3.3v 549.495n 3.3v 549.505n 3.3v 559.495n 3.3v 559.505n 3.3v 569.495n 3.3v 569.505n 3.3v 579.495n 3.3v 579.505n 3.3v 589.495n 3.3v 589.505n 3.3v 599.495n 3.3v 599.505n 3.3v 609.495n 3.3v 609.505n 0.0v 619.495n 0.0v 619.505n 0.0v 629.495n 0.0v 629.505n 0.0v 639.495n 0.0v 639.505n 0.0v 649.495n 0.0v 649.505n 0.0v 659.495n 0.0v 659.505n 0.0v 669.495n 0.0v 669.505n 0.0v 679.495n 0.0v 679.505n 0.0v 689.495n 0.0v 689.505n 3.3v 699.495n 3.3v 699.505n 3.3v 709.495n 3.3v 709.505n 3.3v 719.495n 3.3v 719.505n 3.3v 729.495n 3.3v 729.505n 3.3v 739.495n 3.3v 739.505n 0.0v 749.495n 0.0v 749.505n 0.0v 759.495n 0.0v 759.505n 0.0v 769.495n 0.0v 769.505n 3.3v 779.495n 3.3v 779.505n 3.3v 789.495n 3.3v 789.505n 3.3v 799.495n 3.3v 799.505n 3.3v 809.495n 3.3v 809.505n 3.3v 819.495n 3.3v 819.505n 3.3v 829.495n 3.3v 829.505n 3.3v 839.495n 3.3v 839.505n 3.3v 849.495n 3.3v 849.505n 3.3v 859.495n 3.3v 859.505n 3.3v 869.495n 3.3v 869.505n 3.3v 879.495n 3.3v 879.505n 3.3v 889.495n 3.3v 889.505n 3.3v 899.495n 3.3v 899.505n 3.3v 909.495n 3.3v 909.505n 3.3v 919.495n 3.3v 919.505n 3.3v 929.495n 3.3v 929.505n 3.3v 939.495n 3.3v 939.505n 3.3v 949.495n 3.3v 949.505n 3.3v 959.495n 3.3v 959.505n 0.0v 969.495n 0.0v 969.505n 0.0v 979.495n 0.0v 979.505n 0.0v 989.495n 0.0v 989.505n 0.0v 999.495n 0.0v 999.505n 0.0v 1009.495n 0.0v 1009.505n 0.0v 1019.495n 0.0v 1019.505n 0.0v 1029.495n 0.0v 1029.505n 0.0v 1039.495n 0.0v 1039.505n 0.0v 1049.495n 0.0v 1049.505n 0.0v 1059.495n 0.0v 1059.505n 0.0v 1069.495n 0.0v 1069.505n 0.0v 1079.495n 0.0v 1079.505n 0.0v 1089.495n 0.0v 1089.505n 0.0v 1099.495n 0.0v 1099.505n 0.0v 1109.495n 0.0v 1109.505n 0.0v 1119.495n 0.0v 1119.505n 0.0v 1129.495n 0.0v 1129.505n 0.0v 1139.495n 0.0v 1139.505n 0.0v 1149.495n 0.0v 1149.505n 0.0v 1159.495n 0.0v 1159.505n 0.0v 1169.495n 0.0v 1169.505n 0.0v 1179.495n 0.0v 1179.505n 0.0v 1189.495n 0.0v 1189.505n 0.0v 1199.495n 0.0v 1199.505n 0.0v 1209.495n 0.0v 1209.505n 0.0v 1219.495n 0.0v 1219.505n 0.0v 1229.495n 0.0v 1229.505n 0.0v 1239.495n 0.0v 1239.505n 0.0v 1249.495n 0.0v 1249.505n 0.0v 1259.495n 0.0v 1259.505n 0.0v 1269.495n 0.0v 1269.505n 0.0v 1279.495n 0.0v 1279.505n 3.3v 1289.495n 3.3v 1289.505n 3.3v 1299.495n 3.3v 1299.505n 3.3v 1309.495n 3.3v 1309.505n 3.3v 1319.495n 3.3v 1319.505n 0.0v 1329.495n 0.0v 1329.505n 0.0v 1339.495n 0.0v 1339.505n 0.0v 1349.495n 0.0v 1349.505n 0.0v 1359.495n 0.0v 1359.505n 3.3v 1369.495n 3.3v 1369.505n 3.3v 1379.495n 3.3v 1379.505n 3.3v 1389.495n 3.3v 1389.505n 0.0v 1399.495n 0.0v 1399.505n 0.0v 1409.495n 0.0v 1409.505n 0.0v 1419.495n 0.0v 1419.505n 0.0v 1429.495n 0.0v 1429.505n 0.0v 1439.495n 0.0v 1439.505n 3.3v 1449.495n 3.3v 1449.505n 3.3v 1459.495n 3.3v 1459.505n 3.3v 1469.495n 3.3v 1469.505n 0.0v 1479.495n 0.0v 1479.505n 3.3v 1489.495n 3.3v 1489.505n 3.3v 1499.495n 3.3v 1499.505n 3.3v 1509.495n 3.3v 1509.505n 3.3v 1519.495n 3.3v 1519.505n 3.3v 1529.495n 3.3v 1529.505n 3.3v 1539.495n 3.3v 1539.505n 3.3v 1549.495n 3.3v 1549.505n 3.3v 1559.495n 3.3v 1559.505n 3.3v 1569.495n 3.3v 1569.505n 3.3v 1579.495n 3.3v 1579.505n 3.3v 1589.495n 3.3v 1589.505n 3.3v 1599.495n 3.3v 1599.505n 3.3v 1609.495n 3.3v 1609.505n 0.0v 1619.495n 0.0v 1619.505n 0.0v 1629.495n 0.0v 1629.505n 0.0v 1639.495n 0.0v 1639.505n 0.0v 1649.495n 0.0v 1649.505n 0.0v 1659.495n 0.0v 1659.505n 0.0v 1669.495n 0.0v 1669.505n 0.0v 1679.495n 0.0v 1679.505n 3.3v 1689.495n 3.3v 1689.505n 3.3v 1699.495n 3.3v 1699.505n 3.3v 1709.495n 3.3v 1709.505n 3.3v 1719.495n 3.3v 1719.505n 3.3v 1729.495n 3.3v 1729.505n 3.3v 1739.495n 3.3v 1739.505n 3.3v 1749.495n 3.3v 1749.505n 3.3v 1759.495n 3.3v 1759.505n 3.3v 1769.495n 3.3v 1769.505n 0.0v 1779.495n 0.0v 1779.505n 0.0v 1789.495n 0.0v 1789.505n 0.0v 1799.495n 0.0v 1799.505n 0.0v 1809.495n 0.0v 1809.505n 0.0v 1819.495n 0.0v 1819.505n 0.0v 1829.495n 0.0v 1829.505n 0.0v 1839.495n 0.0v 1839.505n 0.0v 1849.495n 0.0v 1849.505n 0.0v 1859.495n 0.0v 1859.505n 0.0v 1869.495n 0.0v 1869.505n 0.0v 1879.495n 0.0v 1879.505n 0.0v 1889.495n 0.0v 1889.505n 0.0v 1899.495n 0.0v 1899.505n 0.0v 1909.495n 0.0v 1909.505n 0.0v 1919.495n 0.0v 1919.505n 0.0v 1929.495n 0.0v 1929.505n 0.0v 1939.495n 0.0v 1939.505n 0.0v 1949.495n 0.0v 1949.505n 0.0v 1959.495n 0.0v 1959.505n 0.0v 1969.495n 0.0v 1969.505n 0.0v 1979.495n 0.0v 1979.505n 0.0v 1989.495n 0.0v 1989.505n 0.0v 1999.495n 0.0v 1999.505n 0.0v 2009.495n 0.0v 2009.505n 0.0v 2019.495n 0.0v 2019.505n 3.3v 2029.495n 3.3v 2029.505n 3.3v 2039.495n 3.3v 2039.505n 3.3v 2049.495n 3.3v 2049.505n 3.3v )
* (time, data): [(0, 0), (10, 0), (20, 1), (30, 0), (40, 0), (50, 1), (60, 0), (70, 1), (80, 1), (90, 1), (100, 1), (110, 1), (120, 1), (130, 1), (140, 1), (150, 1), (160, 1), (170, 1), (180, 1), (190, 1), (200, 1), (210, 1), (220, 1), (230, 1), (240, 1), (250, 1), (260, 1), (270, 1), (280, 1), (290, 1), (300, 1), (310, 1), (320, 1), (330, 0), (340, 0), (350, 0), (360, 0), (370, 0), (380, 0), (390, 0), (400, 0), (410, 0), (420, 0), (430, 0), (440, 0), (450, 0), (460, 0), (470, 0), (480, 0), (490, 0), (500, 0), (510, 0), (520, 0), (530, 0), (540, 0), (550, 0), (560, 0), (570, 0), (580, 0), (590, 0), (600, 0), (610, 1), (620, 1), (630, 1), (640, 1), (650, 1), (660, 1), (670, 1), (680, 1), (690, 0), (700, 0), (710, 0), (720, 0), (730, 0), (740, 0), (750, 1), (760, 1), (770, 1), (780, 1), (790, 1), (800, 0), (810, 0), (820, 0), (830, 0), (840, 1), (850, 1), (860, 1), (870, 1), (880, 1), (890, 1), (900, 1), (910, 0), (920, 0), (930, 0), (940, 0), (950, 0), (960, 0), (970, 0), (980, 0), (990, 0), (1000, 0), (1010, 0), (1020, 0), (1030, 0), (1040, 0), (1050, 0), (1060, 0), (1070, 0), (1080, 1), (1090, 1), (1100, 1), (1110, 1), (1120, 1), (1130, 1), (1140, 1), (1150, 1), (1160, 1), (1170, 1), (1180, 1), (1190, 1), (1200, 1), (1210, 1), (1220, 1), (1230, 1), (1240, 0), (1250, 1), (1260, 1), (1270, 1), (1280, 1), (1290, 1), (1300, 1), (1310, 1), (1320, 1), (1330, 1), (1340, 0), (1350, 0), (1360, 1), (1370, 1), (1380, 1), (1390, 1), (1400, 1), (1410, 1), (1420, 1), (1430, 0), (1440, 1), (1450, 1), (1460, 1), (1470, 0), (1480, 0), (1490, 0), (1500, 0), (1510, 0), (1520, 0), (1530, 0), (1540, 0), (1550, 0), (1560, 0), (1570, 0), (1580, 0), (1590, 0), (1600, 0), (1610, 0), (1620, 0), (1630, 1), (1640, 1), (1650, 1), (1660, 0), (1670, 0), (1680, 1), (1690, 1), (1700, 1), (1710, 1), (1720, 1), (1730, 1), (1740, 1), (1750, 1), (1760, 1), (1770, 1), (1780, 1), (1790, 1), (1800, 1), (1810, 1), (1820, 1), (1830, 1), (1840, 1), (1850, 1), (1860, 1), (1870, 1), (1880, 1), (1890, 1), (1900, 1), (1910, 1), (1920, 1), (1930, 1), (1940, 1), (1950, 1), (1960, 1), (1970, 1), (1980, 0), (1990, 0), (2000, 0), (2010, 0), (2020, 0), (2030, 1), (2040, 1), (2050, 1)]
Vdin1_25  din1_25  0 PWL (0n 0.0v 9.495n 0.0v 9.505n 0.0v 19.495n 0.0v 19.505n 3.3v 29.495n 3.3v 29.505n 0.0v 39.495n 0.0v 39.505n 0.0v 49.495n 0.0v 49.505n 3.3v 59.495n 3.3v 59.505n 0.0v 69.495n 0.0v 69.505n 3.3v 79.495n 3.3v 79.505n 3.3v 89.495n 3.3v 89.505n 3.3v 99.495n 3.3v 99.505n 3.3v 109.495n 3.3v 109.505n 3.3v 119.495n 3.3v 119.505n 3.3v 129.495n 3.3v 129.505n 3.3v 139.495n 3.3v 139.505n 3.3v 149.495n 3.3v 149.505n 3.3v 159.495n 3.3v 159.505n 3.3v 169.495n 3.3v 169.505n 3.3v 179.495n 3.3v 179.505n 3.3v 189.495n 3.3v 189.505n 3.3v 199.495n 3.3v 199.505n 3.3v 209.495n 3.3v 209.505n 3.3v 219.495n 3.3v 219.505n 3.3v 229.495n 3.3v 229.505n 3.3v 239.495n 3.3v 239.505n 3.3v 249.495n 3.3v 249.505n 3.3v 259.495n 3.3v 259.505n 3.3v 269.495n 3.3v 269.505n 3.3v 279.495n 3.3v 279.505n 3.3v 289.495n 3.3v 289.505n 3.3v 299.495n 3.3v 299.505n 3.3v 309.495n 3.3v 309.505n 3.3v 319.495n 3.3v 319.505n 3.3v 329.495n 3.3v 329.505n 0.0v 339.495n 0.0v 339.505n 0.0v 349.495n 0.0v 349.505n 0.0v 359.495n 0.0v 359.505n 0.0v 369.495n 0.0v 369.505n 0.0v 379.495n 0.0v 379.505n 0.0v 389.495n 0.0v 389.505n 0.0v 399.495n 0.0v 399.505n 0.0v 409.495n 0.0v 409.505n 0.0v 419.495n 0.0v 419.505n 0.0v 429.495n 0.0v 429.505n 0.0v 439.495n 0.0v 439.505n 0.0v 449.495n 0.0v 449.505n 0.0v 459.495n 0.0v 459.505n 0.0v 469.495n 0.0v 469.505n 0.0v 479.495n 0.0v 479.505n 0.0v 489.495n 0.0v 489.505n 0.0v 499.495n 0.0v 499.505n 0.0v 509.495n 0.0v 509.505n 0.0v 519.495n 0.0v 519.505n 0.0v 529.495n 0.0v 529.505n 0.0v 539.495n 0.0v 539.505n 0.0v 549.495n 0.0v 549.505n 0.0v 559.495n 0.0v 559.505n 0.0v 569.495n 0.0v 569.505n 0.0v 579.495n 0.0v 579.505n 0.0v 589.495n 0.0v 589.505n 0.0v 599.495n 0.0v 599.505n 0.0v 609.495n 0.0v 609.505n 3.3v 619.495n 3.3v 619.505n 3.3v 629.495n 3.3v 629.505n 3.3v 639.495n 3.3v 639.505n 3.3v 649.495n 3.3v 649.505n 3.3v 659.495n 3.3v 659.505n 3.3v 669.495n 3.3v 669.505n 3.3v 679.495n 3.3v 679.505n 3.3v 689.495n 3.3v 689.505n 0.0v 699.495n 0.0v 699.505n 0.0v 709.495n 0.0v 709.505n 0.0v 719.495n 0.0v 719.505n 0.0v 729.495n 0.0v 729.505n 0.0v 739.495n 0.0v 739.505n 0.0v 749.495n 0.0v 749.505n 3.3v 759.495n 3.3v 759.505n 3.3v 769.495n 3.3v 769.505n 3.3v 779.495n 3.3v 779.505n 3.3v 789.495n 3.3v 789.505n 3.3v 799.495n 3.3v 799.505n 0.0v 809.495n 0.0v 809.505n 0.0v 819.495n 0.0v 819.505n 0.0v 829.495n 0.0v 829.505n 0.0v 839.495n 0.0v 839.505n 3.3v 849.495n 3.3v 849.505n 3.3v 859.495n 3.3v 859.505n 3.3v 869.495n 3.3v 869.505n 3.3v 879.495n 3.3v 879.505n 3.3v 889.495n 3.3v 889.505n 3.3v 899.495n 3.3v 899.505n 3.3v 909.495n 3.3v 909.505n 0.0v 919.495n 0.0v 919.505n 0.0v 929.495n 0.0v 929.505n 0.0v 939.495n 0.0v 939.505n 0.0v 949.495n 0.0v 949.505n 0.0v 959.495n 0.0v 959.505n 0.0v 969.495n 0.0v 969.505n 0.0v 979.495n 0.0v 979.505n 0.0v 989.495n 0.0v 989.505n 0.0v 999.495n 0.0v 999.505n 0.0v 1009.495n 0.0v 1009.505n 0.0v 1019.495n 0.0v 1019.505n 0.0v 1029.495n 0.0v 1029.505n 0.0v 1039.495n 0.0v 1039.505n 0.0v 1049.495n 0.0v 1049.505n 0.0v 1059.495n 0.0v 1059.505n 0.0v 1069.495n 0.0v 1069.505n 0.0v 1079.495n 0.0v 1079.505n 3.3v 1089.495n 3.3v 1089.505n 3.3v 1099.495n 3.3v 1099.505n 3.3v 1109.495n 3.3v 1109.505n 3.3v 1119.495n 3.3v 1119.505n 3.3v 1129.495n 3.3v 1129.505n 3.3v 1139.495n 3.3v 1139.505n 3.3v 1149.495n 3.3v 1149.505n 3.3v 1159.495n 3.3v 1159.505n 3.3v 1169.495n 3.3v 1169.505n 3.3v 1179.495n 3.3v 1179.505n 3.3v 1189.495n 3.3v 1189.505n 3.3v 1199.495n 3.3v 1199.505n 3.3v 1209.495n 3.3v 1209.505n 3.3v 1219.495n 3.3v 1219.505n 3.3v 1229.495n 3.3v 1229.505n 3.3v 1239.495n 3.3v 1239.505n 0.0v 1249.495n 0.0v 1249.505n 3.3v 1259.495n 3.3v 1259.505n 3.3v 1269.495n 3.3v 1269.505n 3.3v 1279.495n 3.3v 1279.505n 3.3v 1289.495n 3.3v 1289.505n 3.3v 1299.495n 3.3v 1299.505n 3.3v 1309.495n 3.3v 1309.505n 3.3v 1319.495n 3.3v 1319.505n 3.3v 1329.495n 3.3v 1329.505n 3.3v 1339.495n 3.3v 1339.505n 0.0v 1349.495n 0.0v 1349.505n 0.0v 1359.495n 0.0v 1359.505n 3.3v 1369.495n 3.3v 1369.505n 3.3v 1379.495n 3.3v 1379.505n 3.3v 1389.495n 3.3v 1389.505n 3.3v 1399.495n 3.3v 1399.505n 3.3v 1409.495n 3.3v 1409.505n 3.3v 1419.495n 3.3v 1419.505n 3.3v 1429.495n 3.3v 1429.505n 0.0v 1439.495n 0.0v 1439.505n 3.3v 1449.495n 3.3v 1449.505n 3.3v 1459.495n 3.3v 1459.505n 3.3v 1469.495n 3.3v 1469.505n 0.0v 1479.495n 0.0v 1479.505n 0.0v 1489.495n 0.0v 1489.505n 0.0v 1499.495n 0.0v 1499.505n 0.0v 1509.495n 0.0v 1509.505n 0.0v 1519.495n 0.0v 1519.505n 0.0v 1529.495n 0.0v 1529.505n 0.0v 1539.495n 0.0v 1539.505n 0.0v 1549.495n 0.0v 1549.505n 0.0v 1559.495n 0.0v 1559.505n 0.0v 1569.495n 0.0v 1569.505n 0.0v 1579.495n 0.0v 1579.505n 0.0v 1589.495n 0.0v 1589.505n 0.0v 1599.495n 0.0v 1599.505n 0.0v 1609.495n 0.0v 1609.505n 0.0v 1619.495n 0.0v 1619.505n 0.0v 1629.495n 0.0v 1629.505n 3.3v 1639.495n 3.3v 1639.505n 3.3v 1649.495n 3.3v 1649.505n 3.3v 1659.495n 3.3v 1659.505n 0.0v 1669.495n 0.0v 1669.505n 0.0v 1679.495n 0.0v 1679.505n 3.3v 1689.495n 3.3v 1689.505n 3.3v 1699.495n 3.3v 1699.505n 3.3v 1709.495n 3.3v 1709.505n 3.3v 1719.495n 3.3v 1719.505n 3.3v 1729.495n 3.3v 1729.505n 3.3v 1739.495n 3.3v 1739.505n 3.3v 1749.495n 3.3v 1749.505n 3.3v 1759.495n 3.3v 1759.505n 3.3v 1769.495n 3.3v 1769.505n 3.3v 1779.495n 3.3v 1779.505n 3.3v 1789.495n 3.3v 1789.505n 3.3v 1799.495n 3.3v 1799.505n 3.3v 1809.495n 3.3v 1809.505n 3.3v 1819.495n 3.3v 1819.505n 3.3v 1829.495n 3.3v 1829.505n 3.3v 1839.495n 3.3v 1839.505n 3.3v 1849.495n 3.3v 1849.505n 3.3v 1859.495n 3.3v 1859.505n 3.3v 1869.495n 3.3v 1869.505n 3.3v 1879.495n 3.3v 1879.505n 3.3v 1889.495n 3.3v 1889.505n 3.3v 1899.495n 3.3v 1899.505n 3.3v 1909.495n 3.3v 1909.505n 3.3v 1919.495n 3.3v 1919.505n 3.3v 1929.495n 3.3v 1929.505n 3.3v 1939.495n 3.3v 1939.505n 3.3v 1949.495n 3.3v 1949.505n 3.3v 1959.495n 3.3v 1959.505n 3.3v 1969.495n 3.3v 1969.505n 3.3v 1979.495n 3.3v 1979.505n 0.0v 1989.495n 0.0v 1989.505n 0.0v 1999.495n 0.0v 1999.505n 0.0v 2009.495n 0.0v 2009.505n 0.0v 2019.495n 0.0v 2019.505n 0.0v 2029.495n 0.0v 2029.505n 3.3v 2039.495n 3.3v 2039.505n 3.3v 2049.495n 3.3v 2049.505n 3.3v )
* (time, data): [(0, 0), (10, 0), (20, 1), (30, 1), (40, 1), (50, 0), (60, 1), (70, 0), (80, 0), (90, 0), (100, 1), (110, 1), (120, 1), (130, 1), (140, 1), (150, 1), (160, 1), (170, 1), (180, 1), (190, 1), (200, 1), (210, 1), (220, 1), (230, 1), (240, 1), (250, 1), (260, 1), (270, 1), (280, 1), (290, 1), (300, 1), (310, 1), (320, 1), (330, 0), (340, 0), (350, 0), (360, 0), (370, 0), (380, 0), (390, 0), (400, 0), (410, 0), (420, 0), (430, 0), (440, 0), (450, 0), (460, 0), (470, 0), (480, 0), (490, 0), (500, 0), (510, 0), (520, 0), (530, 0), (540, 0), (550, 0), (560, 0), (570, 0), (580, 0), (590, 0), (600, 0), (610, 1), (620, 1), (630, 1), (640, 1), (650, 1), (660, 1), (670, 1), (680, 1), (690, 1), (700, 1), (710, 1), (720, 1), (730, 1), (740, 0), (750, 1), (760, 1), (770, 1), (780, 1), (790, 1), (800, 0), (810, 0), (820, 1), (830, 1), (840, 0), (850, 0), (860, 0), (870, 0), (880, 0), (890, 0), (900, 0), (910, 0), (920, 0), (930, 0), (940, 0), (950, 0), (960, 0), (970, 0), (980, 0), (990, 0), (1000, 1), (1010, 1), (1020, 1), (1030, 1), (1040, 1), (1050, 1), (1060, 1), (1070, 1), (1080, 1), (1090, 1), (1100, 1), (1110, 1), (1120, 1), (1130, 1), (1140, 1), (1150, 1), (1160, 1), (1170, 1), (1180, 1), (1190, 1), (1200, 1), (1210, 1), (1220, 1), (1230, 1), (1240, 0), (1250, 0), (1260, 0), (1270, 0), (1280, 1), (1290, 1), (1300, 1), (1310, 1), (1320, 0), (1330, 0), (1340, 1), (1350, 1), (1360, 1), (1370, 1), (1380, 1), (1390, 0), (1400, 0), (1410, 0), (1420, 0), (1430, 0), (1440, 0), (1450, 0), (1460, 0), (1470, 1), (1480, 0), (1490, 0), (1500, 0), (1510, 0), (1520, 0), (1530, 0), (1540, 0), (1550, 0), (1560, 0), (1570, 0), (1580, 0), (1590, 0), (1600, 0), (1610, 0), (1620, 0), (1630, 1), (1640, 1), (1650, 1), (1660, 0), (1670, 0), (1680, 0), (1690, 0), (1700, 0), (1710, 0), (1720, 0), (1730, 0), (1740, 0), (1750, 0), (1760, 0), (1770, 0), (1780, 0), (1790, 0), (1800, 0), (1810, 0), (1820, 0), (1830, 0), (1840, 0), (1850, 0), (1860, 0), (1870, 0), (1880, 0), (1890, 0), (1900, 0), (1910, 0), (1920, 0), (1930, 0), (1940, 0), (1950, 1), (1960, 1), (1970, 1), (1980, 0), (1990, 0), (2000, 0), (2010, 0), (2020, 0), (2030, 0), (2040, 0), (2050, 0)]
Vdin1_26  din1_26  0 PWL (0n 0.0v 9.495n 0.0v 9.505n 0.0v 19.495n 0.0v 19.505n 3.3v 29.495n 3.3v 29.505n 3.3v 39.495n 3.3v 39.505n 3.3v 49.495n 3.3v 49.505n 0.0v 59.495n 0.0v 59.505n 3.3v 69.495n 3.3v 69.505n 0.0v 79.495n 0.0v 79.505n 0.0v 89.495n 0.0v 89.505n 0.0v 99.495n 0.0v 99.505n 3.3v 109.495n 3.3v 109.505n 3.3v 119.495n 3.3v 119.505n 3.3v 129.495n 3.3v 129.505n 3.3v 139.495n 3.3v 139.505n 3.3v 149.495n 3.3v 149.505n 3.3v 159.495n 3.3v 159.505n 3.3v 169.495n 3.3v 169.505n 3.3v 179.495n 3.3v 179.505n 3.3v 189.495n 3.3v 189.505n 3.3v 199.495n 3.3v 199.505n 3.3v 209.495n 3.3v 209.505n 3.3v 219.495n 3.3v 219.505n 3.3v 229.495n 3.3v 229.505n 3.3v 239.495n 3.3v 239.505n 3.3v 249.495n 3.3v 249.505n 3.3v 259.495n 3.3v 259.505n 3.3v 269.495n 3.3v 269.505n 3.3v 279.495n 3.3v 279.505n 3.3v 289.495n 3.3v 289.505n 3.3v 299.495n 3.3v 299.505n 3.3v 309.495n 3.3v 309.505n 3.3v 319.495n 3.3v 319.505n 3.3v 329.495n 3.3v 329.505n 0.0v 339.495n 0.0v 339.505n 0.0v 349.495n 0.0v 349.505n 0.0v 359.495n 0.0v 359.505n 0.0v 369.495n 0.0v 369.505n 0.0v 379.495n 0.0v 379.505n 0.0v 389.495n 0.0v 389.505n 0.0v 399.495n 0.0v 399.505n 0.0v 409.495n 0.0v 409.505n 0.0v 419.495n 0.0v 419.505n 0.0v 429.495n 0.0v 429.505n 0.0v 439.495n 0.0v 439.505n 0.0v 449.495n 0.0v 449.505n 0.0v 459.495n 0.0v 459.505n 0.0v 469.495n 0.0v 469.505n 0.0v 479.495n 0.0v 479.505n 0.0v 489.495n 0.0v 489.505n 0.0v 499.495n 0.0v 499.505n 0.0v 509.495n 0.0v 509.505n 0.0v 519.495n 0.0v 519.505n 0.0v 529.495n 0.0v 529.505n 0.0v 539.495n 0.0v 539.505n 0.0v 549.495n 0.0v 549.505n 0.0v 559.495n 0.0v 559.505n 0.0v 569.495n 0.0v 569.505n 0.0v 579.495n 0.0v 579.505n 0.0v 589.495n 0.0v 589.505n 0.0v 599.495n 0.0v 599.505n 0.0v 609.495n 0.0v 609.505n 3.3v 619.495n 3.3v 619.505n 3.3v 629.495n 3.3v 629.505n 3.3v 639.495n 3.3v 639.505n 3.3v 649.495n 3.3v 649.505n 3.3v 659.495n 3.3v 659.505n 3.3v 669.495n 3.3v 669.505n 3.3v 679.495n 3.3v 679.505n 3.3v 689.495n 3.3v 689.505n 3.3v 699.495n 3.3v 699.505n 3.3v 709.495n 3.3v 709.505n 3.3v 719.495n 3.3v 719.505n 3.3v 729.495n 3.3v 729.505n 3.3v 739.495n 3.3v 739.505n 0.0v 749.495n 0.0v 749.505n 3.3v 759.495n 3.3v 759.505n 3.3v 769.495n 3.3v 769.505n 3.3v 779.495n 3.3v 779.505n 3.3v 789.495n 3.3v 789.505n 3.3v 799.495n 3.3v 799.505n 0.0v 809.495n 0.0v 809.505n 0.0v 819.495n 0.0v 819.505n 3.3v 829.495n 3.3v 829.505n 3.3v 839.495n 3.3v 839.505n 0.0v 849.495n 0.0v 849.505n 0.0v 859.495n 0.0v 859.505n 0.0v 869.495n 0.0v 869.505n 0.0v 879.495n 0.0v 879.505n 0.0v 889.495n 0.0v 889.505n 0.0v 899.495n 0.0v 899.505n 0.0v 909.495n 0.0v 909.505n 0.0v 919.495n 0.0v 919.505n 0.0v 929.495n 0.0v 929.505n 0.0v 939.495n 0.0v 939.505n 0.0v 949.495n 0.0v 949.505n 0.0v 959.495n 0.0v 959.505n 0.0v 969.495n 0.0v 969.505n 0.0v 979.495n 0.0v 979.505n 0.0v 989.495n 0.0v 989.505n 0.0v 999.495n 0.0v 999.505n 3.3v 1009.495n 3.3v 1009.505n 3.3v 1019.495n 3.3v 1019.505n 3.3v 1029.495n 3.3v 1029.505n 3.3v 1039.495n 3.3v 1039.505n 3.3v 1049.495n 3.3v 1049.505n 3.3v 1059.495n 3.3v 1059.505n 3.3v 1069.495n 3.3v 1069.505n 3.3v 1079.495n 3.3v 1079.505n 3.3v 1089.495n 3.3v 1089.505n 3.3v 1099.495n 3.3v 1099.505n 3.3v 1109.495n 3.3v 1109.505n 3.3v 1119.495n 3.3v 1119.505n 3.3v 1129.495n 3.3v 1129.505n 3.3v 1139.495n 3.3v 1139.505n 3.3v 1149.495n 3.3v 1149.505n 3.3v 1159.495n 3.3v 1159.505n 3.3v 1169.495n 3.3v 1169.505n 3.3v 1179.495n 3.3v 1179.505n 3.3v 1189.495n 3.3v 1189.505n 3.3v 1199.495n 3.3v 1199.505n 3.3v 1209.495n 3.3v 1209.505n 3.3v 1219.495n 3.3v 1219.505n 3.3v 1229.495n 3.3v 1229.505n 3.3v 1239.495n 3.3v 1239.505n 0.0v 1249.495n 0.0v 1249.505n 0.0v 1259.495n 0.0v 1259.505n 0.0v 1269.495n 0.0v 1269.505n 0.0v 1279.495n 0.0v 1279.505n 3.3v 1289.495n 3.3v 1289.505n 3.3v 1299.495n 3.3v 1299.505n 3.3v 1309.495n 3.3v 1309.505n 3.3v 1319.495n 3.3v 1319.505n 0.0v 1329.495n 0.0v 1329.505n 0.0v 1339.495n 0.0v 1339.505n 3.3v 1349.495n 3.3v 1349.505n 3.3v 1359.495n 3.3v 1359.505n 3.3v 1369.495n 3.3v 1369.505n 3.3v 1379.495n 3.3v 1379.505n 3.3v 1389.495n 3.3v 1389.505n 0.0v 1399.495n 0.0v 1399.505n 0.0v 1409.495n 0.0v 1409.505n 0.0v 1419.495n 0.0v 1419.505n 0.0v 1429.495n 0.0v 1429.505n 0.0v 1439.495n 0.0v 1439.505n 0.0v 1449.495n 0.0v 1449.505n 0.0v 1459.495n 0.0v 1459.505n 0.0v 1469.495n 0.0v 1469.505n 3.3v 1479.495n 3.3v 1479.505n 0.0v 1489.495n 0.0v 1489.505n 0.0v 1499.495n 0.0v 1499.505n 0.0v 1509.495n 0.0v 1509.505n 0.0v 1519.495n 0.0v 1519.505n 0.0v 1529.495n 0.0v 1529.505n 0.0v 1539.495n 0.0v 1539.505n 0.0v 1549.495n 0.0v 1549.505n 0.0v 1559.495n 0.0v 1559.505n 0.0v 1569.495n 0.0v 1569.505n 0.0v 1579.495n 0.0v 1579.505n 0.0v 1589.495n 0.0v 1589.505n 0.0v 1599.495n 0.0v 1599.505n 0.0v 1609.495n 0.0v 1609.505n 0.0v 1619.495n 0.0v 1619.505n 0.0v 1629.495n 0.0v 1629.505n 3.3v 1639.495n 3.3v 1639.505n 3.3v 1649.495n 3.3v 1649.505n 3.3v 1659.495n 3.3v 1659.505n 0.0v 1669.495n 0.0v 1669.505n 0.0v 1679.495n 0.0v 1679.505n 0.0v 1689.495n 0.0v 1689.505n 0.0v 1699.495n 0.0v 1699.505n 0.0v 1709.495n 0.0v 1709.505n 0.0v 1719.495n 0.0v 1719.505n 0.0v 1729.495n 0.0v 1729.505n 0.0v 1739.495n 0.0v 1739.505n 0.0v 1749.495n 0.0v 1749.505n 0.0v 1759.495n 0.0v 1759.505n 0.0v 1769.495n 0.0v 1769.505n 0.0v 1779.495n 0.0v 1779.505n 0.0v 1789.495n 0.0v 1789.505n 0.0v 1799.495n 0.0v 1799.505n 0.0v 1809.495n 0.0v 1809.505n 0.0v 1819.495n 0.0v 1819.505n 0.0v 1829.495n 0.0v 1829.505n 0.0v 1839.495n 0.0v 1839.505n 0.0v 1849.495n 0.0v 1849.505n 0.0v 1859.495n 0.0v 1859.505n 0.0v 1869.495n 0.0v 1869.505n 0.0v 1879.495n 0.0v 1879.505n 0.0v 1889.495n 0.0v 1889.505n 0.0v 1899.495n 0.0v 1899.505n 0.0v 1909.495n 0.0v 1909.505n 0.0v 1919.495n 0.0v 1919.505n 0.0v 1929.495n 0.0v 1929.505n 0.0v 1939.495n 0.0v 1939.505n 0.0v 1949.495n 0.0v 1949.505n 3.3v 1959.495n 3.3v 1959.505n 3.3v 1969.495n 3.3v 1969.505n 3.3v 1979.495n 3.3v 1979.505n 0.0v 1989.495n 0.0v 1989.505n 0.0v 1999.495n 0.0v 1999.505n 0.0v 2009.495n 0.0v 2009.505n 0.0v 2019.495n 0.0v 2019.505n 0.0v 2029.495n 0.0v 2029.505n 0.0v 2039.495n 0.0v 2039.505n 0.0v 2049.495n 0.0v 2049.505n 0.0v )
* (time, data): [(0, 0), (10, 1), (20, 1), (30, 0), (40, 0), (50, 1), (60, 1), (70, 1), (80, 1), (90, 1), (100, 0), (110, 0), (120, 0), (130, 0), (140, 0), (150, 1), (160, 1), (170, 1), (180, 0), (190, 0), (200, 0), (210, 0), (220, 0), (230, 0), (240, 0), (250, 0), (260, 0), (270, 0), (280, 0), (290, 0), (300, 0), (310, 0), (320, 0), (330, 0), (340, 0), (350, 0), (360, 1), (370, 1), (380, 1), (390, 1), (400, 1), (410, 1), (420, 1), (430, 1), (440, 0), (450, 0), (460, 0), (470, 0), (480, 0), (490, 0), (500, 0), (510, 0), (520, 0), (530, 0), (540, 0), (550, 0), (560, 0), (570, 0), (580, 0), (590, 0), (600, 0), (610, 0), (620, 0), (630, 1), (640, 1), (650, 1), (660, 1), (670, 1), (680, 1), (690, 0), (700, 0), (710, 0), (720, 0), (730, 0), (740, 1), (750, 1), (760, 1), (770, 1), (780, 1), (790, 1), (800, 1), (810, 1), (820, 0), (830, 0), (840, 0), (850, 0), (860, 0), (870, 0), (880, 0), (890, 0), (900, 0), (910, 1), (920, 1), (930, 1), (940, 1), (950, 1), (960, 1), (970, 1), (980, 1), (990, 1), (1000, 1), (1010, 1), (1020, 1), (1030, 1), (1040, 1), (1050, 1), (1060, 1), (1070, 1), (1080, 1), (1090, 1), (1100, 1), (1110, 1), (1120, 1), (1130, 1), (1140, 1), (1150, 1), (1160, 1), (1170, 1), (1180, 1), (1190, 1), (1200, 1), (1210, 1), (1220, 1), (1230, 1), (1240, 0), (1250, 0), (1260, 0), (1270, 0), (1280, 1), (1290, 1), (1300, 1), (1310, 1), (1320, 0), (1330, 0), (1340, 0), (1350, 0), (1360, 1), (1370, 1), (1380, 1), (1390, 1), (1400, 1), (1410, 1), (1420, 1), (1430, 1), (1440, 1), (1450, 1), (1460, 1), (1470, 1), (1480, 1), (1490, 1), (1500, 1), (1510, 1), (1520, 1), (1530, 1), (1540, 1), (1550, 0), (1560, 0), (1570, 0), (1580, 0), (1590, 0), (1600, 0), (1610, 0), (1620, 0), (1630, 0), (1640, 0), (1650, 0), (1660, 1), (1670, 1), (1680, 1), (1690, 1), (1700, 1), (1710, 1), (1720, 1), (1730, 1), (1740, 1), (1750, 1), (1760, 1), (1770, 1), (1780, 1), (1790, 0), (1800, 0), (1810, 0), (1820, 0), (1830, 0), (1840, 0), (1850, 0), (1860, 0), (1870, 0), (1880, 0), (1890, 0), (1900, 0), (1910, 0), (1920, 0), (1930, 0), (1940, 0), (1950, 1), (1960, 1), (1970, 1), (1980, 0), (1990, 0), (2000, 0), (2010, 0), (2020, 0), (2030, 1), (2040, 1), (2050, 1)]
Vdin1_27  din1_27  0 PWL (0n 0.0v 9.495n 0.0v 9.505n 3.3v 19.495n 3.3v 19.505n 3.3v 29.495n 3.3v 29.505n 0.0v 39.495n 0.0v 39.505n 0.0v 49.495n 0.0v 49.505n 3.3v 59.495n 3.3v 59.505n 3.3v 69.495n 3.3v 69.505n 3.3v 79.495n 3.3v 79.505n 3.3v 89.495n 3.3v 89.505n 3.3v 99.495n 3.3v 99.505n 0.0v 109.495n 0.0v 109.505n 0.0v 119.495n 0.0v 119.505n 0.0v 129.495n 0.0v 129.505n 0.0v 139.495n 0.0v 139.505n 0.0v 149.495n 0.0v 149.505n 3.3v 159.495n 3.3v 159.505n 3.3v 169.495n 3.3v 169.505n 3.3v 179.495n 3.3v 179.505n 0.0v 189.495n 0.0v 189.505n 0.0v 199.495n 0.0v 199.505n 0.0v 209.495n 0.0v 209.505n 0.0v 219.495n 0.0v 219.505n 0.0v 229.495n 0.0v 229.505n 0.0v 239.495n 0.0v 239.505n 0.0v 249.495n 0.0v 249.505n 0.0v 259.495n 0.0v 259.505n 0.0v 269.495n 0.0v 269.505n 0.0v 279.495n 0.0v 279.505n 0.0v 289.495n 0.0v 289.505n 0.0v 299.495n 0.0v 299.505n 0.0v 309.495n 0.0v 309.505n 0.0v 319.495n 0.0v 319.505n 0.0v 329.495n 0.0v 329.505n 0.0v 339.495n 0.0v 339.505n 0.0v 349.495n 0.0v 349.505n 0.0v 359.495n 0.0v 359.505n 3.3v 369.495n 3.3v 369.505n 3.3v 379.495n 3.3v 379.505n 3.3v 389.495n 3.3v 389.505n 3.3v 399.495n 3.3v 399.505n 3.3v 409.495n 3.3v 409.505n 3.3v 419.495n 3.3v 419.505n 3.3v 429.495n 3.3v 429.505n 3.3v 439.495n 3.3v 439.505n 0.0v 449.495n 0.0v 449.505n 0.0v 459.495n 0.0v 459.505n 0.0v 469.495n 0.0v 469.505n 0.0v 479.495n 0.0v 479.505n 0.0v 489.495n 0.0v 489.505n 0.0v 499.495n 0.0v 499.505n 0.0v 509.495n 0.0v 509.505n 0.0v 519.495n 0.0v 519.505n 0.0v 529.495n 0.0v 529.505n 0.0v 539.495n 0.0v 539.505n 0.0v 549.495n 0.0v 549.505n 0.0v 559.495n 0.0v 559.505n 0.0v 569.495n 0.0v 569.505n 0.0v 579.495n 0.0v 579.505n 0.0v 589.495n 0.0v 589.505n 0.0v 599.495n 0.0v 599.505n 0.0v 609.495n 0.0v 609.505n 0.0v 619.495n 0.0v 619.505n 0.0v 629.495n 0.0v 629.505n 3.3v 639.495n 3.3v 639.505n 3.3v 649.495n 3.3v 649.505n 3.3v 659.495n 3.3v 659.505n 3.3v 669.495n 3.3v 669.505n 3.3v 679.495n 3.3v 679.505n 3.3v 689.495n 3.3v 689.505n 0.0v 699.495n 0.0v 699.505n 0.0v 709.495n 0.0v 709.505n 0.0v 719.495n 0.0v 719.505n 0.0v 729.495n 0.0v 729.505n 0.0v 739.495n 0.0v 739.505n 3.3v 749.495n 3.3v 749.505n 3.3v 759.495n 3.3v 759.505n 3.3v 769.495n 3.3v 769.505n 3.3v 779.495n 3.3v 779.505n 3.3v 789.495n 3.3v 789.505n 3.3v 799.495n 3.3v 799.505n 3.3v 809.495n 3.3v 809.505n 3.3v 819.495n 3.3v 819.505n 0.0v 829.495n 0.0v 829.505n 0.0v 839.495n 0.0v 839.505n 0.0v 849.495n 0.0v 849.505n 0.0v 859.495n 0.0v 859.505n 0.0v 869.495n 0.0v 869.505n 0.0v 879.495n 0.0v 879.505n 0.0v 889.495n 0.0v 889.505n 0.0v 899.495n 0.0v 899.505n 0.0v 909.495n 0.0v 909.505n 3.3v 919.495n 3.3v 919.505n 3.3v 929.495n 3.3v 929.505n 3.3v 939.495n 3.3v 939.505n 3.3v 949.495n 3.3v 949.505n 3.3v 959.495n 3.3v 959.505n 3.3v 969.495n 3.3v 969.505n 3.3v 979.495n 3.3v 979.505n 3.3v 989.495n 3.3v 989.505n 3.3v 999.495n 3.3v 999.505n 3.3v 1009.495n 3.3v 1009.505n 3.3v 1019.495n 3.3v 1019.505n 3.3v 1029.495n 3.3v 1029.505n 3.3v 1039.495n 3.3v 1039.505n 3.3v 1049.495n 3.3v 1049.505n 3.3v 1059.495n 3.3v 1059.505n 3.3v 1069.495n 3.3v 1069.505n 3.3v 1079.495n 3.3v 1079.505n 3.3v 1089.495n 3.3v 1089.505n 3.3v 1099.495n 3.3v 1099.505n 3.3v 1109.495n 3.3v 1109.505n 3.3v 1119.495n 3.3v 1119.505n 3.3v 1129.495n 3.3v 1129.505n 3.3v 1139.495n 3.3v 1139.505n 3.3v 1149.495n 3.3v 1149.505n 3.3v 1159.495n 3.3v 1159.505n 3.3v 1169.495n 3.3v 1169.505n 3.3v 1179.495n 3.3v 1179.505n 3.3v 1189.495n 3.3v 1189.505n 3.3v 1199.495n 3.3v 1199.505n 3.3v 1209.495n 3.3v 1209.505n 3.3v 1219.495n 3.3v 1219.505n 3.3v 1229.495n 3.3v 1229.505n 3.3v 1239.495n 3.3v 1239.505n 0.0v 1249.495n 0.0v 1249.505n 0.0v 1259.495n 0.0v 1259.505n 0.0v 1269.495n 0.0v 1269.505n 0.0v 1279.495n 0.0v 1279.505n 3.3v 1289.495n 3.3v 1289.505n 3.3v 1299.495n 3.3v 1299.505n 3.3v 1309.495n 3.3v 1309.505n 3.3v 1319.495n 3.3v 1319.505n 0.0v 1329.495n 0.0v 1329.505n 0.0v 1339.495n 0.0v 1339.505n 0.0v 1349.495n 0.0v 1349.505n 0.0v 1359.495n 0.0v 1359.505n 3.3v 1369.495n 3.3v 1369.505n 3.3v 1379.495n 3.3v 1379.505n 3.3v 1389.495n 3.3v 1389.505n 3.3v 1399.495n 3.3v 1399.505n 3.3v 1409.495n 3.3v 1409.505n 3.3v 1419.495n 3.3v 1419.505n 3.3v 1429.495n 3.3v 1429.505n 3.3v 1439.495n 3.3v 1439.505n 3.3v 1449.495n 3.3v 1449.505n 3.3v 1459.495n 3.3v 1459.505n 3.3v 1469.495n 3.3v 1469.505n 3.3v 1479.495n 3.3v 1479.505n 3.3v 1489.495n 3.3v 1489.505n 3.3v 1499.495n 3.3v 1499.505n 3.3v 1509.495n 3.3v 1509.505n 3.3v 1519.495n 3.3v 1519.505n 3.3v 1529.495n 3.3v 1529.505n 3.3v 1539.495n 3.3v 1539.505n 3.3v 1549.495n 3.3v 1549.505n 0.0v 1559.495n 0.0v 1559.505n 0.0v 1569.495n 0.0v 1569.505n 0.0v 1579.495n 0.0v 1579.505n 0.0v 1589.495n 0.0v 1589.505n 0.0v 1599.495n 0.0v 1599.505n 0.0v 1609.495n 0.0v 1609.505n 0.0v 1619.495n 0.0v 1619.505n 0.0v 1629.495n 0.0v 1629.505n 0.0v 1639.495n 0.0v 1639.505n 0.0v 1649.495n 0.0v 1649.505n 0.0v 1659.495n 0.0v 1659.505n 3.3v 1669.495n 3.3v 1669.505n 3.3v 1679.495n 3.3v 1679.505n 3.3v 1689.495n 3.3v 1689.505n 3.3v 1699.495n 3.3v 1699.505n 3.3v 1709.495n 3.3v 1709.505n 3.3v 1719.495n 3.3v 1719.505n 3.3v 1729.495n 3.3v 1729.505n 3.3v 1739.495n 3.3v 1739.505n 3.3v 1749.495n 3.3v 1749.505n 3.3v 1759.495n 3.3v 1759.505n 3.3v 1769.495n 3.3v 1769.505n 3.3v 1779.495n 3.3v 1779.505n 3.3v 1789.495n 3.3v 1789.505n 0.0v 1799.495n 0.0v 1799.505n 0.0v 1809.495n 0.0v 1809.505n 0.0v 1819.495n 0.0v 1819.505n 0.0v 1829.495n 0.0v 1829.505n 0.0v 1839.495n 0.0v 1839.505n 0.0v 1849.495n 0.0v 1849.505n 0.0v 1859.495n 0.0v 1859.505n 0.0v 1869.495n 0.0v 1869.505n 0.0v 1879.495n 0.0v 1879.505n 0.0v 1889.495n 0.0v 1889.505n 0.0v 1899.495n 0.0v 1899.505n 0.0v 1909.495n 0.0v 1909.505n 0.0v 1919.495n 0.0v 1919.505n 0.0v 1929.495n 0.0v 1929.505n 0.0v 1939.495n 0.0v 1939.505n 0.0v 1949.495n 0.0v 1949.505n 3.3v 1959.495n 3.3v 1959.505n 3.3v 1969.495n 3.3v 1969.505n 3.3v 1979.495n 3.3v 1979.505n 0.0v 1989.495n 0.0v 1989.505n 0.0v 1999.495n 0.0v 1999.505n 0.0v 2009.495n 0.0v 2009.505n 0.0v 2019.495n 0.0v 2019.505n 0.0v 2029.495n 0.0v 2029.505n 3.3v 2039.495n 3.3v 2039.505n 3.3v 2049.495n 3.3v 2049.505n 3.3v )
* (time, data): [(0, 0), (10, 0), (20, 0), (30, 1), (40, 1), (50, 1), (60, 0), (70, 1), (80, 1), (90, 1), (100, 1), (110, 1), (120, 1), (130, 1), (140, 1), (150, 0), (160, 0), (170, 0), (180, 0), (190, 0), (200, 0), (210, 0), (220, 0), (230, 0), (240, 0), (250, 0), (260, 0), (270, 0), (280, 0), (290, 0), (300, 0), (310, 0), (320, 0), (330, 1), (340, 1), (350, 1), (360, 1), (370, 1), (380, 1), (390, 1), (400, 1), (410, 1), (420, 1), (430, 1), (440, 0), (450, 0), (460, 0), (470, 0), (480, 0), (490, 0), (500, 0), (510, 0), (520, 0), (530, 0), (540, 1), (550, 1), (560, 1), (570, 1), (580, 1), (590, 1), (600, 1), (610, 1), (620, 1), (630, 0), (640, 0), (650, 0), (660, 0), (670, 0), (680, 0), (690, 1), (700, 1), (710, 1), (720, 1), (730, 1), (740, 0), (750, 1), (760, 1), (770, 1), (780, 1), (790, 1), (800, 1), (810, 1), (820, 1), (830, 1), (840, 0), (850, 0), (860, 0), (870, 0), (880, 0), (890, 0), (900, 0), (910, 0), (920, 0), (930, 0), (940, 1), (950, 1), (960, 0), (970, 0), (980, 0), (990, 0), (1000, 1), (1010, 1), (1020, 1), (1030, 1), (1040, 1), (1050, 1), (1060, 1), (1070, 1), (1080, 0), (1090, 0), (1100, 0), (1110, 0), (1120, 0), (1130, 0), (1140, 0), (1150, 0), (1160, 0), (1170, 0), (1180, 0), (1190, 0), (1200, 0), (1210, 0), (1220, 0), (1230, 0), (1240, 0), (1250, 1), (1260, 1), (1270, 1), (1280, 1), (1290, 1), (1300, 1), (1310, 1), (1320, 1), (1330, 1), (1340, 0), (1350, 0), (1360, 1), (1370, 1), (1380, 1), (1390, 1), (1400, 1), (1410, 1), (1420, 1), (1430, 1), (1440, 1), (1450, 1), (1460, 1), (1470, 1), (1480, 1), (1490, 1), (1500, 1), (1510, 1), (1520, 1), (1530, 1), (1540, 1), (1550, 0), (1560, 0), (1570, 1), (1580, 1), (1590, 1), (1600, 1), (1610, 0), (1620, 0), (1630, 0), (1640, 0), (1650, 0), (1660, 0), (1670, 0), (1680, 0), (1690, 0), (1700, 0), (1710, 0), (1720, 0), (1730, 0), (1740, 0), (1750, 0), (1760, 0), (1770, 1), (1780, 1), (1790, 0), (1800, 0), (1810, 0), (1820, 0), (1830, 0), (1840, 0), (1850, 0), (1860, 0), (1870, 0), (1880, 0), (1890, 0), (1900, 0), (1910, 0), (1920, 0), (1930, 0), (1940, 0), (1950, 0), (1960, 0), (1970, 0), (1980, 1), (1990, 1), (2000, 1), (2010, 1), (2020, 1), (2030, 0), (2040, 0), (2050, 0)]
Vdin1_28  din1_28  0 PWL (0n 0.0v 9.495n 0.0v 9.505n 0.0v 19.495n 0.0v 19.505n 0.0v 29.495n 0.0v 29.505n 3.3v 39.495n 3.3v 39.505n 3.3v 49.495n 3.3v 49.505n 3.3v 59.495n 3.3v 59.505n 0.0v 69.495n 0.0v 69.505n 3.3v 79.495n 3.3v 79.505n 3.3v 89.495n 3.3v 89.505n 3.3v 99.495n 3.3v 99.505n 3.3v 109.495n 3.3v 109.505n 3.3v 119.495n 3.3v 119.505n 3.3v 129.495n 3.3v 129.505n 3.3v 139.495n 3.3v 139.505n 3.3v 149.495n 3.3v 149.505n 0.0v 159.495n 0.0v 159.505n 0.0v 169.495n 0.0v 169.505n 0.0v 179.495n 0.0v 179.505n 0.0v 189.495n 0.0v 189.505n 0.0v 199.495n 0.0v 199.505n 0.0v 209.495n 0.0v 209.505n 0.0v 219.495n 0.0v 219.505n 0.0v 229.495n 0.0v 229.505n 0.0v 239.495n 0.0v 239.505n 0.0v 249.495n 0.0v 249.505n 0.0v 259.495n 0.0v 259.505n 0.0v 269.495n 0.0v 269.505n 0.0v 279.495n 0.0v 279.505n 0.0v 289.495n 0.0v 289.505n 0.0v 299.495n 0.0v 299.505n 0.0v 309.495n 0.0v 309.505n 0.0v 319.495n 0.0v 319.505n 0.0v 329.495n 0.0v 329.505n 3.3v 339.495n 3.3v 339.505n 3.3v 349.495n 3.3v 349.505n 3.3v 359.495n 3.3v 359.505n 3.3v 369.495n 3.3v 369.505n 3.3v 379.495n 3.3v 379.505n 3.3v 389.495n 3.3v 389.505n 3.3v 399.495n 3.3v 399.505n 3.3v 409.495n 3.3v 409.505n 3.3v 419.495n 3.3v 419.505n 3.3v 429.495n 3.3v 429.505n 3.3v 439.495n 3.3v 439.505n 0.0v 449.495n 0.0v 449.505n 0.0v 459.495n 0.0v 459.505n 0.0v 469.495n 0.0v 469.505n 0.0v 479.495n 0.0v 479.505n 0.0v 489.495n 0.0v 489.505n 0.0v 499.495n 0.0v 499.505n 0.0v 509.495n 0.0v 509.505n 0.0v 519.495n 0.0v 519.505n 0.0v 529.495n 0.0v 529.505n 0.0v 539.495n 0.0v 539.505n 3.3v 549.495n 3.3v 549.505n 3.3v 559.495n 3.3v 559.505n 3.3v 569.495n 3.3v 569.505n 3.3v 579.495n 3.3v 579.505n 3.3v 589.495n 3.3v 589.505n 3.3v 599.495n 3.3v 599.505n 3.3v 609.495n 3.3v 609.505n 3.3v 619.495n 3.3v 619.505n 3.3v 629.495n 3.3v 629.505n 0.0v 639.495n 0.0v 639.505n 0.0v 649.495n 0.0v 649.505n 0.0v 659.495n 0.0v 659.505n 0.0v 669.495n 0.0v 669.505n 0.0v 679.495n 0.0v 679.505n 0.0v 689.495n 0.0v 689.505n 3.3v 699.495n 3.3v 699.505n 3.3v 709.495n 3.3v 709.505n 3.3v 719.495n 3.3v 719.505n 3.3v 729.495n 3.3v 729.505n 3.3v 739.495n 3.3v 739.505n 0.0v 749.495n 0.0v 749.505n 3.3v 759.495n 3.3v 759.505n 3.3v 769.495n 3.3v 769.505n 3.3v 779.495n 3.3v 779.505n 3.3v 789.495n 3.3v 789.505n 3.3v 799.495n 3.3v 799.505n 3.3v 809.495n 3.3v 809.505n 3.3v 819.495n 3.3v 819.505n 3.3v 829.495n 3.3v 829.505n 3.3v 839.495n 3.3v 839.505n 0.0v 849.495n 0.0v 849.505n 0.0v 859.495n 0.0v 859.505n 0.0v 869.495n 0.0v 869.505n 0.0v 879.495n 0.0v 879.505n 0.0v 889.495n 0.0v 889.505n 0.0v 899.495n 0.0v 899.505n 0.0v 909.495n 0.0v 909.505n 0.0v 919.495n 0.0v 919.505n 0.0v 929.495n 0.0v 929.505n 0.0v 939.495n 0.0v 939.505n 3.3v 949.495n 3.3v 949.505n 3.3v 959.495n 3.3v 959.505n 0.0v 969.495n 0.0v 969.505n 0.0v 979.495n 0.0v 979.505n 0.0v 989.495n 0.0v 989.505n 0.0v 999.495n 0.0v 999.505n 3.3v 1009.495n 3.3v 1009.505n 3.3v 1019.495n 3.3v 1019.505n 3.3v 1029.495n 3.3v 1029.505n 3.3v 1039.495n 3.3v 1039.505n 3.3v 1049.495n 3.3v 1049.505n 3.3v 1059.495n 3.3v 1059.505n 3.3v 1069.495n 3.3v 1069.505n 3.3v 1079.495n 3.3v 1079.505n 0.0v 1089.495n 0.0v 1089.505n 0.0v 1099.495n 0.0v 1099.505n 0.0v 1109.495n 0.0v 1109.505n 0.0v 1119.495n 0.0v 1119.505n 0.0v 1129.495n 0.0v 1129.505n 0.0v 1139.495n 0.0v 1139.505n 0.0v 1149.495n 0.0v 1149.505n 0.0v 1159.495n 0.0v 1159.505n 0.0v 1169.495n 0.0v 1169.505n 0.0v 1179.495n 0.0v 1179.505n 0.0v 1189.495n 0.0v 1189.505n 0.0v 1199.495n 0.0v 1199.505n 0.0v 1209.495n 0.0v 1209.505n 0.0v 1219.495n 0.0v 1219.505n 0.0v 1229.495n 0.0v 1229.505n 0.0v 1239.495n 0.0v 1239.505n 0.0v 1249.495n 0.0v 1249.505n 3.3v 1259.495n 3.3v 1259.505n 3.3v 1269.495n 3.3v 1269.505n 3.3v 1279.495n 3.3v 1279.505n 3.3v 1289.495n 3.3v 1289.505n 3.3v 1299.495n 3.3v 1299.505n 3.3v 1309.495n 3.3v 1309.505n 3.3v 1319.495n 3.3v 1319.505n 3.3v 1329.495n 3.3v 1329.505n 3.3v 1339.495n 3.3v 1339.505n 0.0v 1349.495n 0.0v 1349.505n 0.0v 1359.495n 0.0v 1359.505n 3.3v 1369.495n 3.3v 1369.505n 3.3v 1379.495n 3.3v 1379.505n 3.3v 1389.495n 3.3v 1389.505n 3.3v 1399.495n 3.3v 1399.505n 3.3v 1409.495n 3.3v 1409.505n 3.3v 1419.495n 3.3v 1419.505n 3.3v 1429.495n 3.3v 1429.505n 3.3v 1439.495n 3.3v 1439.505n 3.3v 1449.495n 3.3v 1449.505n 3.3v 1459.495n 3.3v 1459.505n 3.3v 1469.495n 3.3v 1469.505n 3.3v 1479.495n 3.3v 1479.505n 3.3v 1489.495n 3.3v 1489.505n 3.3v 1499.495n 3.3v 1499.505n 3.3v 1509.495n 3.3v 1509.505n 3.3v 1519.495n 3.3v 1519.505n 3.3v 1529.495n 3.3v 1529.505n 3.3v 1539.495n 3.3v 1539.505n 3.3v 1549.495n 3.3v 1549.505n 0.0v 1559.495n 0.0v 1559.505n 0.0v 1569.495n 0.0v 1569.505n 3.3v 1579.495n 3.3v 1579.505n 3.3v 1589.495n 3.3v 1589.505n 3.3v 1599.495n 3.3v 1599.505n 3.3v 1609.495n 3.3v 1609.505n 0.0v 1619.495n 0.0v 1619.505n 0.0v 1629.495n 0.0v 1629.505n 0.0v 1639.495n 0.0v 1639.505n 0.0v 1649.495n 0.0v 1649.505n 0.0v 1659.495n 0.0v 1659.505n 0.0v 1669.495n 0.0v 1669.505n 0.0v 1679.495n 0.0v 1679.505n 0.0v 1689.495n 0.0v 1689.505n 0.0v 1699.495n 0.0v 1699.505n 0.0v 1709.495n 0.0v 1709.505n 0.0v 1719.495n 0.0v 1719.505n 0.0v 1729.495n 0.0v 1729.505n 0.0v 1739.495n 0.0v 1739.505n 0.0v 1749.495n 0.0v 1749.505n 0.0v 1759.495n 0.0v 1759.505n 0.0v 1769.495n 0.0v 1769.505n 3.3v 1779.495n 3.3v 1779.505n 3.3v 1789.495n 3.3v 1789.505n 0.0v 1799.495n 0.0v 1799.505n 0.0v 1809.495n 0.0v 1809.505n 0.0v 1819.495n 0.0v 1819.505n 0.0v 1829.495n 0.0v 1829.505n 0.0v 1839.495n 0.0v 1839.505n 0.0v 1849.495n 0.0v 1849.505n 0.0v 1859.495n 0.0v 1859.505n 0.0v 1869.495n 0.0v 1869.505n 0.0v 1879.495n 0.0v 1879.505n 0.0v 1889.495n 0.0v 1889.505n 0.0v 1899.495n 0.0v 1899.505n 0.0v 1909.495n 0.0v 1909.505n 0.0v 1919.495n 0.0v 1919.505n 0.0v 1929.495n 0.0v 1929.505n 0.0v 1939.495n 0.0v 1939.505n 0.0v 1949.495n 0.0v 1949.505n 0.0v 1959.495n 0.0v 1959.505n 0.0v 1969.495n 0.0v 1969.505n 0.0v 1979.495n 0.0v 1979.505n 3.3v 1989.495n 3.3v 1989.505n 3.3v 1999.495n 3.3v 1999.505n 3.3v 2009.495n 3.3v 2009.505n 3.3v 2019.495n 3.3v 2019.505n 3.3v 2029.495n 3.3v 2029.505n 0.0v 2039.495n 0.0v 2039.505n 0.0v 2049.495n 0.0v 2049.505n 0.0v )
* (time, data): [(0, 0), (10, 0), (20, 1), (30, 1), (40, 1), (50, 0), (60, 0), (70, 1), (80, 1), (90, 1), (100, 1), (110, 1), (120, 1), (130, 1), (140, 1), (150, 1), (160, 0), (170, 0), (180, 1), (190, 1), (200, 1), (210, 1), (220, 1), (230, 0), (240, 0), (250, 0), (260, 0), (270, 0), (280, 0), (290, 0), (300, 0), (310, 0), (320, 0), (330, 1), (340, 1), (350, 1), (360, 1), (370, 1), (380, 1), (390, 1), (400, 1), (410, 1), (420, 1), (430, 1), (440, 0), (450, 0), (460, 0), (470, 0), (480, 0), (490, 0), (500, 0), (510, 0), (520, 0), (530, 0), (540, 0), (550, 0), (560, 0), (570, 0), (580, 0), (590, 0), (600, 0), (610, 0), (620, 0), (630, 0), (640, 0), (650, 0), (660, 0), (670, 0), (680, 0), (690, 0), (700, 0), (710, 0), (720, 0), (730, 0), (740, 1), (750, 0), (760, 0), (770, 0), (780, 0), (790, 0), (800, 1), (810, 1), (820, 1), (830, 1), (840, 1), (850, 1), (860, 1), (870, 1), (880, 1), (890, 1), (900, 1), (910, 0), (920, 0), (930, 0), (940, 0), (950, 0), (960, 1), (970, 1), (980, 1), (990, 1), (1000, 0), (1010, 0), (1020, 0), (1030, 0), (1040, 0), (1050, 0), (1060, 0), (1070, 0), (1080, 0), (1090, 1), (1100, 1), (1110, 1), (1120, 1), (1130, 1), (1140, 1), (1150, 1), (1160, 1), (1170, 1), (1180, 1), (1190, 1), (1200, 1), (1210, 1), (1220, 1), (1230, 1), (1240, 0), (1250, 0), (1260, 0), (1270, 0), (1280, 1), (1290, 1), (1300, 1), (1310, 1), (1320, 1), (1330, 1), (1340, 1), (1350, 1), (1360, 0), (1370, 0), (1380, 0), (1390, 0), (1400, 0), (1410, 0), (1420, 0), (1430, 1), (1440, 1), (1450, 1), (1460, 1), (1470, 1), (1480, 0), (1490, 0), (1500, 0), (1510, 0), (1520, 0), (1530, 0), (1540, 0), (1550, 1), (1560, 1), (1570, 0), (1580, 0), (1590, 0), (1600, 0), (1610, 1), (1620, 1), (1630, 0), (1640, 0), (1650, 0), (1660, 0), (1670, 0), (1680, 1), (1690, 1), (1700, 1), (1710, 1), (1720, 1), (1730, 1), (1740, 1), (1750, 1), (1760, 1), (1770, 0), (1780, 0), (1790, 0), (1800, 0), (1810, 0), (1820, 0), (1830, 0), (1840, 0), (1850, 0), (1860, 0), (1870, 0), (1880, 0), (1890, 0), (1900, 0), (1910, 0), (1920, 0), (1930, 0), (1940, 0), (1950, 0), (1960, 0), (1970, 0), (1980, 0), (1990, 0), (2000, 0), (2010, 0), (2020, 1), (2030, 1), (2040, 1), (2050, 1)]
Vdin1_29  din1_29  0 PWL (0n 0.0v 9.495n 0.0v 9.505n 0.0v 19.495n 0.0v 19.505n 3.3v 29.495n 3.3v 29.505n 3.3v 39.495n 3.3v 39.505n 3.3v 49.495n 3.3v 49.505n 0.0v 59.495n 0.0v 59.505n 0.0v 69.495n 0.0v 69.505n 3.3v 79.495n 3.3v 79.505n 3.3v 89.495n 3.3v 89.505n 3.3v 99.495n 3.3v 99.505n 3.3v 109.495n 3.3v 109.505n 3.3v 119.495n 3.3v 119.505n 3.3v 129.495n 3.3v 129.505n 3.3v 139.495n 3.3v 139.505n 3.3v 149.495n 3.3v 149.505n 3.3v 159.495n 3.3v 159.505n 0.0v 169.495n 0.0v 169.505n 0.0v 179.495n 0.0v 179.505n 3.3v 189.495n 3.3v 189.505n 3.3v 199.495n 3.3v 199.505n 3.3v 209.495n 3.3v 209.505n 3.3v 219.495n 3.3v 219.505n 3.3v 229.495n 3.3v 229.505n 0.0v 239.495n 0.0v 239.505n 0.0v 249.495n 0.0v 249.505n 0.0v 259.495n 0.0v 259.505n 0.0v 269.495n 0.0v 269.505n 0.0v 279.495n 0.0v 279.505n 0.0v 289.495n 0.0v 289.505n 0.0v 299.495n 0.0v 299.505n 0.0v 309.495n 0.0v 309.505n 0.0v 319.495n 0.0v 319.505n 0.0v 329.495n 0.0v 329.505n 3.3v 339.495n 3.3v 339.505n 3.3v 349.495n 3.3v 349.505n 3.3v 359.495n 3.3v 359.505n 3.3v 369.495n 3.3v 369.505n 3.3v 379.495n 3.3v 379.505n 3.3v 389.495n 3.3v 389.505n 3.3v 399.495n 3.3v 399.505n 3.3v 409.495n 3.3v 409.505n 3.3v 419.495n 3.3v 419.505n 3.3v 429.495n 3.3v 429.505n 3.3v 439.495n 3.3v 439.505n 0.0v 449.495n 0.0v 449.505n 0.0v 459.495n 0.0v 459.505n 0.0v 469.495n 0.0v 469.505n 0.0v 479.495n 0.0v 479.505n 0.0v 489.495n 0.0v 489.505n 0.0v 499.495n 0.0v 499.505n 0.0v 509.495n 0.0v 509.505n 0.0v 519.495n 0.0v 519.505n 0.0v 529.495n 0.0v 529.505n 0.0v 539.495n 0.0v 539.505n 0.0v 549.495n 0.0v 549.505n 0.0v 559.495n 0.0v 559.505n 0.0v 569.495n 0.0v 569.505n 0.0v 579.495n 0.0v 579.505n 0.0v 589.495n 0.0v 589.505n 0.0v 599.495n 0.0v 599.505n 0.0v 609.495n 0.0v 609.505n 0.0v 619.495n 0.0v 619.505n 0.0v 629.495n 0.0v 629.505n 0.0v 639.495n 0.0v 639.505n 0.0v 649.495n 0.0v 649.505n 0.0v 659.495n 0.0v 659.505n 0.0v 669.495n 0.0v 669.505n 0.0v 679.495n 0.0v 679.505n 0.0v 689.495n 0.0v 689.505n 0.0v 699.495n 0.0v 699.505n 0.0v 709.495n 0.0v 709.505n 0.0v 719.495n 0.0v 719.505n 0.0v 729.495n 0.0v 729.505n 0.0v 739.495n 0.0v 739.505n 3.3v 749.495n 3.3v 749.505n 0.0v 759.495n 0.0v 759.505n 0.0v 769.495n 0.0v 769.505n 0.0v 779.495n 0.0v 779.505n 0.0v 789.495n 0.0v 789.505n 0.0v 799.495n 0.0v 799.505n 3.3v 809.495n 3.3v 809.505n 3.3v 819.495n 3.3v 819.505n 3.3v 829.495n 3.3v 829.505n 3.3v 839.495n 3.3v 839.505n 3.3v 849.495n 3.3v 849.505n 3.3v 859.495n 3.3v 859.505n 3.3v 869.495n 3.3v 869.505n 3.3v 879.495n 3.3v 879.505n 3.3v 889.495n 3.3v 889.505n 3.3v 899.495n 3.3v 899.505n 3.3v 909.495n 3.3v 909.505n 0.0v 919.495n 0.0v 919.505n 0.0v 929.495n 0.0v 929.505n 0.0v 939.495n 0.0v 939.505n 0.0v 949.495n 0.0v 949.505n 0.0v 959.495n 0.0v 959.505n 3.3v 969.495n 3.3v 969.505n 3.3v 979.495n 3.3v 979.505n 3.3v 989.495n 3.3v 989.505n 3.3v 999.495n 3.3v 999.505n 0.0v 1009.495n 0.0v 1009.505n 0.0v 1019.495n 0.0v 1019.505n 0.0v 1029.495n 0.0v 1029.505n 0.0v 1039.495n 0.0v 1039.505n 0.0v 1049.495n 0.0v 1049.505n 0.0v 1059.495n 0.0v 1059.505n 0.0v 1069.495n 0.0v 1069.505n 0.0v 1079.495n 0.0v 1079.505n 0.0v 1089.495n 0.0v 1089.505n 3.3v 1099.495n 3.3v 1099.505n 3.3v 1109.495n 3.3v 1109.505n 3.3v 1119.495n 3.3v 1119.505n 3.3v 1129.495n 3.3v 1129.505n 3.3v 1139.495n 3.3v 1139.505n 3.3v 1149.495n 3.3v 1149.505n 3.3v 1159.495n 3.3v 1159.505n 3.3v 1169.495n 3.3v 1169.505n 3.3v 1179.495n 3.3v 1179.505n 3.3v 1189.495n 3.3v 1189.505n 3.3v 1199.495n 3.3v 1199.505n 3.3v 1209.495n 3.3v 1209.505n 3.3v 1219.495n 3.3v 1219.505n 3.3v 1229.495n 3.3v 1229.505n 3.3v 1239.495n 3.3v 1239.505n 0.0v 1249.495n 0.0v 1249.505n 0.0v 1259.495n 0.0v 1259.505n 0.0v 1269.495n 0.0v 1269.505n 0.0v 1279.495n 0.0v 1279.505n 3.3v 1289.495n 3.3v 1289.505n 3.3v 1299.495n 3.3v 1299.505n 3.3v 1309.495n 3.3v 1309.505n 3.3v 1319.495n 3.3v 1319.505n 3.3v 1329.495n 3.3v 1329.505n 3.3v 1339.495n 3.3v 1339.505n 3.3v 1349.495n 3.3v 1349.505n 3.3v 1359.495n 3.3v 1359.505n 0.0v 1369.495n 0.0v 1369.505n 0.0v 1379.495n 0.0v 1379.505n 0.0v 1389.495n 0.0v 1389.505n 0.0v 1399.495n 0.0v 1399.505n 0.0v 1409.495n 0.0v 1409.505n 0.0v 1419.495n 0.0v 1419.505n 0.0v 1429.495n 0.0v 1429.505n 3.3v 1439.495n 3.3v 1439.505n 3.3v 1449.495n 3.3v 1449.505n 3.3v 1459.495n 3.3v 1459.505n 3.3v 1469.495n 3.3v 1469.505n 3.3v 1479.495n 3.3v 1479.505n 0.0v 1489.495n 0.0v 1489.505n 0.0v 1499.495n 0.0v 1499.505n 0.0v 1509.495n 0.0v 1509.505n 0.0v 1519.495n 0.0v 1519.505n 0.0v 1529.495n 0.0v 1529.505n 0.0v 1539.495n 0.0v 1539.505n 0.0v 1549.495n 0.0v 1549.505n 3.3v 1559.495n 3.3v 1559.505n 3.3v 1569.495n 3.3v 1569.505n 0.0v 1579.495n 0.0v 1579.505n 0.0v 1589.495n 0.0v 1589.505n 0.0v 1599.495n 0.0v 1599.505n 0.0v 1609.495n 0.0v 1609.505n 3.3v 1619.495n 3.3v 1619.505n 3.3v 1629.495n 3.3v 1629.505n 0.0v 1639.495n 0.0v 1639.505n 0.0v 1649.495n 0.0v 1649.505n 0.0v 1659.495n 0.0v 1659.505n 0.0v 1669.495n 0.0v 1669.505n 0.0v 1679.495n 0.0v 1679.505n 3.3v 1689.495n 3.3v 1689.505n 3.3v 1699.495n 3.3v 1699.505n 3.3v 1709.495n 3.3v 1709.505n 3.3v 1719.495n 3.3v 1719.505n 3.3v 1729.495n 3.3v 1729.505n 3.3v 1739.495n 3.3v 1739.505n 3.3v 1749.495n 3.3v 1749.505n 3.3v 1759.495n 3.3v 1759.505n 3.3v 1769.495n 3.3v 1769.505n 0.0v 1779.495n 0.0v 1779.505n 0.0v 1789.495n 0.0v 1789.505n 0.0v 1799.495n 0.0v 1799.505n 0.0v 1809.495n 0.0v 1809.505n 0.0v 1819.495n 0.0v 1819.505n 0.0v 1829.495n 0.0v 1829.505n 0.0v 1839.495n 0.0v 1839.505n 0.0v 1849.495n 0.0v 1849.505n 0.0v 1859.495n 0.0v 1859.505n 0.0v 1869.495n 0.0v 1869.505n 0.0v 1879.495n 0.0v 1879.505n 0.0v 1889.495n 0.0v 1889.505n 0.0v 1899.495n 0.0v 1899.505n 0.0v 1909.495n 0.0v 1909.505n 0.0v 1919.495n 0.0v 1919.505n 0.0v 1929.495n 0.0v 1929.505n 0.0v 1939.495n 0.0v 1939.505n 0.0v 1949.495n 0.0v 1949.505n 0.0v 1959.495n 0.0v 1959.505n 0.0v 1969.495n 0.0v 1969.505n 0.0v 1979.495n 0.0v 1979.505n 0.0v 1989.495n 0.0v 1989.505n 0.0v 1999.495n 0.0v 1999.505n 0.0v 2009.495n 0.0v 2009.505n 0.0v 2019.495n 0.0v 2019.505n 3.3v 2029.495n 3.3v 2029.505n 3.3v 2039.495n 3.3v 2039.505n 3.3v 2049.495n 3.3v 2049.505n 3.3v )
* (time, data): [(0, 0), (10, 1), (20, 0), (30, 0), (40, 0), (50, 1), (60, 0), (70, 1), (80, 1), (90, 1), (100, 0), (110, 0), (120, 0), (130, 0), (140, 0), (150, 0), (160, 1), (170, 1), (180, 1), (190, 1), (200, 1), (210, 1), (220, 1), (230, 0), (240, 0), (250, 0), (260, 0), (270, 0), (280, 0), (290, 0), (300, 0), (310, 0), (320, 0), (330, 0), (340, 0), (350, 0), (360, 1), (370, 1), (380, 1), (390, 1), (400, 1), (410, 1), (420, 1), (430, 1), (440, 1), (450, 1), (460, 1), (470, 1), (480, 1), (490, 1), (500, 1), (510, 1), (520, 1), (530, 1), (540, 0), (550, 0), (560, 0), (570, 0), (580, 0), (590, 0), (600, 0), (610, 0), (620, 0), (630, 0), (640, 0), (650, 0), (660, 0), (670, 0), (680, 0), (690, 0), (700, 0), (710, 0), (720, 0), (730, 0), (740, 0), (750, 1), (760, 1), (770, 0), (780, 0), (790, 0), (800, 1), (810, 1), (820, 0), (830, 0), (840, 0), (850, 0), (860, 0), (870, 0), (880, 0), (890, 0), (900, 0), (910, 0), (920, 0), (930, 0), (940, 1), (950, 1), (960, 0), (970, 0), (980, 0), (990, 0), (1000, 1), (1010, 1), (1020, 1), (1030, 1), (1040, 1), (1050, 1), (1060, 1), (1070, 1), (1080, 0), (1090, 0), (1100, 0), (1110, 0), (1120, 0), (1130, 0), (1140, 0), (1150, 0), (1160, 0), (1170, 0), (1180, 0), (1190, 0), (1200, 0), (1210, 0), (1220, 0), (1230, 0), (1240, 1), (1250, 1), (1260, 1), (1270, 1), (1280, 0), (1290, 0), (1300, 0), (1310, 0), (1320, 1), (1330, 1), (1340, 0), (1350, 0), (1360, 0), (1370, 0), (1380, 0), (1390, 0), (1400, 0), (1410, 0), (1420, 0), (1430, 1), (1440, 0), (1450, 0), (1460, 0), (1470, 1), (1480, 0), (1490, 0), (1500, 0), (1510, 0), (1520, 0), (1530, 0), (1540, 0), (1550, 1), (1560, 1), (1570, 1), (1580, 1), (1590, 1), (1600, 1), (1610, 0), (1620, 0), (1630, 0), (1640, 0), (1650, 0), (1660, 0), (1670, 0), (1680, 1), (1690, 1), (1700, 1), (1710, 1), (1720, 1), (1730, 1), (1740, 1), (1750, 1), (1760, 1), (1770, 1), (1780, 1), (1790, 1), (1800, 1), (1810, 1), (1820, 1), (1830, 1), (1840, 1), (1850, 1), (1860, 1), (1870, 1), (1880, 1), (1890, 1), (1900, 1), (1910, 1), (1920, 1), (1930, 1), (1940, 1), (1950, 0), (1960, 0), (1970, 0), (1980, 1), (1990, 1), (2000, 1), (2010, 1), (2020, 0), (2030, 0), (2040, 0), (2050, 0)]
Vdin1_30  din1_30  0 PWL (0n 0.0v 9.495n 0.0v 9.505n 3.3v 19.495n 3.3v 19.505n 0.0v 29.495n 0.0v 29.505n 0.0v 39.495n 0.0v 39.505n 0.0v 49.495n 0.0v 49.505n 3.3v 59.495n 3.3v 59.505n 0.0v 69.495n 0.0v 69.505n 3.3v 79.495n 3.3v 79.505n 3.3v 89.495n 3.3v 89.505n 3.3v 99.495n 3.3v 99.505n 0.0v 109.495n 0.0v 109.505n 0.0v 119.495n 0.0v 119.505n 0.0v 129.495n 0.0v 129.505n 0.0v 139.495n 0.0v 139.505n 0.0v 149.495n 0.0v 149.505n 0.0v 159.495n 0.0v 159.505n 3.3v 169.495n 3.3v 169.505n 3.3v 179.495n 3.3v 179.505n 3.3v 189.495n 3.3v 189.505n 3.3v 199.495n 3.3v 199.505n 3.3v 209.495n 3.3v 209.505n 3.3v 219.495n 3.3v 219.505n 3.3v 229.495n 3.3v 229.505n 0.0v 239.495n 0.0v 239.505n 0.0v 249.495n 0.0v 249.505n 0.0v 259.495n 0.0v 259.505n 0.0v 269.495n 0.0v 269.505n 0.0v 279.495n 0.0v 279.505n 0.0v 289.495n 0.0v 289.505n 0.0v 299.495n 0.0v 299.505n 0.0v 309.495n 0.0v 309.505n 0.0v 319.495n 0.0v 319.505n 0.0v 329.495n 0.0v 329.505n 0.0v 339.495n 0.0v 339.505n 0.0v 349.495n 0.0v 349.505n 0.0v 359.495n 0.0v 359.505n 3.3v 369.495n 3.3v 369.505n 3.3v 379.495n 3.3v 379.505n 3.3v 389.495n 3.3v 389.505n 3.3v 399.495n 3.3v 399.505n 3.3v 409.495n 3.3v 409.505n 3.3v 419.495n 3.3v 419.505n 3.3v 429.495n 3.3v 429.505n 3.3v 439.495n 3.3v 439.505n 3.3v 449.495n 3.3v 449.505n 3.3v 459.495n 3.3v 459.505n 3.3v 469.495n 3.3v 469.505n 3.3v 479.495n 3.3v 479.505n 3.3v 489.495n 3.3v 489.505n 3.3v 499.495n 3.3v 499.505n 3.3v 509.495n 3.3v 509.505n 3.3v 519.495n 3.3v 519.505n 3.3v 529.495n 3.3v 529.505n 3.3v 539.495n 3.3v 539.505n 0.0v 549.495n 0.0v 549.505n 0.0v 559.495n 0.0v 559.505n 0.0v 569.495n 0.0v 569.505n 0.0v 579.495n 0.0v 579.505n 0.0v 589.495n 0.0v 589.505n 0.0v 599.495n 0.0v 599.505n 0.0v 609.495n 0.0v 609.505n 0.0v 619.495n 0.0v 619.505n 0.0v 629.495n 0.0v 629.505n 0.0v 639.495n 0.0v 639.505n 0.0v 649.495n 0.0v 649.505n 0.0v 659.495n 0.0v 659.505n 0.0v 669.495n 0.0v 669.505n 0.0v 679.495n 0.0v 679.505n 0.0v 689.495n 0.0v 689.505n 0.0v 699.495n 0.0v 699.505n 0.0v 709.495n 0.0v 709.505n 0.0v 719.495n 0.0v 719.505n 0.0v 729.495n 0.0v 729.505n 0.0v 739.495n 0.0v 739.505n 0.0v 749.495n 0.0v 749.505n 3.3v 759.495n 3.3v 759.505n 3.3v 769.495n 3.3v 769.505n 0.0v 779.495n 0.0v 779.505n 0.0v 789.495n 0.0v 789.505n 0.0v 799.495n 0.0v 799.505n 3.3v 809.495n 3.3v 809.505n 3.3v 819.495n 3.3v 819.505n 0.0v 829.495n 0.0v 829.505n 0.0v 839.495n 0.0v 839.505n 0.0v 849.495n 0.0v 849.505n 0.0v 859.495n 0.0v 859.505n 0.0v 869.495n 0.0v 869.505n 0.0v 879.495n 0.0v 879.505n 0.0v 889.495n 0.0v 889.505n 0.0v 899.495n 0.0v 899.505n 0.0v 909.495n 0.0v 909.505n 0.0v 919.495n 0.0v 919.505n 0.0v 929.495n 0.0v 929.505n 0.0v 939.495n 0.0v 939.505n 3.3v 949.495n 3.3v 949.505n 3.3v 959.495n 3.3v 959.505n 0.0v 969.495n 0.0v 969.505n 0.0v 979.495n 0.0v 979.505n 0.0v 989.495n 0.0v 989.505n 0.0v 999.495n 0.0v 999.505n 3.3v 1009.495n 3.3v 1009.505n 3.3v 1019.495n 3.3v 1019.505n 3.3v 1029.495n 3.3v 1029.505n 3.3v 1039.495n 3.3v 1039.505n 3.3v 1049.495n 3.3v 1049.505n 3.3v 1059.495n 3.3v 1059.505n 3.3v 1069.495n 3.3v 1069.505n 3.3v 1079.495n 3.3v 1079.505n 0.0v 1089.495n 0.0v 1089.505n 0.0v 1099.495n 0.0v 1099.505n 0.0v 1109.495n 0.0v 1109.505n 0.0v 1119.495n 0.0v 1119.505n 0.0v 1129.495n 0.0v 1129.505n 0.0v 1139.495n 0.0v 1139.505n 0.0v 1149.495n 0.0v 1149.505n 0.0v 1159.495n 0.0v 1159.505n 0.0v 1169.495n 0.0v 1169.505n 0.0v 1179.495n 0.0v 1179.505n 0.0v 1189.495n 0.0v 1189.505n 0.0v 1199.495n 0.0v 1199.505n 0.0v 1209.495n 0.0v 1209.505n 0.0v 1219.495n 0.0v 1219.505n 0.0v 1229.495n 0.0v 1229.505n 0.0v 1239.495n 0.0v 1239.505n 3.3v 1249.495n 3.3v 1249.505n 3.3v 1259.495n 3.3v 1259.505n 3.3v 1269.495n 3.3v 1269.505n 3.3v 1279.495n 3.3v 1279.505n 0.0v 1289.495n 0.0v 1289.505n 0.0v 1299.495n 0.0v 1299.505n 0.0v 1309.495n 0.0v 1309.505n 0.0v 1319.495n 0.0v 1319.505n 3.3v 1329.495n 3.3v 1329.505n 3.3v 1339.495n 3.3v 1339.505n 0.0v 1349.495n 0.0v 1349.505n 0.0v 1359.495n 0.0v 1359.505n 0.0v 1369.495n 0.0v 1369.505n 0.0v 1379.495n 0.0v 1379.505n 0.0v 1389.495n 0.0v 1389.505n 0.0v 1399.495n 0.0v 1399.505n 0.0v 1409.495n 0.0v 1409.505n 0.0v 1419.495n 0.0v 1419.505n 0.0v 1429.495n 0.0v 1429.505n 3.3v 1439.495n 3.3v 1439.505n 0.0v 1449.495n 0.0v 1449.505n 0.0v 1459.495n 0.0v 1459.505n 0.0v 1469.495n 0.0v 1469.505n 3.3v 1479.495n 3.3v 1479.505n 0.0v 1489.495n 0.0v 1489.505n 0.0v 1499.495n 0.0v 1499.505n 0.0v 1509.495n 0.0v 1509.505n 0.0v 1519.495n 0.0v 1519.505n 0.0v 1529.495n 0.0v 1529.505n 0.0v 1539.495n 0.0v 1539.505n 0.0v 1549.495n 0.0v 1549.505n 3.3v 1559.495n 3.3v 1559.505n 3.3v 1569.495n 3.3v 1569.505n 3.3v 1579.495n 3.3v 1579.505n 3.3v 1589.495n 3.3v 1589.505n 3.3v 1599.495n 3.3v 1599.505n 3.3v 1609.495n 3.3v 1609.505n 0.0v 1619.495n 0.0v 1619.505n 0.0v 1629.495n 0.0v 1629.505n 0.0v 1639.495n 0.0v 1639.505n 0.0v 1649.495n 0.0v 1649.505n 0.0v 1659.495n 0.0v 1659.505n 0.0v 1669.495n 0.0v 1669.505n 0.0v 1679.495n 0.0v 1679.505n 3.3v 1689.495n 3.3v 1689.505n 3.3v 1699.495n 3.3v 1699.505n 3.3v 1709.495n 3.3v 1709.505n 3.3v 1719.495n 3.3v 1719.505n 3.3v 1729.495n 3.3v 1729.505n 3.3v 1739.495n 3.3v 1739.505n 3.3v 1749.495n 3.3v 1749.505n 3.3v 1759.495n 3.3v 1759.505n 3.3v 1769.495n 3.3v 1769.505n 3.3v 1779.495n 3.3v 1779.505n 3.3v 1789.495n 3.3v 1789.505n 3.3v 1799.495n 3.3v 1799.505n 3.3v 1809.495n 3.3v 1809.505n 3.3v 1819.495n 3.3v 1819.505n 3.3v 1829.495n 3.3v 1829.505n 3.3v 1839.495n 3.3v 1839.505n 3.3v 1849.495n 3.3v 1849.505n 3.3v 1859.495n 3.3v 1859.505n 3.3v 1869.495n 3.3v 1869.505n 3.3v 1879.495n 3.3v 1879.505n 3.3v 1889.495n 3.3v 1889.505n 3.3v 1899.495n 3.3v 1899.505n 3.3v 1909.495n 3.3v 1909.505n 3.3v 1919.495n 3.3v 1919.505n 3.3v 1929.495n 3.3v 1929.505n 3.3v 1939.495n 3.3v 1939.505n 3.3v 1949.495n 3.3v 1949.505n 0.0v 1959.495n 0.0v 1959.505n 0.0v 1969.495n 0.0v 1969.505n 0.0v 1979.495n 0.0v 1979.505n 3.3v 1989.495n 3.3v 1989.505n 3.3v 1999.495n 3.3v 1999.505n 3.3v 2009.495n 3.3v 2009.505n 3.3v 2019.495n 3.3v 2019.505n 0.0v 2029.495n 0.0v 2029.505n 0.0v 2039.495n 0.0v 2039.505n 0.0v 2049.495n 0.0v 2049.505n 0.0v )
* (time, data): [(0, 0), (10, 1), (20, 1), (30, 1), (40, 1), (50, 1), (60, 0), (70, 0), (80, 0), (90, 0), (100, 1), (110, 1), (120, 1), (130, 1), (140, 1), (150, 0), (160, 0), (170, 0), (180, 0), (190, 0), (200, 0), (210, 0), (220, 0), (230, 1), (240, 1), (250, 1), (260, 1), (270, 1), (280, 1), (290, 1), (300, 1), (310, 1), (320, 1), (330, 0), (340, 0), (350, 0), (360, 1), (370, 1), (380, 1), (390, 1), (400, 1), (410, 1), (420, 1), (430, 1), (440, 0), (450, 0), (460, 0), (470, 0), (480, 0), (490, 0), (500, 0), (510, 0), (520, 0), (530, 0), (540, 0), (550, 0), (560, 0), (570, 0), (580, 0), (590, 0), (600, 0), (610, 0), (620, 0), (630, 1), (640, 1), (650, 1), (660, 1), (670, 1), (680, 1), (690, 1), (700, 1), (710, 1), (720, 1), (730, 1), (740, 0), (750, 0), (760, 0), (770, 0), (780, 0), (790, 0), (800, 1), (810, 1), (820, 1), (830, 1), (840, 1), (850, 1), (860, 1), (870, 1), (880, 1), (890, 1), (900, 1), (910, 0), (920, 0), (930, 0), (940, 0), (950, 0), (960, 1), (970, 1), (980, 1), (990, 1), (1000, 1), (1010, 1), (1020, 1), (1030, 1), (1040, 1), (1050, 1), (1060, 1), (1070, 1), (1080, 1), (1090, 1), (1100, 1), (1110, 1), (1120, 1), (1130, 1), (1140, 1), (1150, 1), (1160, 1), (1170, 1), (1180, 1), (1190, 1), (1200, 1), (1210, 1), (1220, 1), (1230, 1), (1240, 1), (1250, 1), (1260, 1), (1270, 1), (1280, 1), (1290, 1), (1300, 1), (1310, 1), (1320, 0), (1330, 0), (1340, 0), (1350, 0), (1360, 1), (1370, 1), (1380, 1), (1390, 1), (1400, 1), (1410, 1), (1420, 1), (1430, 0), (1440, 0), (1450, 0), (1460, 0), (1470, 0), (1480, 0), (1490, 0), (1500, 0), (1510, 0), (1520, 0), (1530, 0), (1540, 0), (1550, 1), (1560, 1), (1570, 0), (1580, 0), (1590, 0), (1600, 0), (1610, 0), (1620, 0), (1630, 0), (1640, 0), (1650, 0), (1660, 0), (1670, 0), (1680, 0), (1690, 0), (1700, 0), (1710, 0), (1720, 0), (1730, 0), (1740, 0), (1750, 0), (1760, 0), (1770, 0), (1780, 0), (1790, 1), (1800, 1), (1810, 1), (1820, 1), (1830, 1), (1840, 1), (1850, 1), (1860, 1), (1870, 1), (1880, 1), (1890, 1), (1900, 1), (1910, 1), (1920, 1), (1930, 1), (1940, 1), (1950, 0), (1960, 0), (1970, 0), (1980, 1), (1990, 1), (2000, 1), (2010, 1), (2020, 0), (2030, 1), (2040, 1), (2050, 1)]
Vdin1_31  din1_31  0 PWL (0n 0.0v 9.495n 0.0v 9.505n 3.3v 19.495n 3.3v 19.505n 3.3v 29.495n 3.3v 29.505n 3.3v 39.495n 3.3v 39.505n 3.3v 49.495n 3.3v 49.505n 3.3v 59.495n 3.3v 59.505n 0.0v 69.495n 0.0v 69.505n 0.0v 79.495n 0.0v 79.505n 0.0v 89.495n 0.0v 89.505n 0.0v 99.495n 0.0v 99.505n 3.3v 109.495n 3.3v 109.505n 3.3v 119.495n 3.3v 119.505n 3.3v 129.495n 3.3v 129.505n 3.3v 139.495n 3.3v 139.505n 3.3v 149.495n 3.3v 149.505n 0.0v 159.495n 0.0v 159.505n 0.0v 169.495n 0.0v 169.505n 0.0v 179.495n 0.0v 179.505n 0.0v 189.495n 0.0v 189.505n 0.0v 199.495n 0.0v 199.505n 0.0v 209.495n 0.0v 209.505n 0.0v 219.495n 0.0v 219.505n 0.0v 229.495n 0.0v 229.505n 3.3v 239.495n 3.3v 239.505n 3.3v 249.495n 3.3v 249.505n 3.3v 259.495n 3.3v 259.505n 3.3v 269.495n 3.3v 269.505n 3.3v 279.495n 3.3v 279.505n 3.3v 289.495n 3.3v 289.505n 3.3v 299.495n 3.3v 299.505n 3.3v 309.495n 3.3v 309.505n 3.3v 319.495n 3.3v 319.505n 3.3v 329.495n 3.3v 329.505n 0.0v 339.495n 0.0v 339.505n 0.0v 349.495n 0.0v 349.505n 0.0v 359.495n 0.0v 359.505n 3.3v 369.495n 3.3v 369.505n 3.3v 379.495n 3.3v 379.505n 3.3v 389.495n 3.3v 389.505n 3.3v 399.495n 3.3v 399.505n 3.3v 409.495n 3.3v 409.505n 3.3v 419.495n 3.3v 419.505n 3.3v 429.495n 3.3v 429.505n 3.3v 439.495n 3.3v 439.505n 0.0v 449.495n 0.0v 449.505n 0.0v 459.495n 0.0v 459.505n 0.0v 469.495n 0.0v 469.505n 0.0v 479.495n 0.0v 479.505n 0.0v 489.495n 0.0v 489.505n 0.0v 499.495n 0.0v 499.505n 0.0v 509.495n 0.0v 509.505n 0.0v 519.495n 0.0v 519.505n 0.0v 529.495n 0.0v 529.505n 0.0v 539.495n 0.0v 539.505n 0.0v 549.495n 0.0v 549.505n 0.0v 559.495n 0.0v 559.505n 0.0v 569.495n 0.0v 569.505n 0.0v 579.495n 0.0v 579.505n 0.0v 589.495n 0.0v 589.505n 0.0v 599.495n 0.0v 599.505n 0.0v 609.495n 0.0v 609.505n 0.0v 619.495n 0.0v 619.505n 0.0v 629.495n 0.0v 629.505n 3.3v 639.495n 3.3v 639.505n 3.3v 649.495n 3.3v 649.505n 3.3v 659.495n 3.3v 659.505n 3.3v 669.495n 3.3v 669.505n 3.3v 679.495n 3.3v 679.505n 3.3v 689.495n 3.3v 689.505n 3.3v 699.495n 3.3v 699.505n 3.3v 709.495n 3.3v 709.505n 3.3v 719.495n 3.3v 719.505n 3.3v 729.495n 3.3v 729.505n 3.3v 739.495n 3.3v 739.505n 0.0v 749.495n 0.0v 749.505n 0.0v 759.495n 0.0v 759.505n 0.0v 769.495n 0.0v 769.505n 0.0v 779.495n 0.0v 779.505n 0.0v 789.495n 0.0v 789.505n 0.0v 799.495n 0.0v 799.505n 3.3v 809.495n 3.3v 809.505n 3.3v 819.495n 3.3v 819.505n 3.3v 829.495n 3.3v 829.505n 3.3v 839.495n 3.3v 839.505n 3.3v 849.495n 3.3v 849.505n 3.3v 859.495n 3.3v 859.505n 3.3v 869.495n 3.3v 869.505n 3.3v 879.495n 3.3v 879.505n 3.3v 889.495n 3.3v 889.505n 3.3v 899.495n 3.3v 899.505n 3.3v 909.495n 3.3v 909.505n 0.0v 919.495n 0.0v 919.505n 0.0v 929.495n 0.0v 929.505n 0.0v 939.495n 0.0v 939.505n 0.0v 949.495n 0.0v 949.505n 0.0v 959.495n 0.0v 959.505n 3.3v 969.495n 3.3v 969.505n 3.3v 979.495n 3.3v 979.505n 3.3v 989.495n 3.3v 989.505n 3.3v 999.495n 3.3v 999.505n 3.3v 1009.495n 3.3v 1009.505n 3.3v 1019.495n 3.3v 1019.505n 3.3v 1029.495n 3.3v 1029.505n 3.3v 1039.495n 3.3v 1039.505n 3.3v 1049.495n 3.3v 1049.505n 3.3v 1059.495n 3.3v 1059.505n 3.3v 1069.495n 3.3v 1069.505n 3.3v 1079.495n 3.3v 1079.505n 3.3v 1089.495n 3.3v 1089.505n 3.3v 1099.495n 3.3v 1099.505n 3.3v 1109.495n 3.3v 1109.505n 3.3v 1119.495n 3.3v 1119.505n 3.3v 1129.495n 3.3v 1129.505n 3.3v 1139.495n 3.3v 1139.505n 3.3v 1149.495n 3.3v 1149.505n 3.3v 1159.495n 3.3v 1159.505n 3.3v 1169.495n 3.3v 1169.505n 3.3v 1179.495n 3.3v 1179.505n 3.3v 1189.495n 3.3v 1189.505n 3.3v 1199.495n 3.3v 1199.505n 3.3v 1209.495n 3.3v 1209.505n 3.3v 1219.495n 3.3v 1219.505n 3.3v 1229.495n 3.3v 1229.505n 3.3v 1239.495n 3.3v 1239.505n 3.3v 1249.495n 3.3v 1249.505n 3.3v 1259.495n 3.3v 1259.505n 3.3v 1269.495n 3.3v 1269.505n 3.3v 1279.495n 3.3v 1279.505n 3.3v 1289.495n 3.3v 1289.505n 3.3v 1299.495n 3.3v 1299.505n 3.3v 1309.495n 3.3v 1309.505n 3.3v 1319.495n 3.3v 1319.505n 0.0v 1329.495n 0.0v 1329.505n 0.0v 1339.495n 0.0v 1339.505n 0.0v 1349.495n 0.0v 1349.505n 0.0v 1359.495n 0.0v 1359.505n 3.3v 1369.495n 3.3v 1369.505n 3.3v 1379.495n 3.3v 1379.505n 3.3v 1389.495n 3.3v 1389.505n 3.3v 1399.495n 3.3v 1399.505n 3.3v 1409.495n 3.3v 1409.505n 3.3v 1419.495n 3.3v 1419.505n 3.3v 1429.495n 3.3v 1429.505n 0.0v 1439.495n 0.0v 1439.505n 0.0v 1449.495n 0.0v 1449.505n 0.0v 1459.495n 0.0v 1459.505n 0.0v 1469.495n 0.0v 1469.505n 0.0v 1479.495n 0.0v 1479.505n 0.0v 1489.495n 0.0v 1489.505n 0.0v 1499.495n 0.0v 1499.505n 0.0v 1509.495n 0.0v 1509.505n 0.0v 1519.495n 0.0v 1519.505n 0.0v 1529.495n 0.0v 1529.505n 0.0v 1539.495n 0.0v 1539.505n 0.0v 1549.495n 0.0v 1549.505n 3.3v 1559.495n 3.3v 1559.505n 3.3v 1569.495n 3.3v 1569.505n 0.0v 1579.495n 0.0v 1579.505n 0.0v 1589.495n 0.0v 1589.505n 0.0v 1599.495n 0.0v 1599.505n 0.0v 1609.495n 0.0v 1609.505n 0.0v 1619.495n 0.0v 1619.505n 0.0v 1629.495n 0.0v 1629.505n 0.0v 1639.495n 0.0v 1639.505n 0.0v 1649.495n 0.0v 1649.505n 0.0v 1659.495n 0.0v 1659.505n 0.0v 1669.495n 0.0v 1669.505n 0.0v 1679.495n 0.0v 1679.505n 0.0v 1689.495n 0.0v 1689.505n 0.0v 1699.495n 0.0v 1699.505n 0.0v 1709.495n 0.0v 1709.505n 0.0v 1719.495n 0.0v 1719.505n 0.0v 1729.495n 0.0v 1729.505n 0.0v 1739.495n 0.0v 1739.505n 0.0v 1749.495n 0.0v 1749.505n 0.0v 1759.495n 0.0v 1759.505n 0.0v 1769.495n 0.0v 1769.505n 0.0v 1779.495n 0.0v 1779.505n 0.0v 1789.495n 0.0v 1789.505n 3.3v 1799.495n 3.3v 1799.505n 3.3v 1809.495n 3.3v 1809.505n 3.3v 1819.495n 3.3v 1819.505n 3.3v 1829.495n 3.3v 1829.505n 3.3v 1839.495n 3.3v 1839.505n 3.3v 1849.495n 3.3v 1849.505n 3.3v 1859.495n 3.3v 1859.505n 3.3v 1869.495n 3.3v 1869.505n 3.3v 1879.495n 3.3v 1879.505n 3.3v 1889.495n 3.3v 1889.505n 3.3v 1899.495n 3.3v 1899.505n 3.3v 1909.495n 3.3v 1909.505n 3.3v 1919.495n 3.3v 1919.505n 3.3v 1929.495n 3.3v 1929.505n 3.3v 1939.495n 3.3v 1939.505n 3.3v 1949.495n 3.3v 1949.505n 0.0v 1959.495n 0.0v 1959.505n 0.0v 1969.495n 0.0v 1969.505n 0.0v 1979.495n 0.0v 1979.505n 3.3v 1989.495n 3.3v 1989.505n 3.3v 1999.495n 3.3v 1999.505n 3.3v 2009.495n 3.3v 2009.505n 3.3v 2019.495n 3.3v 2019.505n 0.0v 2029.495n 0.0v 2029.505n 3.3v 2039.495n 3.3v 2039.505n 3.3v 2049.495n 3.3v 2049.505n 3.3v )
* (time, data): [(0, 0), (10, 0), (20, 0), (30, 0), (40, 0), (50, 0), (60, 0), (70, 0), (80, 0), (90, 0), (100, 0), (110, 0), (120, 0), (130, 0), (140, 0), (150, 0), (160, 0), (170, 0), (180, 0), (190, 0), (200, 0), (210, 0), (220, 0), (230, 0), (240, 0), (250, 0), (260, 0), (270, 0), (280, 0), (290, 0), (300, 0), (310, 0), (320, 0), (330, 0), (340, 0), (350, 0), (360, 0), (370, 0), (380, 0), (390, 0), (400, 0), (410, 0), (420, 0), (430, 0), (440, 0), (450, 0), (460, 0), (470, 0), (480, 0), (490, 0), (500, 0), (510, 0), (520, 0), (530, 0), (540, 0), (550, 0), (560, 0), (570, 0), (580, 0), (590, 0), (600, 0), (610, 0), (620, 0), (630, 0), (640, 0), (650, 0), (660, 0), (670, 0), (680, 0), (690, 0), (700, 0), (710, 0), (720, 0), (730, 0), (740, 0), (750, 0), (760, 0), (770, 0), (780, 0), (790, 0), (800, 0), (810, 0), (820, 0), (830, 0), (840, 0), (850, 0), (860, 0), (870, 0), (880, 0), (890, 0), (900, 0), (910, 0), (920, 0), (930, 0), (940, 0), (950, 0), (960, 0), (970, 0), (980, 0), (990, 0), (1000, 0), (1010, 0), (1020, 0), (1030, 0), (1040, 0), (1050, 0), (1060, 0), (1070, 0), (1080, 0), (1090, 0), (1100, 0), (1110, 0), (1120, 0), (1130, 0), (1140, 0), (1150, 0), (1160, 0), (1170, 0), (1180, 0), (1190, 0), (1200, 0), (1210, 0), (1220, 0), (1230, 0), (1240, 0), (1250, 0), (1260, 0), (1270, 0), (1280, 0), (1290, 0), (1300, 0), (1310, 0), (1320, 0), (1330, 0), (1340, 0), (1350, 0), (1360, 0), (1370, 0), (1380, 0), (1390, 0), (1400, 0), (1410, 0), (1420, 0), (1430, 0), (1440, 0), (1450, 0), (1460, 0), (1470, 0), (1480, 0), (1490, 0), (1500, 0), (1510, 0), (1520, 0), (1530, 0), (1540, 0), (1550, 0), (1560, 0), (1570, 0), (1580, 0), (1590, 0), (1600, 0), (1610, 0), (1620, 0), (1630, 0), (1640, 0), (1650, 0), (1660, 0), (1670, 0), (1680, 0), (1690, 0), (1700, 0), (1710, 0), (1720, 0), (1730, 0), (1740, 0), (1750, 0), (1760, 0), (1770, 0), (1780, 0), (1790, 0), (1800, 0), (1810, 0), (1820, 0), (1830, 0), (1840, 0), (1850, 0), (1860, 0), (1870, 0), (1880, 0), (1890, 0), (1900, 0), (1910, 0), (1920, 0), (1930, 0), (1940, 0), (1950, 0), (1960, 0), (1970, 0), (1980, 0), (1990, 0), (2000, 0), (2010, 0), (2020, 0), (2030, 0), (2040, 0), (2050, 0)]
Va0_0  a0_0  0 PWL (0n 0.0v 9.495n 0.0v 9.505n 0.0v 19.495n 0.0v 19.505n 0.0v 29.495n 0.0v 29.505n 0.0v 39.495n 0.0v 39.505n 0.0v 49.495n 0.0v 49.505n 0.0v 59.495n 0.0v 59.505n 0.0v 69.495n 0.0v 69.505n 0.0v 79.495n 0.0v 79.505n 0.0v 89.495n 0.0v 89.505n 0.0v 99.495n 0.0v 99.505n 0.0v 109.495n 0.0v 109.505n 0.0v 119.495n 0.0v 119.505n 0.0v 129.495n 0.0v 129.505n 0.0v 139.495n 0.0v 139.505n 0.0v 149.495n 0.0v 149.505n 0.0v 159.495n 0.0v 159.505n 0.0v 169.495n 0.0v 169.505n 0.0v 179.495n 0.0v 179.505n 0.0v 189.495n 0.0v 189.505n 0.0v 199.495n 0.0v 199.505n 0.0v 209.495n 0.0v 209.505n 0.0v 219.495n 0.0v 219.505n 0.0v 229.495n 0.0v 229.505n 0.0v 239.495n 0.0v 239.505n 0.0v 249.495n 0.0v 249.505n 0.0v 259.495n 0.0v 259.505n 0.0v 269.495n 0.0v 269.505n 0.0v 279.495n 0.0v 279.505n 0.0v 289.495n 0.0v 289.505n 0.0v 299.495n 0.0v 299.505n 0.0v 309.495n 0.0v 309.505n 0.0v 319.495n 0.0v 319.505n 0.0v 329.495n 0.0v 329.505n 0.0v 339.495n 0.0v 339.505n 0.0v 349.495n 0.0v 349.505n 0.0v 359.495n 0.0v 359.505n 0.0v 369.495n 0.0v 369.505n 0.0v 379.495n 0.0v 379.505n 0.0v 389.495n 0.0v 389.505n 0.0v 399.495n 0.0v 399.505n 0.0v 409.495n 0.0v 409.505n 0.0v 419.495n 0.0v 419.505n 0.0v 429.495n 0.0v 429.505n 0.0v 439.495n 0.0v 439.505n 0.0v 449.495n 0.0v 449.505n 0.0v 459.495n 0.0v 459.505n 0.0v 469.495n 0.0v 469.505n 0.0v 479.495n 0.0v 479.505n 0.0v 489.495n 0.0v 489.505n 0.0v 499.495n 0.0v 499.505n 0.0v 509.495n 0.0v 509.505n 0.0v 519.495n 0.0v 519.505n 0.0v 529.495n 0.0v 529.505n 0.0v 539.495n 0.0v 539.505n 0.0v 549.495n 0.0v 549.505n 0.0v 559.495n 0.0v 559.505n 0.0v 569.495n 0.0v 569.505n 0.0v 579.495n 0.0v 579.505n 0.0v 589.495n 0.0v 589.505n 0.0v 599.495n 0.0v 599.505n 0.0v 609.495n 0.0v 609.505n 0.0v 619.495n 0.0v 619.505n 0.0v 629.495n 0.0v 629.505n 0.0v 639.495n 0.0v 639.505n 0.0v 649.495n 0.0v 649.505n 0.0v 659.495n 0.0v 659.505n 0.0v 669.495n 0.0v 669.505n 0.0v 679.495n 0.0v 679.505n 0.0v 689.495n 0.0v 689.505n 0.0v 699.495n 0.0v 699.505n 0.0v 709.495n 0.0v 709.505n 0.0v 719.495n 0.0v 719.505n 0.0v 729.495n 0.0v 729.505n 0.0v 739.495n 0.0v 739.505n 0.0v 749.495n 0.0v 749.505n 0.0v 759.495n 0.0v 759.505n 0.0v 769.495n 0.0v 769.505n 0.0v 779.495n 0.0v 779.505n 0.0v 789.495n 0.0v 789.505n 0.0v 799.495n 0.0v 799.505n 0.0v 809.495n 0.0v 809.505n 0.0v 819.495n 0.0v 819.505n 0.0v 829.495n 0.0v 829.505n 0.0v 839.495n 0.0v 839.505n 0.0v 849.495n 0.0v 849.505n 0.0v 859.495n 0.0v 859.505n 0.0v 869.495n 0.0v 869.505n 0.0v 879.495n 0.0v 879.505n 0.0v 889.495n 0.0v 889.505n 0.0v 899.495n 0.0v 899.505n 0.0v 909.495n 0.0v 909.505n 0.0v 919.495n 0.0v 919.505n 0.0v 929.495n 0.0v 929.505n 0.0v 939.495n 0.0v 939.505n 0.0v 949.495n 0.0v 949.505n 0.0v 959.495n 0.0v 959.505n 0.0v 969.495n 0.0v 969.505n 0.0v 979.495n 0.0v 979.505n 0.0v 989.495n 0.0v 989.505n 0.0v 999.495n 0.0v 999.505n 0.0v 1009.495n 0.0v 1009.505n 0.0v 1019.495n 0.0v 1019.505n 0.0v 1029.495n 0.0v 1029.505n 0.0v 1039.495n 0.0v 1039.505n 0.0v 1049.495n 0.0v 1049.505n 0.0v 1059.495n 0.0v 1059.505n 0.0v 1069.495n 0.0v 1069.505n 0.0v 1079.495n 0.0v 1079.505n 0.0v 1089.495n 0.0v 1089.505n 0.0v 1099.495n 0.0v 1099.505n 0.0v 1109.495n 0.0v 1109.505n 0.0v 1119.495n 0.0v 1119.505n 0.0v 1129.495n 0.0v 1129.505n 0.0v 1139.495n 0.0v 1139.505n 0.0v 1149.495n 0.0v 1149.505n 0.0v 1159.495n 0.0v 1159.505n 0.0v 1169.495n 0.0v 1169.505n 0.0v 1179.495n 0.0v 1179.505n 0.0v 1189.495n 0.0v 1189.505n 0.0v 1199.495n 0.0v 1199.505n 0.0v 1209.495n 0.0v 1209.505n 0.0v 1219.495n 0.0v 1219.505n 0.0v 1229.495n 0.0v 1229.505n 0.0v 1239.495n 0.0v 1239.505n 0.0v 1249.495n 0.0v 1249.505n 0.0v 1259.495n 0.0v 1259.505n 0.0v 1269.495n 0.0v 1269.505n 0.0v 1279.495n 0.0v 1279.505n 0.0v 1289.495n 0.0v 1289.505n 0.0v 1299.495n 0.0v 1299.505n 0.0v 1309.495n 0.0v 1309.505n 0.0v 1319.495n 0.0v 1319.505n 0.0v 1329.495n 0.0v 1329.505n 0.0v 1339.495n 0.0v 1339.505n 0.0v 1349.495n 0.0v 1349.505n 0.0v 1359.495n 0.0v 1359.505n 0.0v 1369.495n 0.0v 1369.505n 0.0v 1379.495n 0.0v 1379.505n 0.0v 1389.495n 0.0v 1389.505n 0.0v 1399.495n 0.0v 1399.505n 0.0v 1409.495n 0.0v 1409.505n 0.0v 1419.495n 0.0v 1419.505n 0.0v 1429.495n 0.0v 1429.505n 0.0v 1439.495n 0.0v 1439.505n 0.0v 1449.495n 0.0v 1449.505n 0.0v 1459.495n 0.0v 1459.505n 0.0v 1469.495n 0.0v 1469.505n 0.0v 1479.495n 0.0v 1479.505n 0.0v 1489.495n 0.0v 1489.505n 0.0v 1499.495n 0.0v 1499.505n 0.0v 1509.495n 0.0v 1509.505n 0.0v 1519.495n 0.0v 1519.505n 0.0v 1529.495n 0.0v 1529.505n 0.0v 1539.495n 0.0v 1539.505n 0.0v 1549.495n 0.0v 1549.505n 0.0v 1559.495n 0.0v 1559.505n 0.0v 1569.495n 0.0v 1569.505n 0.0v 1579.495n 0.0v 1579.505n 0.0v 1589.495n 0.0v 1589.505n 0.0v 1599.495n 0.0v 1599.505n 0.0v 1609.495n 0.0v 1609.505n 0.0v 1619.495n 0.0v 1619.505n 0.0v 1629.495n 0.0v 1629.505n 0.0v 1639.495n 0.0v 1639.505n 0.0v 1649.495n 0.0v 1649.505n 0.0v 1659.495n 0.0v 1659.505n 0.0v 1669.495n 0.0v 1669.505n 0.0v 1679.495n 0.0v 1679.505n 0.0v 1689.495n 0.0v 1689.505n 0.0v 1699.495n 0.0v 1699.505n 0.0v 1709.495n 0.0v 1709.505n 0.0v 1719.495n 0.0v 1719.505n 0.0v 1729.495n 0.0v 1729.505n 0.0v 1739.495n 0.0v 1739.505n 0.0v 1749.495n 0.0v 1749.505n 0.0v 1759.495n 0.0v 1759.505n 0.0v 1769.495n 0.0v 1769.505n 0.0v 1779.495n 0.0v 1779.505n 0.0v 1789.495n 0.0v 1789.505n 0.0v 1799.495n 0.0v 1799.505n 0.0v 1809.495n 0.0v 1809.505n 0.0v 1819.495n 0.0v 1819.505n 0.0v 1829.495n 0.0v 1829.505n 0.0v 1839.495n 0.0v 1839.505n 0.0v 1849.495n 0.0v 1849.505n 0.0v 1859.495n 0.0v 1859.505n 0.0v 1869.495n 0.0v 1869.505n 0.0v 1879.495n 0.0v 1879.505n 0.0v 1889.495n 0.0v 1889.505n 0.0v 1899.495n 0.0v 1899.505n 0.0v 1909.495n 0.0v 1909.505n 0.0v 1919.495n 0.0v 1919.505n 0.0v 1929.495n 0.0v 1929.505n 0.0v 1939.495n 0.0v 1939.505n 0.0v 1949.495n 0.0v 1949.505n 0.0v 1959.495n 0.0v 1959.505n 0.0v 1969.495n 0.0v 1969.505n 0.0v 1979.495n 0.0v 1979.505n 0.0v 1989.495n 0.0v 1989.505n 0.0v 1999.495n 0.0v 1999.505n 0.0v 2009.495n 0.0v 2009.505n 0.0v 2019.495n 0.0v 2019.505n 0.0v 2029.495n 0.0v 2029.505n 0.0v 2039.495n 0.0v 2039.505n 0.0v 2049.495n 0.0v 2049.505n 0.0v )
* (time, data): [(0, 0), (10, 1), (20, 1), (30, 0), (40, 1), (50, 1), (60, 0), (70, 0), (80, 0), (90, 0), (100, 1), (110, 0), (120, 1), (130, 0), (140, 0), (150, 1), (160, 0), (170, 0), (180, 0), (190, 0), (200, 1), (210, 1), (220, 1), (230, 1), (240, 0), (250, 1), (260, 1), (270, 1), (280, 0), (290, 1), (300, 1), (310, 0), (320, 0), (330, 0), (340, 1), (350, 1), (360, 1), (370, 1), (380, 1), (390, 0), (400, 0), (410, 1), (420, 0), (430, 0), (440, 0), (450, 1), (460, 0), (470, 0), (480, 0), (490, 0), (500, 0), (510, 0), (520, 1), (530, 1), (540, 0), (550, 1), (560, 0), (570, 1), (580, 1), (590, 1), (600, 1), (610, 1), (620, 0), (630, 0), (640, 0), (650, 0), (660, 1), (670, 0), (680, 0), (690, 1), (700, 1), (710, 1), (720, 0), (730, 0), (740, 1), (750, 1), (760, 0), (770, 1), (780, 1), (790, 0), (800, 1), (810, 0), (820, 0), (830, 1), (840, 0), (850, 0), (860, 0), (870, 1), (880, 1), (890, 1), (900, 1), (910, 0), (920, 1), (930, 0), (940, 1), (950, 1), (960, 0), (970, 1), (980, 1), (990, 1), (1000, 1), (1010, 1), (1020, 0), (1030, 1), (1040, 1), (1050, 0), (1060, 1), (1070, 1), (1080, 1), (1090, 0), (1100, 0), (1110, 1), (1120, 1), (1130, 0), (1140, 0), (1150, 0), (1160, 0), (1170, 0), (1180, 1), (1190, 1), (1200, 1), (1210, 0), (1220, 1), (1230, 1), (1240, 1), (1250, 1), (1260, 1), (1270, 1), (1280, 1), (1290, 1), (1300, 0), (1310, 1), (1320, 1), (1330, 1), (1340, 1), (1350, 0), (1360, 1), (1370, 0), (1380, 1), (1390, 0), (1400, 0), (1410, 0), (1420, 1), (1430, 1), (1440, 0), (1450, 0), (1460, 0), (1470, 0), (1480, 0), (1490, 0), (1500, 0), (1510, 0), (1520, 1), (1530, 0), (1540, 1), (1550, 1), (1560, 1), (1570, 0), (1580, 0), (1590, 0), (1600, 0), (1610, 0), (1620, 0), (1630, 0), (1640, 1), (1650, 1), (1660, 1), (1670, 1), (1680, 1), (1690, 1), (1700, 1), (1710, 1), (1720, 1), (1730, 1), (1740, 0), (1750, 0), (1760, 0), (1770, 0), (1780, 1), (1790, 0), (1800, 0), (1810, 0), (1820, 0), (1830, 0), (1840, 1), (1850, 1), (1860, 1), (1870, 1), (1880, 1), (1890, 0), (1900, 0), (1910, 1), (1920, 1), (1930, 1), (1940, 1), (1950, 1), (1960, 0), (1970, 0), (1980, 0), (1990, 1), (2000, 1), (2010, 0), (2020, 1), (2030, 1), (2040, 1), (2050, 1)]
Va0_1  a0_1  0 PWL (0n 0.0v 9.495n 0.0v 9.505n 3.3v 19.495n 3.3v 19.505n 3.3v 29.495n 3.3v 29.505n 0.0v 39.495n 0.0v 39.505n 3.3v 49.495n 3.3v 49.505n 3.3v 59.495n 3.3v 59.505n 0.0v 69.495n 0.0v 69.505n 0.0v 79.495n 0.0v 79.505n 0.0v 89.495n 0.0v 89.505n 0.0v 99.495n 0.0v 99.505n 3.3v 109.495n 3.3v 109.505n 0.0v 119.495n 0.0v 119.505n 3.3v 129.495n 3.3v 129.505n 0.0v 139.495n 0.0v 139.505n 0.0v 149.495n 0.0v 149.505n 3.3v 159.495n 3.3v 159.505n 0.0v 169.495n 0.0v 169.505n 0.0v 179.495n 0.0v 179.505n 0.0v 189.495n 0.0v 189.505n 0.0v 199.495n 0.0v 199.505n 3.3v 209.495n 3.3v 209.505n 3.3v 219.495n 3.3v 219.505n 3.3v 229.495n 3.3v 229.505n 3.3v 239.495n 3.3v 239.505n 0.0v 249.495n 0.0v 249.505n 3.3v 259.495n 3.3v 259.505n 3.3v 269.495n 3.3v 269.505n 3.3v 279.495n 3.3v 279.505n 0.0v 289.495n 0.0v 289.505n 3.3v 299.495n 3.3v 299.505n 3.3v 309.495n 3.3v 309.505n 0.0v 319.495n 0.0v 319.505n 0.0v 329.495n 0.0v 329.505n 0.0v 339.495n 0.0v 339.505n 3.3v 349.495n 3.3v 349.505n 3.3v 359.495n 3.3v 359.505n 3.3v 369.495n 3.3v 369.505n 3.3v 379.495n 3.3v 379.505n 3.3v 389.495n 3.3v 389.505n 0.0v 399.495n 0.0v 399.505n 0.0v 409.495n 0.0v 409.505n 3.3v 419.495n 3.3v 419.505n 0.0v 429.495n 0.0v 429.505n 0.0v 439.495n 0.0v 439.505n 0.0v 449.495n 0.0v 449.505n 3.3v 459.495n 3.3v 459.505n 0.0v 469.495n 0.0v 469.505n 0.0v 479.495n 0.0v 479.505n 0.0v 489.495n 0.0v 489.505n 0.0v 499.495n 0.0v 499.505n 0.0v 509.495n 0.0v 509.505n 0.0v 519.495n 0.0v 519.505n 3.3v 529.495n 3.3v 529.505n 3.3v 539.495n 3.3v 539.505n 0.0v 549.495n 0.0v 549.505n 3.3v 559.495n 3.3v 559.505n 0.0v 569.495n 0.0v 569.505n 3.3v 579.495n 3.3v 579.505n 3.3v 589.495n 3.3v 589.505n 3.3v 599.495n 3.3v 599.505n 3.3v 609.495n 3.3v 609.505n 3.3v 619.495n 3.3v 619.505n 0.0v 629.495n 0.0v 629.505n 0.0v 639.495n 0.0v 639.505n 0.0v 649.495n 0.0v 649.505n 0.0v 659.495n 0.0v 659.505n 3.3v 669.495n 3.3v 669.505n 0.0v 679.495n 0.0v 679.505n 0.0v 689.495n 0.0v 689.505n 3.3v 699.495n 3.3v 699.505n 3.3v 709.495n 3.3v 709.505n 3.3v 719.495n 3.3v 719.505n 0.0v 729.495n 0.0v 729.505n 0.0v 739.495n 0.0v 739.505n 3.3v 749.495n 3.3v 749.505n 3.3v 759.495n 3.3v 759.505n 0.0v 769.495n 0.0v 769.505n 3.3v 779.495n 3.3v 779.505n 3.3v 789.495n 3.3v 789.505n 0.0v 799.495n 0.0v 799.505n 3.3v 809.495n 3.3v 809.505n 0.0v 819.495n 0.0v 819.505n 0.0v 829.495n 0.0v 829.505n 3.3v 839.495n 3.3v 839.505n 0.0v 849.495n 0.0v 849.505n 0.0v 859.495n 0.0v 859.505n 0.0v 869.495n 0.0v 869.505n 3.3v 879.495n 3.3v 879.505n 3.3v 889.495n 3.3v 889.505n 3.3v 899.495n 3.3v 899.505n 3.3v 909.495n 3.3v 909.505n 0.0v 919.495n 0.0v 919.505n 3.3v 929.495n 3.3v 929.505n 0.0v 939.495n 0.0v 939.505n 3.3v 949.495n 3.3v 949.505n 3.3v 959.495n 3.3v 959.505n 0.0v 969.495n 0.0v 969.505n 3.3v 979.495n 3.3v 979.505n 3.3v 989.495n 3.3v 989.505n 3.3v 999.495n 3.3v 999.505n 3.3v 1009.495n 3.3v 1009.505n 3.3v 1019.495n 3.3v 1019.505n 0.0v 1029.495n 0.0v 1029.505n 3.3v 1039.495n 3.3v 1039.505n 3.3v 1049.495n 3.3v 1049.505n 0.0v 1059.495n 0.0v 1059.505n 3.3v 1069.495n 3.3v 1069.505n 3.3v 1079.495n 3.3v 1079.505n 3.3v 1089.495n 3.3v 1089.505n 0.0v 1099.495n 0.0v 1099.505n 0.0v 1109.495n 0.0v 1109.505n 3.3v 1119.495n 3.3v 1119.505n 3.3v 1129.495n 3.3v 1129.505n 0.0v 1139.495n 0.0v 1139.505n 0.0v 1149.495n 0.0v 1149.505n 0.0v 1159.495n 0.0v 1159.505n 0.0v 1169.495n 0.0v 1169.505n 0.0v 1179.495n 0.0v 1179.505n 3.3v 1189.495n 3.3v 1189.505n 3.3v 1199.495n 3.3v 1199.505n 3.3v 1209.495n 3.3v 1209.505n 0.0v 1219.495n 0.0v 1219.505n 3.3v 1229.495n 3.3v 1229.505n 3.3v 1239.495n 3.3v 1239.505n 3.3v 1249.495n 3.3v 1249.505n 3.3v 1259.495n 3.3v 1259.505n 3.3v 1269.495n 3.3v 1269.505n 3.3v 1279.495n 3.3v 1279.505n 3.3v 1289.495n 3.3v 1289.505n 3.3v 1299.495n 3.3v 1299.505n 0.0v 1309.495n 0.0v 1309.505n 3.3v 1319.495n 3.3v 1319.505n 3.3v 1329.495n 3.3v 1329.505n 3.3v 1339.495n 3.3v 1339.505n 3.3v 1349.495n 3.3v 1349.505n 0.0v 1359.495n 0.0v 1359.505n 3.3v 1369.495n 3.3v 1369.505n 0.0v 1379.495n 0.0v 1379.505n 3.3v 1389.495n 3.3v 1389.505n 0.0v 1399.495n 0.0v 1399.505n 0.0v 1409.495n 0.0v 1409.505n 0.0v 1419.495n 0.0v 1419.505n 3.3v 1429.495n 3.3v 1429.505n 3.3v 1439.495n 3.3v 1439.505n 0.0v 1449.495n 0.0v 1449.505n 0.0v 1459.495n 0.0v 1459.505n 0.0v 1469.495n 0.0v 1469.505n 0.0v 1479.495n 0.0v 1479.505n 0.0v 1489.495n 0.0v 1489.505n 0.0v 1499.495n 0.0v 1499.505n 0.0v 1509.495n 0.0v 1509.505n 0.0v 1519.495n 0.0v 1519.505n 3.3v 1529.495n 3.3v 1529.505n 0.0v 1539.495n 0.0v 1539.505n 3.3v 1549.495n 3.3v 1549.505n 3.3v 1559.495n 3.3v 1559.505n 3.3v 1569.495n 3.3v 1569.505n 0.0v 1579.495n 0.0v 1579.505n 0.0v 1589.495n 0.0v 1589.505n 0.0v 1599.495n 0.0v 1599.505n 0.0v 1609.495n 0.0v 1609.505n 0.0v 1619.495n 0.0v 1619.505n 0.0v 1629.495n 0.0v 1629.505n 0.0v 1639.495n 0.0v 1639.505n 3.3v 1649.495n 3.3v 1649.505n 3.3v 1659.495n 3.3v 1659.505n 3.3v 1669.495n 3.3v 1669.505n 3.3v 1679.495n 3.3v 1679.505n 3.3v 1689.495n 3.3v 1689.505n 3.3v 1699.495n 3.3v 1699.505n 3.3v 1709.495n 3.3v 1709.505n 3.3v 1719.495n 3.3v 1719.505n 3.3v 1729.495n 3.3v 1729.505n 3.3v 1739.495n 3.3v 1739.505n 0.0v 1749.495n 0.0v 1749.505n 0.0v 1759.495n 0.0v 1759.505n 0.0v 1769.495n 0.0v 1769.505n 0.0v 1779.495n 0.0v 1779.505n 3.3v 1789.495n 3.3v 1789.505n 0.0v 1799.495n 0.0v 1799.505n 0.0v 1809.495n 0.0v 1809.505n 0.0v 1819.495n 0.0v 1819.505n 0.0v 1829.495n 0.0v 1829.505n 0.0v 1839.495n 0.0v 1839.505n 3.3v 1849.495n 3.3v 1849.505n 3.3v 1859.495n 3.3v 1859.505n 3.3v 1869.495n 3.3v 1869.505n 3.3v 1879.495n 3.3v 1879.505n 3.3v 1889.495n 3.3v 1889.505n 0.0v 1899.495n 0.0v 1899.505n 0.0v 1909.495n 0.0v 1909.505n 3.3v 1919.495n 3.3v 1919.505n 3.3v 1929.495n 3.3v 1929.505n 3.3v 1939.495n 3.3v 1939.505n 3.3v 1949.495n 3.3v 1949.505n 3.3v 1959.495n 3.3v 1959.505n 0.0v 1969.495n 0.0v 1969.505n 0.0v 1979.495n 0.0v 1979.505n 0.0v 1989.495n 0.0v 1989.505n 3.3v 1999.495n 3.3v 1999.505n 3.3v 2009.495n 3.3v 2009.505n 0.0v 2019.495n 0.0v 2019.505n 3.3v 2029.495n 3.3v 2029.505n 3.3v 2039.495n 3.3v 2039.505n 3.3v 2049.495n 3.3v 2049.505n 3.3v )
* (time, data): [(0, 0), (10, 1), (20, 1), (30, 0), (40, 1), (50, 1), (60, 0), (70, 0), (80, 0), (90, 0), (100, 1), (110, 0), (120, 1), (130, 0), (140, 0), (150, 1), (160, 0), (170, 0), (180, 0), (190, 0), (200, 1), (210, 1), (220, 1), (230, 1), (240, 0), (250, 1), (260, 1), (270, 1), (280, 0), (290, 1), (300, 1), (310, 0), (320, 0), (330, 0), (340, 1), (350, 1), (360, 1), (370, 1), (380, 1), (390, 0), (400, 0), (410, 1), (420, 0), (430, 0), (440, 0), (450, 1), (460, 0), (470, 0), (480, 0), (490, 0), (500, 0), (510, 0), (520, 1), (530, 1), (540, 0), (550, 1), (560, 0), (570, 1), (580, 1), (590, 1), (600, 1), (610, 1), (620, 0), (630, 0), (640, 0), (650, 0), (660, 1), (670, 0), (680, 0), (690, 1), (700, 1), (710, 1), (720, 0), (730, 0), (740, 1), (750, 1), (760, 0), (770, 1), (780, 1), (790, 0), (800, 1), (810, 0), (820, 0), (830, 1), (840, 0), (850, 0), (860, 0), (870, 1), (880, 1), (890, 1), (900, 1), (910, 0), (920, 1), (930, 0), (940, 1), (950, 1), (960, 0), (970, 1), (980, 1), (990, 1), (1000, 1), (1010, 1), (1020, 0), (1030, 1), (1040, 1), (1050, 0), (1060, 1), (1070, 1), (1080, 1), (1090, 0), (1100, 0), (1110, 1), (1120, 1), (1130, 0), (1140, 0), (1150, 0), (1160, 0), (1170, 0), (1180, 1), (1190, 1), (1200, 1), (1210, 0), (1220, 1), (1230, 1), (1240, 1), (1250, 1), (1260, 1), (1270, 1), (1280, 1), (1290, 1), (1300, 0), (1310, 1), (1320, 1), (1330, 1), (1340, 1), (1350, 0), (1360, 1), (1370, 0), (1380, 1), (1390, 0), (1400, 0), (1410, 0), (1420, 1), (1430, 1), (1440, 0), (1450, 0), (1460, 0), (1470, 0), (1480, 0), (1490, 0), (1500, 0), (1510, 0), (1520, 1), (1530, 0), (1540, 1), (1550, 1), (1560, 1), (1570, 0), (1580, 0), (1590, 0), (1600, 0), (1610, 0), (1620, 0), (1630, 0), (1640, 1), (1650, 1), (1660, 1), (1670, 1), (1680, 1), (1690, 1), (1700, 1), (1710, 1), (1720, 1), (1730, 1), (1740, 0), (1750, 0), (1760, 0), (1770, 0), (1780, 1), (1790, 0), (1800, 0), (1810, 0), (1820, 0), (1830, 0), (1840, 1), (1850, 1), (1860, 1), (1870, 1), (1880, 1), (1890, 0), (1900, 0), (1910, 1), (1920, 1), (1930, 1), (1940, 1), (1950, 1), (1960, 0), (1970, 0), (1980, 0), (1990, 1), (2000, 1), (2010, 0), (2020, 1), (2030, 1), (2040, 1), (2050, 1)]
Va0_2  a0_2  0 PWL (0n 0.0v 9.495n 0.0v 9.505n 3.3v 19.495n 3.3v 19.505n 3.3v 29.495n 3.3v 29.505n 0.0v 39.495n 0.0v 39.505n 3.3v 49.495n 3.3v 49.505n 3.3v 59.495n 3.3v 59.505n 0.0v 69.495n 0.0v 69.505n 0.0v 79.495n 0.0v 79.505n 0.0v 89.495n 0.0v 89.505n 0.0v 99.495n 0.0v 99.505n 3.3v 109.495n 3.3v 109.505n 0.0v 119.495n 0.0v 119.505n 3.3v 129.495n 3.3v 129.505n 0.0v 139.495n 0.0v 139.505n 0.0v 149.495n 0.0v 149.505n 3.3v 159.495n 3.3v 159.505n 0.0v 169.495n 0.0v 169.505n 0.0v 179.495n 0.0v 179.505n 0.0v 189.495n 0.0v 189.505n 0.0v 199.495n 0.0v 199.505n 3.3v 209.495n 3.3v 209.505n 3.3v 219.495n 3.3v 219.505n 3.3v 229.495n 3.3v 229.505n 3.3v 239.495n 3.3v 239.505n 0.0v 249.495n 0.0v 249.505n 3.3v 259.495n 3.3v 259.505n 3.3v 269.495n 3.3v 269.505n 3.3v 279.495n 3.3v 279.505n 0.0v 289.495n 0.0v 289.505n 3.3v 299.495n 3.3v 299.505n 3.3v 309.495n 3.3v 309.505n 0.0v 319.495n 0.0v 319.505n 0.0v 329.495n 0.0v 329.505n 0.0v 339.495n 0.0v 339.505n 3.3v 349.495n 3.3v 349.505n 3.3v 359.495n 3.3v 359.505n 3.3v 369.495n 3.3v 369.505n 3.3v 379.495n 3.3v 379.505n 3.3v 389.495n 3.3v 389.505n 0.0v 399.495n 0.0v 399.505n 0.0v 409.495n 0.0v 409.505n 3.3v 419.495n 3.3v 419.505n 0.0v 429.495n 0.0v 429.505n 0.0v 439.495n 0.0v 439.505n 0.0v 449.495n 0.0v 449.505n 3.3v 459.495n 3.3v 459.505n 0.0v 469.495n 0.0v 469.505n 0.0v 479.495n 0.0v 479.505n 0.0v 489.495n 0.0v 489.505n 0.0v 499.495n 0.0v 499.505n 0.0v 509.495n 0.0v 509.505n 0.0v 519.495n 0.0v 519.505n 3.3v 529.495n 3.3v 529.505n 3.3v 539.495n 3.3v 539.505n 0.0v 549.495n 0.0v 549.505n 3.3v 559.495n 3.3v 559.505n 0.0v 569.495n 0.0v 569.505n 3.3v 579.495n 3.3v 579.505n 3.3v 589.495n 3.3v 589.505n 3.3v 599.495n 3.3v 599.505n 3.3v 609.495n 3.3v 609.505n 3.3v 619.495n 3.3v 619.505n 0.0v 629.495n 0.0v 629.505n 0.0v 639.495n 0.0v 639.505n 0.0v 649.495n 0.0v 649.505n 0.0v 659.495n 0.0v 659.505n 3.3v 669.495n 3.3v 669.505n 0.0v 679.495n 0.0v 679.505n 0.0v 689.495n 0.0v 689.505n 3.3v 699.495n 3.3v 699.505n 3.3v 709.495n 3.3v 709.505n 3.3v 719.495n 3.3v 719.505n 0.0v 729.495n 0.0v 729.505n 0.0v 739.495n 0.0v 739.505n 3.3v 749.495n 3.3v 749.505n 3.3v 759.495n 3.3v 759.505n 0.0v 769.495n 0.0v 769.505n 3.3v 779.495n 3.3v 779.505n 3.3v 789.495n 3.3v 789.505n 0.0v 799.495n 0.0v 799.505n 3.3v 809.495n 3.3v 809.505n 0.0v 819.495n 0.0v 819.505n 0.0v 829.495n 0.0v 829.505n 3.3v 839.495n 3.3v 839.505n 0.0v 849.495n 0.0v 849.505n 0.0v 859.495n 0.0v 859.505n 0.0v 869.495n 0.0v 869.505n 3.3v 879.495n 3.3v 879.505n 3.3v 889.495n 3.3v 889.505n 3.3v 899.495n 3.3v 899.505n 3.3v 909.495n 3.3v 909.505n 0.0v 919.495n 0.0v 919.505n 3.3v 929.495n 3.3v 929.505n 0.0v 939.495n 0.0v 939.505n 3.3v 949.495n 3.3v 949.505n 3.3v 959.495n 3.3v 959.505n 0.0v 969.495n 0.0v 969.505n 3.3v 979.495n 3.3v 979.505n 3.3v 989.495n 3.3v 989.505n 3.3v 999.495n 3.3v 999.505n 3.3v 1009.495n 3.3v 1009.505n 3.3v 1019.495n 3.3v 1019.505n 0.0v 1029.495n 0.0v 1029.505n 3.3v 1039.495n 3.3v 1039.505n 3.3v 1049.495n 3.3v 1049.505n 0.0v 1059.495n 0.0v 1059.505n 3.3v 1069.495n 3.3v 1069.505n 3.3v 1079.495n 3.3v 1079.505n 3.3v 1089.495n 3.3v 1089.505n 0.0v 1099.495n 0.0v 1099.505n 0.0v 1109.495n 0.0v 1109.505n 3.3v 1119.495n 3.3v 1119.505n 3.3v 1129.495n 3.3v 1129.505n 0.0v 1139.495n 0.0v 1139.505n 0.0v 1149.495n 0.0v 1149.505n 0.0v 1159.495n 0.0v 1159.505n 0.0v 1169.495n 0.0v 1169.505n 0.0v 1179.495n 0.0v 1179.505n 3.3v 1189.495n 3.3v 1189.505n 3.3v 1199.495n 3.3v 1199.505n 3.3v 1209.495n 3.3v 1209.505n 0.0v 1219.495n 0.0v 1219.505n 3.3v 1229.495n 3.3v 1229.505n 3.3v 1239.495n 3.3v 1239.505n 3.3v 1249.495n 3.3v 1249.505n 3.3v 1259.495n 3.3v 1259.505n 3.3v 1269.495n 3.3v 1269.505n 3.3v 1279.495n 3.3v 1279.505n 3.3v 1289.495n 3.3v 1289.505n 3.3v 1299.495n 3.3v 1299.505n 0.0v 1309.495n 0.0v 1309.505n 3.3v 1319.495n 3.3v 1319.505n 3.3v 1329.495n 3.3v 1329.505n 3.3v 1339.495n 3.3v 1339.505n 3.3v 1349.495n 3.3v 1349.505n 0.0v 1359.495n 0.0v 1359.505n 3.3v 1369.495n 3.3v 1369.505n 0.0v 1379.495n 0.0v 1379.505n 3.3v 1389.495n 3.3v 1389.505n 0.0v 1399.495n 0.0v 1399.505n 0.0v 1409.495n 0.0v 1409.505n 0.0v 1419.495n 0.0v 1419.505n 3.3v 1429.495n 3.3v 1429.505n 3.3v 1439.495n 3.3v 1439.505n 0.0v 1449.495n 0.0v 1449.505n 0.0v 1459.495n 0.0v 1459.505n 0.0v 1469.495n 0.0v 1469.505n 0.0v 1479.495n 0.0v 1479.505n 0.0v 1489.495n 0.0v 1489.505n 0.0v 1499.495n 0.0v 1499.505n 0.0v 1509.495n 0.0v 1509.505n 0.0v 1519.495n 0.0v 1519.505n 3.3v 1529.495n 3.3v 1529.505n 0.0v 1539.495n 0.0v 1539.505n 3.3v 1549.495n 3.3v 1549.505n 3.3v 1559.495n 3.3v 1559.505n 3.3v 1569.495n 3.3v 1569.505n 0.0v 1579.495n 0.0v 1579.505n 0.0v 1589.495n 0.0v 1589.505n 0.0v 1599.495n 0.0v 1599.505n 0.0v 1609.495n 0.0v 1609.505n 0.0v 1619.495n 0.0v 1619.505n 0.0v 1629.495n 0.0v 1629.505n 0.0v 1639.495n 0.0v 1639.505n 3.3v 1649.495n 3.3v 1649.505n 3.3v 1659.495n 3.3v 1659.505n 3.3v 1669.495n 3.3v 1669.505n 3.3v 1679.495n 3.3v 1679.505n 3.3v 1689.495n 3.3v 1689.505n 3.3v 1699.495n 3.3v 1699.505n 3.3v 1709.495n 3.3v 1709.505n 3.3v 1719.495n 3.3v 1719.505n 3.3v 1729.495n 3.3v 1729.505n 3.3v 1739.495n 3.3v 1739.505n 0.0v 1749.495n 0.0v 1749.505n 0.0v 1759.495n 0.0v 1759.505n 0.0v 1769.495n 0.0v 1769.505n 0.0v 1779.495n 0.0v 1779.505n 3.3v 1789.495n 3.3v 1789.505n 0.0v 1799.495n 0.0v 1799.505n 0.0v 1809.495n 0.0v 1809.505n 0.0v 1819.495n 0.0v 1819.505n 0.0v 1829.495n 0.0v 1829.505n 0.0v 1839.495n 0.0v 1839.505n 3.3v 1849.495n 3.3v 1849.505n 3.3v 1859.495n 3.3v 1859.505n 3.3v 1869.495n 3.3v 1869.505n 3.3v 1879.495n 3.3v 1879.505n 3.3v 1889.495n 3.3v 1889.505n 0.0v 1899.495n 0.0v 1899.505n 0.0v 1909.495n 0.0v 1909.505n 3.3v 1919.495n 3.3v 1919.505n 3.3v 1929.495n 3.3v 1929.505n 3.3v 1939.495n 3.3v 1939.505n 3.3v 1949.495n 3.3v 1949.505n 3.3v 1959.495n 3.3v 1959.505n 0.0v 1969.495n 0.0v 1969.505n 0.0v 1979.495n 0.0v 1979.505n 0.0v 1989.495n 0.0v 1989.505n 3.3v 1999.495n 3.3v 1999.505n 3.3v 2009.495n 3.3v 2009.505n 0.0v 2019.495n 0.0v 2019.505n 3.3v 2029.495n 3.3v 2029.505n 3.3v 2039.495n 3.3v 2039.505n 3.3v 2049.495n 3.3v 2049.505n 3.3v )
* (time, data): [(0, 0), (10, 1), (20, 1), (30, 0), (40, 1), (50, 1), (60, 0), (70, 0), (80, 0), (90, 0), (100, 1), (110, 0), (120, 1), (130, 0), (140, 0), (150, 1), (160, 0), (170, 0), (180, 0), (190, 0), (200, 1), (210, 1), (220, 1), (230, 1), (240, 0), (250, 1), (260, 1), (270, 1), (280, 0), (290, 1), (300, 1), (310, 0), (320, 0), (330, 0), (340, 1), (350, 1), (360, 1), (370, 1), (380, 1), (390, 0), (400, 0), (410, 1), (420, 0), (430, 0), (440, 0), (450, 1), (460, 0), (470, 0), (480, 0), (490, 0), (500, 0), (510, 0), (520, 1), (530, 1), (540, 0), (550, 1), (560, 0), (570, 1), (580, 1), (590, 1), (600, 1), (610, 1), (620, 0), (630, 0), (640, 0), (650, 0), (660, 1), (670, 0), (680, 0), (690, 1), (700, 1), (710, 1), (720, 0), (730, 0), (740, 1), (750, 1), (760, 0), (770, 1), (780, 1), (790, 0), (800, 1), (810, 0), (820, 0), (830, 1), (840, 0), (850, 0), (860, 0), (870, 1), (880, 1), (890, 1), (900, 1), (910, 0), (920, 1), (930, 0), (940, 1), (950, 1), (960, 0), (970, 1), (980, 1), (990, 1), (1000, 1), (1010, 1), (1020, 0), (1030, 1), (1040, 1), (1050, 0), (1060, 1), (1070, 1), (1080, 1), (1090, 0), (1100, 0), (1110, 1), (1120, 1), (1130, 0), (1140, 0), (1150, 0), (1160, 0), (1170, 0), (1180, 1), (1190, 1), (1200, 1), (1210, 0), (1220, 1), (1230, 1), (1240, 1), (1250, 1), (1260, 1), (1270, 1), (1280, 1), (1290, 1), (1300, 0), (1310, 1), (1320, 1), (1330, 1), (1340, 1), (1350, 0), (1360, 1), (1370, 0), (1380, 1), (1390, 0), (1400, 0), (1410, 0), (1420, 1), (1430, 1), (1440, 0), (1450, 0), (1460, 0), (1470, 0), (1480, 0), (1490, 0), (1500, 0), (1510, 0), (1520, 1), (1530, 0), (1540, 1), (1550, 1), (1560, 1), (1570, 0), (1580, 0), (1590, 0), (1600, 0), (1610, 0), (1620, 0), (1630, 0), (1640, 1), (1650, 1), (1660, 1), (1670, 1), (1680, 1), (1690, 1), (1700, 1), (1710, 1), (1720, 1), (1730, 1), (1740, 0), (1750, 0), (1760, 0), (1770, 0), (1780, 1), (1790, 0), (1800, 0), (1810, 0), (1820, 0), (1830, 0), (1840, 1), (1850, 1), (1860, 1), (1870, 1), (1880, 1), (1890, 0), (1900, 0), (1910, 1), (1920, 1), (1930, 1), (1940, 1), (1950, 1), (1960, 0), (1970, 0), (1980, 0), (1990, 1), (2000, 1), (2010, 0), (2020, 1), (2030, 1), (2040, 1), (2050, 1)]
Va0_3  a0_3  0 PWL (0n 0.0v 9.495n 0.0v 9.505n 3.3v 19.495n 3.3v 19.505n 3.3v 29.495n 3.3v 29.505n 0.0v 39.495n 0.0v 39.505n 3.3v 49.495n 3.3v 49.505n 3.3v 59.495n 3.3v 59.505n 0.0v 69.495n 0.0v 69.505n 0.0v 79.495n 0.0v 79.505n 0.0v 89.495n 0.0v 89.505n 0.0v 99.495n 0.0v 99.505n 3.3v 109.495n 3.3v 109.505n 0.0v 119.495n 0.0v 119.505n 3.3v 129.495n 3.3v 129.505n 0.0v 139.495n 0.0v 139.505n 0.0v 149.495n 0.0v 149.505n 3.3v 159.495n 3.3v 159.505n 0.0v 169.495n 0.0v 169.505n 0.0v 179.495n 0.0v 179.505n 0.0v 189.495n 0.0v 189.505n 0.0v 199.495n 0.0v 199.505n 3.3v 209.495n 3.3v 209.505n 3.3v 219.495n 3.3v 219.505n 3.3v 229.495n 3.3v 229.505n 3.3v 239.495n 3.3v 239.505n 0.0v 249.495n 0.0v 249.505n 3.3v 259.495n 3.3v 259.505n 3.3v 269.495n 3.3v 269.505n 3.3v 279.495n 3.3v 279.505n 0.0v 289.495n 0.0v 289.505n 3.3v 299.495n 3.3v 299.505n 3.3v 309.495n 3.3v 309.505n 0.0v 319.495n 0.0v 319.505n 0.0v 329.495n 0.0v 329.505n 0.0v 339.495n 0.0v 339.505n 3.3v 349.495n 3.3v 349.505n 3.3v 359.495n 3.3v 359.505n 3.3v 369.495n 3.3v 369.505n 3.3v 379.495n 3.3v 379.505n 3.3v 389.495n 3.3v 389.505n 0.0v 399.495n 0.0v 399.505n 0.0v 409.495n 0.0v 409.505n 3.3v 419.495n 3.3v 419.505n 0.0v 429.495n 0.0v 429.505n 0.0v 439.495n 0.0v 439.505n 0.0v 449.495n 0.0v 449.505n 3.3v 459.495n 3.3v 459.505n 0.0v 469.495n 0.0v 469.505n 0.0v 479.495n 0.0v 479.505n 0.0v 489.495n 0.0v 489.505n 0.0v 499.495n 0.0v 499.505n 0.0v 509.495n 0.0v 509.505n 0.0v 519.495n 0.0v 519.505n 3.3v 529.495n 3.3v 529.505n 3.3v 539.495n 3.3v 539.505n 0.0v 549.495n 0.0v 549.505n 3.3v 559.495n 3.3v 559.505n 0.0v 569.495n 0.0v 569.505n 3.3v 579.495n 3.3v 579.505n 3.3v 589.495n 3.3v 589.505n 3.3v 599.495n 3.3v 599.505n 3.3v 609.495n 3.3v 609.505n 3.3v 619.495n 3.3v 619.505n 0.0v 629.495n 0.0v 629.505n 0.0v 639.495n 0.0v 639.505n 0.0v 649.495n 0.0v 649.505n 0.0v 659.495n 0.0v 659.505n 3.3v 669.495n 3.3v 669.505n 0.0v 679.495n 0.0v 679.505n 0.0v 689.495n 0.0v 689.505n 3.3v 699.495n 3.3v 699.505n 3.3v 709.495n 3.3v 709.505n 3.3v 719.495n 3.3v 719.505n 0.0v 729.495n 0.0v 729.505n 0.0v 739.495n 0.0v 739.505n 3.3v 749.495n 3.3v 749.505n 3.3v 759.495n 3.3v 759.505n 0.0v 769.495n 0.0v 769.505n 3.3v 779.495n 3.3v 779.505n 3.3v 789.495n 3.3v 789.505n 0.0v 799.495n 0.0v 799.505n 3.3v 809.495n 3.3v 809.505n 0.0v 819.495n 0.0v 819.505n 0.0v 829.495n 0.0v 829.505n 3.3v 839.495n 3.3v 839.505n 0.0v 849.495n 0.0v 849.505n 0.0v 859.495n 0.0v 859.505n 0.0v 869.495n 0.0v 869.505n 3.3v 879.495n 3.3v 879.505n 3.3v 889.495n 3.3v 889.505n 3.3v 899.495n 3.3v 899.505n 3.3v 909.495n 3.3v 909.505n 0.0v 919.495n 0.0v 919.505n 3.3v 929.495n 3.3v 929.505n 0.0v 939.495n 0.0v 939.505n 3.3v 949.495n 3.3v 949.505n 3.3v 959.495n 3.3v 959.505n 0.0v 969.495n 0.0v 969.505n 3.3v 979.495n 3.3v 979.505n 3.3v 989.495n 3.3v 989.505n 3.3v 999.495n 3.3v 999.505n 3.3v 1009.495n 3.3v 1009.505n 3.3v 1019.495n 3.3v 1019.505n 0.0v 1029.495n 0.0v 1029.505n 3.3v 1039.495n 3.3v 1039.505n 3.3v 1049.495n 3.3v 1049.505n 0.0v 1059.495n 0.0v 1059.505n 3.3v 1069.495n 3.3v 1069.505n 3.3v 1079.495n 3.3v 1079.505n 3.3v 1089.495n 3.3v 1089.505n 0.0v 1099.495n 0.0v 1099.505n 0.0v 1109.495n 0.0v 1109.505n 3.3v 1119.495n 3.3v 1119.505n 3.3v 1129.495n 3.3v 1129.505n 0.0v 1139.495n 0.0v 1139.505n 0.0v 1149.495n 0.0v 1149.505n 0.0v 1159.495n 0.0v 1159.505n 0.0v 1169.495n 0.0v 1169.505n 0.0v 1179.495n 0.0v 1179.505n 3.3v 1189.495n 3.3v 1189.505n 3.3v 1199.495n 3.3v 1199.505n 3.3v 1209.495n 3.3v 1209.505n 0.0v 1219.495n 0.0v 1219.505n 3.3v 1229.495n 3.3v 1229.505n 3.3v 1239.495n 3.3v 1239.505n 3.3v 1249.495n 3.3v 1249.505n 3.3v 1259.495n 3.3v 1259.505n 3.3v 1269.495n 3.3v 1269.505n 3.3v 1279.495n 3.3v 1279.505n 3.3v 1289.495n 3.3v 1289.505n 3.3v 1299.495n 3.3v 1299.505n 0.0v 1309.495n 0.0v 1309.505n 3.3v 1319.495n 3.3v 1319.505n 3.3v 1329.495n 3.3v 1329.505n 3.3v 1339.495n 3.3v 1339.505n 3.3v 1349.495n 3.3v 1349.505n 0.0v 1359.495n 0.0v 1359.505n 3.3v 1369.495n 3.3v 1369.505n 0.0v 1379.495n 0.0v 1379.505n 3.3v 1389.495n 3.3v 1389.505n 0.0v 1399.495n 0.0v 1399.505n 0.0v 1409.495n 0.0v 1409.505n 0.0v 1419.495n 0.0v 1419.505n 3.3v 1429.495n 3.3v 1429.505n 3.3v 1439.495n 3.3v 1439.505n 0.0v 1449.495n 0.0v 1449.505n 0.0v 1459.495n 0.0v 1459.505n 0.0v 1469.495n 0.0v 1469.505n 0.0v 1479.495n 0.0v 1479.505n 0.0v 1489.495n 0.0v 1489.505n 0.0v 1499.495n 0.0v 1499.505n 0.0v 1509.495n 0.0v 1509.505n 0.0v 1519.495n 0.0v 1519.505n 3.3v 1529.495n 3.3v 1529.505n 0.0v 1539.495n 0.0v 1539.505n 3.3v 1549.495n 3.3v 1549.505n 3.3v 1559.495n 3.3v 1559.505n 3.3v 1569.495n 3.3v 1569.505n 0.0v 1579.495n 0.0v 1579.505n 0.0v 1589.495n 0.0v 1589.505n 0.0v 1599.495n 0.0v 1599.505n 0.0v 1609.495n 0.0v 1609.505n 0.0v 1619.495n 0.0v 1619.505n 0.0v 1629.495n 0.0v 1629.505n 0.0v 1639.495n 0.0v 1639.505n 3.3v 1649.495n 3.3v 1649.505n 3.3v 1659.495n 3.3v 1659.505n 3.3v 1669.495n 3.3v 1669.505n 3.3v 1679.495n 3.3v 1679.505n 3.3v 1689.495n 3.3v 1689.505n 3.3v 1699.495n 3.3v 1699.505n 3.3v 1709.495n 3.3v 1709.505n 3.3v 1719.495n 3.3v 1719.505n 3.3v 1729.495n 3.3v 1729.505n 3.3v 1739.495n 3.3v 1739.505n 0.0v 1749.495n 0.0v 1749.505n 0.0v 1759.495n 0.0v 1759.505n 0.0v 1769.495n 0.0v 1769.505n 0.0v 1779.495n 0.0v 1779.505n 3.3v 1789.495n 3.3v 1789.505n 0.0v 1799.495n 0.0v 1799.505n 0.0v 1809.495n 0.0v 1809.505n 0.0v 1819.495n 0.0v 1819.505n 0.0v 1829.495n 0.0v 1829.505n 0.0v 1839.495n 0.0v 1839.505n 3.3v 1849.495n 3.3v 1849.505n 3.3v 1859.495n 3.3v 1859.505n 3.3v 1869.495n 3.3v 1869.505n 3.3v 1879.495n 3.3v 1879.505n 3.3v 1889.495n 3.3v 1889.505n 0.0v 1899.495n 0.0v 1899.505n 0.0v 1909.495n 0.0v 1909.505n 3.3v 1919.495n 3.3v 1919.505n 3.3v 1929.495n 3.3v 1929.505n 3.3v 1939.495n 3.3v 1939.505n 3.3v 1949.495n 3.3v 1949.505n 3.3v 1959.495n 3.3v 1959.505n 0.0v 1969.495n 0.0v 1969.505n 0.0v 1979.495n 0.0v 1979.505n 0.0v 1989.495n 0.0v 1989.505n 3.3v 1999.495n 3.3v 1999.505n 3.3v 2009.495n 3.3v 2009.505n 0.0v 2019.495n 0.0v 2019.505n 3.3v 2029.495n 3.3v 2029.505n 3.3v 2039.495n 3.3v 2039.505n 3.3v 2049.495n 3.3v 2049.505n 3.3v )
* (time, data): [(0, 0), (10, 0), (20, 0), (30, 0), (40, 0), (50, 0), (60, 0), (70, 0), (80, 0), (90, 0), (100, 0), (110, 0), (120, 0), (130, 0), (140, 0), (150, 0), (160, 0), (170, 0), (180, 0), (190, 0), (200, 0), (210, 0), (220, 0), (230, 0), (240, 0), (250, 0), (260, 0), (270, 0), (280, 0), (290, 0), (300, 0), (310, 0), (320, 0), (330, 0), (340, 0), (350, 0), (360, 0), (370, 0), (380, 0), (390, 0), (400, 0), (410, 0), (420, 0), (430, 0), (440, 0), (450, 0), (460, 0), (470, 0), (480, 0), (490, 0), (500, 0), (510, 0), (520, 0), (530, 0), (540, 0), (550, 0), (560, 0), (570, 0), (580, 0), (590, 0), (600, 0), (610, 0), (620, 0), (630, 0), (640, 0), (650, 0), (660, 0), (670, 0), (680, 0), (690, 0), (700, 0), (710, 0), (720, 0), (730, 0), (740, 0), (750, 0), (760, 0), (770, 0), (780, 0), (790, 0), (800, 0), (810, 0), (820, 0), (830, 0), (840, 0), (850, 0), (860, 0), (870, 0), (880, 0), (890, 0), (900, 0), (910, 0), (920, 0), (930, 0), (940, 0), (950, 0), (960, 0), (970, 0), (980, 0), (990, 0), (1000, 0), (1010, 0), (1020, 0), (1030, 0), (1040, 0), (1050, 0), (1060, 0), (1070, 0), (1080, 0), (1090, 0), (1100, 0), (1110, 0), (1120, 0), (1130, 0), (1140, 0), (1150, 0), (1160, 0), (1170, 0), (1180, 0), (1190, 0), (1200, 0), (1210, 0), (1220, 0), (1230, 0), (1240, 0), (1250, 0), (1260, 0), (1270, 0), (1280, 0), (1290, 0), (1300, 0), (1310, 0), (1320, 0), (1330, 0), (1340, 0), (1350, 0), (1360, 0), (1370, 0), (1380, 0), (1390, 0), (1400, 0), (1410, 0), (1420, 0), (1430, 0), (1440, 0), (1450, 0), (1460, 0), (1470, 0), (1480, 0), (1490, 0), (1500, 0), (1510, 0), (1520, 0), (1530, 0), (1540, 0), (1550, 0), (1560, 0), (1570, 0), (1580, 0), (1590, 0), (1600, 0), (1610, 0), (1620, 0), (1630, 0), (1640, 0), (1650, 0), (1660, 0), (1670, 0), (1680, 0), (1690, 0), (1700, 0), (1710, 0), (1720, 0), (1730, 0), (1740, 0), (1750, 0), (1760, 0), (1770, 0), (1780, 0), (1790, 0), (1800, 0), (1810, 0), (1820, 0), (1830, 0), (1840, 0), (1850, 0), (1860, 0), (1870, 0), (1880, 0), (1890, 0), (1900, 0), (1910, 0), (1920, 0), (1930, 0), (1940, 0), (1950, 0), (1960, 0), (1970, 0), (1980, 0), (1990, 0), (2000, 0), (2010, 0), (2020, 0), (2030, 0), (2040, 0), (2050, 0)]
Va1_0  a1_0  0 PWL (0n 0.0v 9.495n 0.0v 9.505n 0.0v 19.495n 0.0v 19.505n 0.0v 29.495n 0.0v 29.505n 0.0v 39.495n 0.0v 39.505n 0.0v 49.495n 0.0v 49.505n 0.0v 59.495n 0.0v 59.505n 0.0v 69.495n 0.0v 69.505n 0.0v 79.495n 0.0v 79.505n 0.0v 89.495n 0.0v 89.505n 0.0v 99.495n 0.0v 99.505n 0.0v 109.495n 0.0v 109.505n 0.0v 119.495n 0.0v 119.505n 0.0v 129.495n 0.0v 129.505n 0.0v 139.495n 0.0v 139.505n 0.0v 149.495n 0.0v 149.505n 0.0v 159.495n 0.0v 159.505n 0.0v 169.495n 0.0v 169.505n 0.0v 179.495n 0.0v 179.505n 0.0v 189.495n 0.0v 189.505n 0.0v 199.495n 0.0v 199.505n 0.0v 209.495n 0.0v 209.505n 0.0v 219.495n 0.0v 219.505n 0.0v 229.495n 0.0v 229.505n 0.0v 239.495n 0.0v 239.505n 0.0v 249.495n 0.0v 249.505n 0.0v 259.495n 0.0v 259.505n 0.0v 269.495n 0.0v 269.505n 0.0v 279.495n 0.0v 279.505n 0.0v 289.495n 0.0v 289.505n 0.0v 299.495n 0.0v 299.505n 0.0v 309.495n 0.0v 309.505n 0.0v 319.495n 0.0v 319.505n 0.0v 329.495n 0.0v 329.505n 0.0v 339.495n 0.0v 339.505n 0.0v 349.495n 0.0v 349.505n 0.0v 359.495n 0.0v 359.505n 0.0v 369.495n 0.0v 369.505n 0.0v 379.495n 0.0v 379.505n 0.0v 389.495n 0.0v 389.505n 0.0v 399.495n 0.0v 399.505n 0.0v 409.495n 0.0v 409.505n 0.0v 419.495n 0.0v 419.505n 0.0v 429.495n 0.0v 429.505n 0.0v 439.495n 0.0v 439.505n 0.0v 449.495n 0.0v 449.505n 0.0v 459.495n 0.0v 459.505n 0.0v 469.495n 0.0v 469.505n 0.0v 479.495n 0.0v 479.505n 0.0v 489.495n 0.0v 489.505n 0.0v 499.495n 0.0v 499.505n 0.0v 509.495n 0.0v 509.505n 0.0v 519.495n 0.0v 519.505n 0.0v 529.495n 0.0v 529.505n 0.0v 539.495n 0.0v 539.505n 0.0v 549.495n 0.0v 549.505n 0.0v 559.495n 0.0v 559.505n 0.0v 569.495n 0.0v 569.505n 0.0v 579.495n 0.0v 579.505n 0.0v 589.495n 0.0v 589.505n 0.0v 599.495n 0.0v 599.505n 0.0v 609.495n 0.0v 609.505n 0.0v 619.495n 0.0v 619.505n 0.0v 629.495n 0.0v 629.505n 0.0v 639.495n 0.0v 639.505n 0.0v 649.495n 0.0v 649.505n 0.0v 659.495n 0.0v 659.505n 0.0v 669.495n 0.0v 669.505n 0.0v 679.495n 0.0v 679.505n 0.0v 689.495n 0.0v 689.505n 0.0v 699.495n 0.0v 699.505n 0.0v 709.495n 0.0v 709.505n 0.0v 719.495n 0.0v 719.505n 0.0v 729.495n 0.0v 729.505n 0.0v 739.495n 0.0v 739.505n 0.0v 749.495n 0.0v 749.505n 0.0v 759.495n 0.0v 759.505n 0.0v 769.495n 0.0v 769.505n 0.0v 779.495n 0.0v 779.505n 0.0v 789.495n 0.0v 789.505n 0.0v 799.495n 0.0v 799.505n 0.0v 809.495n 0.0v 809.505n 0.0v 819.495n 0.0v 819.505n 0.0v 829.495n 0.0v 829.505n 0.0v 839.495n 0.0v 839.505n 0.0v 849.495n 0.0v 849.505n 0.0v 859.495n 0.0v 859.505n 0.0v 869.495n 0.0v 869.505n 0.0v 879.495n 0.0v 879.505n 0.0v 889.495n 0.0v 889.505n 0.0v 899.495n 0.0v 899.505n 0.0v 909.495n 0.0v 909.505n 0.0v 919.495n 0.0v 919.505n 0.0v 929.495n 0.0v 929.505n 0.0v 939.495n 0.0v 939.505n 0.0v 949.495n 0.0v 949.505n 0.0v 959.495n 0.0v 959.505n 0.0v 969.495n 0.0v 969.505n 0.0v 979.495n 0.0v 979.505n 0.0v 989.495n 0.0v 989.505n 0.0v 999.495n 0.0v 999.505n 0.0v 1009.495n 0.0v 1009.505n 0.0v 1019.495n 0.0v 1019.505n 0.0v 1029.495n 0.0v 1029.505n 0.0v 1039.495n 0.0v 1039.505n 0.0v 1049.495n 0.0v 1049.505n 0.0v 1059.495n 0.0v 1059.505n 0.0v 1069.495n 0.0v 1069.505n 0.0v 1079.495n 0.0v 1079.505n 0.0v 1089.495n 0.0v 1089.505n 0.0v 1099.495n 0.0v 1099.505n 0.0v 1109.495n 0.0v 1109.505n 0.0v 1119.495n 0.0v 1119.505n 0.0v 1129.495n 0.0v 1129.505n 0.0v 1139.495n 0.0v 1139.505n 0.0v 1149.495n 0.0v 1149.505n 0.0v 1159.495n 0.0v 1159.505n 0.0v 1169.495n 0.0v 1169.505n 0.0v 1179.495n 0.0v 1179.505n 0.0v 1189.495n 0.0v 1189.505n 0.0v 1199.495n 0.0v 1199.505n 0.0v 1209.495n 0.0v 1209.505n 0.0v 1219.495n 0.0v 1219.505n 0.0v 1229.495n 0.0v 1229.505n 0.0v 1239.495n 0.0v 1239.505n 0.0v 1249.495n 0.0v 1249.505n 0.0v 1259.495n 0.0v 1259.505n 0.0v 1269.495n 0.0v 1269.505n 0.0v 1279.495n 0.0v 1279.505n 0.0v 1289.495n 0.0v 1289.505n 0.0v 1299.495n 0.0v 1299.505n 0.0v 1309.495n 0.0v 1309.505n 0.0v 1319.495n 0.0v 1319.505n 0.0v 1329.495n 0.0v 1329.505n 0.0v 1339.495n 0.0v 1339.505n 0.0v 1349.495n 0.0v 1349.505n 0.0v 1359.495n 0.0v 1359.505n 0.0v 1369.495n 0.0v 1369.505n 0.0v 1379.495n 0.0v 1379.505n 0.0v 1389.495n 0.0v 1389.505n 0.0v 1399.495n 0.0v 1399.505n 0.0v 1409.495n 0.0v 1409.505n 0.0v 1419.495n 0.0v 1419.505n 0.0v 1429.495n 0.0v 1429.505n 0.0v 1439.495n 0.0v 1439.505n 0.0v 1449.495n 0.0v 1449.505n 0.0v 1459.495n 0.0v 1459.505n 0.0v 1469.495n 0.0v 1469.505n 0.0v 1479.495n 0.0v 1479.505n 0.0v 1489.495n 0.0v 1489.505n 0.0v 1499.495n 0.0v 1499.505n 0.0v 1509.495n 0.0v 1509.505n 0.0v 1519.495n 0.0v 1519.505n 0.0v 1529.495n 0.0v 1529.505n 0.0v 1539.495n 0.0v 1539.505n 0.0v 1549.495n 0.0v 1549.505n 0.0v 1559.495n 0.0v 1559.505n 0.0v 1569.495n 0.0v 1569.505n 0.0v 1579.495n 0.0v 1579.505n 0.0v 1589.495n 0.0v 1589.505n 0.0v 1599.495n 0.0v 1599.505n 0.0v 1609.495n 0.0v 1609.505n 0.0v 1619.495n 0.0v 1619.505n 0.0v 1629.495n 0.0v 1629.505n 0.0v 1639.495n 0.0v 1639.505n 0.0v 1649.495n 0.0v 1649.505n 0.0v 1659.495n 0.0v 1659.505n 0.0v 1669.495n 0.0v 1669.505n 0.0v 1679.495n 0.0v 1679.505n 0.0v 1689.495n 0.0v 1689.505n 0.0v 1699.495n 0.0v 1699.505n 0.0v 1709.495n 0.0v 1709.505n 0.0v 1719.495n 0.0v 1719.505n 0.0v 1729.495n 0.0v 1729.505n 0.0v 1739.495n 0.0v 1739.505n 0.0v 1749.495n 0.0v 1749.505n 0.0v 1759.495n 0.0v 1759.505n 0.0v 1769.495n 0.0v 1769.505n 0.0v 1779.495n 0.0v 1779.505n 0.0v 1789.495n 0.0v 1789.505n 0.0v 1799.495n 0.0v 1799.505n 0.0v 1809.495n 0.0v 1809.505n 0.0v 1819.495n 0.0v 1819.505n 0.0v 1829.495n 0.0v 1829.505n 0.0v 1839.495n 0.0v 1839.505n 0.0v 1849.495n 0.0v 1849.505n 0.0v 1859.495n 0.0v 1859.505n 0.0v 1869.495n 0.0v 1869.505n 0.0v 1879.495n 0.0v 1879.505n 0.0v 1889.495n 0.0v 1889.505n 0.0v 1899.495n 0.0v 1899.505n 0.0v 1909.495n 0.0v 1909.505n 0.0v 1919.495n 0.0v 1919.505n 0.0v 1929.495n 0.0v 1929.505n 0.0v 1939.495n 0.0v 1939.505n 0.0v 1949.495n 0.0v 1949.505n 0.0v 1959.495n 0.0v 1959.505n 0.0v 1969.495n 0.0v 1969.505n 0.0v 1979.495n 0.0v 1979.505n 0.0v 1989.495n 0.0v 1989.505n 0.0v 1999.495n 0.0v 1999.505n 0.0v 2009.495n 0.0v 2009.505n 0.0v 2019.495n 0.0v 2019.505n 0.0v 2029.495n 0.0v 2029.505n 0.0v 2039.495n 0.0v 2039.505n 0.0v 2049.495n 0.0v 2049.505n 0.0v )
* (time, data): [(0, 0), (10, 0), (20, 0), (30, 0), (40, 1), (50, 0), (60, 0), (70, 0), (80, 1), (90, 1), (100, 1), (110, 1), (120, 0), (130, 0), (140, 0), (150, 0), (160, 0), (170, 0), (180, 1), (190, 1), (200, 1), (210, 1), (220, 0), (230, 0), (240, 0), (250, 0), (260, 0), (270, 0), (280, 0), (290, 1), (300, 1), (310, 1), (320, 1), (330, 0), (340, 0), (350, 0), (360, 0), (370, 0), (380, 0), (390, 1), (400, 1), (410, 1), (420, 1), (430, 1), (440, 1), (450, 0), (460, 1), (470, 0), (480, 1), (490, 1), (500, 1), (510, 1), (520, 1), (530, 1), (540, 1), (550, 1), (560, 1), (570, 1), (580, 1), (590, 1), (600, 1), (610, 0), (620, 0), (630, 0), (640, 1), (650, 1), (660, 1), (670, 1), (680, 0), (690, 0), (700, 0), (710, 1), (720, 0), (730, 1), (740, 0), (750, 0), (760, 0), (770, 1), (780, 0), (790, 1), (800, 0), (810, 0), (820, 0), (830, 0), (840, 1), (850, 1), (860, 1), (870, 1), (880, 1), (890, 1), (900, 1), (910, 1), (920, 1), (930, 1), (940, 1), (950, 1), (960, 1), (970, 0), (980, 0), (990, 1), (1000, 1), (1010, 0), (1020, 1), (1030, 1), (1040, 1), (1050, 0), (1060, 0), (1070, 1), (1080, 0), (1090, 0), (1100, 0), (1110, 0), (1120, 1), (1130, 1), (1140, 1), (1150, 1), (1160, 1), (1170, 1), (1180, 0), (1190, 0), (1200, 1), (1210, 1), (1220, 1), (1230, 0), (1240, 1), (1250, 0), (1260, 0), (1270, 0), (1280, 1), (1290, 0), (1300, 0), (1310, 0), (1320, 1), (1330, 0), (1340, 1), (1350, 0), (1360, 0), (1370, 1), (1380, 1), (1390, 1), (1400, 1), (1410, 1), (1420, 0), (1430, 0), (1440, 1), (1450, 0), (1460, 0), (1470, 0), (1480, 1), (1490, 1), (1500, 1), (1510, 1), (1520, 1), (1530, 1), (1540, 1), (1550, 1), (1560, 0), (1570, 1), (1580, 0), (1590, 1), (1600, 1), (1610, 0), (1620, 0), (1630, 0), (1640, 0), (1650, 0), (1660, 0), (1670, 0), (1680, 0), (1690, 0), (1700, 0), (1710, 0), (1720, 0), (1730, 1), (1740, 0), (1750, 1), (1760, 0), (1770, 1), (1780, 0), (1790, 0), (1800, 1), (1810, 0), (1820, 1), (1830, 1), (1840, 1), (1850, 1), (1860, 0), (1870, 1), (1880, 1), (1890, 1), (1900, 0), (1910, 0), (1920, 0), (1930, 0), (1940, 1), (1950, 1), (1960, 1), (1970, 0), (1980, 1), (1990, 1), (2000, 0), (2010, 1), (2020, 1), (2030, 0), (2040, 0), (2050, 0)]
Va1_1  a1_1  0 PWL (0n 0.0v 9.495n 0.0v 9.505n 0.0v 19.495n 0.0v 19.505n 0.0v 29.495n 0.0v 29.505n 0.0v 39.495n 0.0v 39.505n 3.3v 49.495n 3.3v 49.505n 0.0v 59.495n 0.0v 59.505n 0.0v 69.495n 0.0v 69.505n 0.0v 79.495n 0.0v 79.505n 3.3v 89.495n 3.3v 89.505n 3.3v 99.495n 3.3v 99.505n 3.3v 109.495n 3.3v 109.505n 3.3v 119.495n 3.3v 119.505n 0.0v 129.495n 0.0v 129.505n 0.0v 139.495n 0.0v 139.505n 0.0v 149.495n 0.0v 149.505n 0.0v 159.495n 0.0v 159.505n 0.0v 169.495n 0.0v 169.505n 0.0v 179.495n 0.0v 179.505n 3.3v 189.495n 3.3v 189.505n 3.3v 199.495n 3.3v 199.505n 3.3v 209.495n 3.3v 209.505n 3.3v 219.495n 3.3v 219.505n 0.0v 229.495n 0.0v 229.505n 0.0v 239.495n 0.0v 239.505n 0.0v 249.495n 0.0v 249.505n 0.0v 259.495n 0.0v 259.505n 0.0v 269.495n 0.0v 269.505n 0.0v 279.495n 0.0v 279.505n 0.0v 289.495n 0.0v 289.505n 3.3v 299.495n 3.3v 299.505n 3.3v 309.495n 3.3v 309.505n 3.3v 319.495n 3.3v 319.505n 3.3v 329.495n 3.3v 329.505n 0.0v 339.495n 0.0v 339.505n 0.0v 349.495n 0.0v 349.505n 0.0v 359.495n 0.0v 359.505n 0.0v 369.495n 0.0v 369.505n 0.0v 379.495n 0.0v 379.505n 0.0v 389.495n 0.0v 389.505n 3.3v 399.495n 3.3v 399.505n 3.3v 409.495n 3.3v 409.505n 3.3v 419.495n 3.3v 419.505n 3.3v 429.495n 3.3v 429.505n 3.3v 439.495n 3.3v 439.505n 3.3v 449.495n 3.3v 449.505n 0.0v 459.495n 0.0v 459.505n 3.3v 469.495n 3.3v 469.505n 0.0v 479.495n 0.0v 479.505n 3.3v 489.495n 3.3v 489.505n 3.3v 499.495n 3.3v 499.505n 3.3v 509.495n 3.3v 509.505n 3.3v 519.495n 3.3v 519.505n 3.3v 529.495n 3.3v 529.505n 3.3v 539.495n 3.3v 539.505n 3.3v 549.495n 3.3v 549.505n 3.3v 559.495n 3.3v 559.505n 3.3v 569.495n 3.3v 569.505n 3.3v 579.495n 3.3v 579.505n 3.3v 589.495n 3.3v 589.505n 3.3v 599.495n 3.3v 599.505n 3.3v 609.495n 3.3v 609.505n 0.0v 619.495n 0.0v 619.505n 0.0v 629.495n 0.0v 629.505n 0.0v 639.495n 0.0v 639.505n 3.3v 649.495n 3.3v 649.505n 3.3v 659.495n 3.3v 659.505n 3.3v 669.495n 3.3v 669.505n 3.3v 679.495n 3.3v 679.505n 0.0v 689.495n 0.0v 689.505n 0.0v 699.495n 0.0v 699.505n 0.0v 709.495n 0.0v 709.505n 3.3v 719.495n 3.3v 719.505n 0.0v 729.495n 0.0v 729.505n 3.3v 739.495n 3.3v 739.505n 0.0v 749.495n 0.0v 749.505n 0.0v 759.495n 0.0v 759.505n 0.0v 769.495n 0.0v 769.505n 3.3v 779.495n 3.3v 779.505n 0.0v 789.495n 0.0v 789.505n 3.3v 799.495n 3.3v 799.505n 0.0v 809.495n 0.0v 809.505n 0.0v 819.495n 0.0v 819.505n 0.0v 829.495n 0.0v 829.505n 0.0v 839.495n 0.0v 839.505n 3.3v 849.495n 3.3v 849.505n 3.3v 859.495n 3.3v 859.505n 3.3v 869.495n 3.3v 869.505n 3.3v 879.495n 3.3v 879.505n 3.3v 889.495n 3.3v 889.505n 3.3v 899.495n 3.3v 899.505n 3.3v 909.495n 3.3v 909.505n 3.3v 919.495n 3.3v 919.505n 3.3v 929.495n 3.3v 929.505n 3.3v 939.495n 3.3v 939.505n 3.3v 949.495n 3.3v 949.505n 3.3v 959.495n 3.3v 959.505n 3.3v 969.495n 3.3v 969.505n 0.0v 979.495n 0.0v 979.505n 0.0v 989.495n 0.0v 989.505n 3.3v 999.495n 3.3v 999.505n 3.3v 1009.495n 3.3v 1009.505n 0.0v 1019.495n 0.0v 1019.505n 3.3v 1029.495n 3.3v 1029.505n 3.3v 1039.495n 3.3v 1039.505n 3.3v 1049.495n 3.3v 1049.505n 0.0v 1059.495n 0.0v 1059.505n 0.0v 1069.495n 0.0v 1069.505n 3.3v 1079.495n 3.3v 1079.505n 0.0v 1089.495n 0.0v 1089.505n 0.0v 1099.495n 0.0v 1099.505n 0.0v 1109.495n 0.0v 1109.505n 0.0v 1119.495n 0.0v 1119.505n 3.3v 1129.495n 3.3v 1129.505n 3.3v 1139.495n 3.3v 1139.505n 3.3v 1149.495n 3.3v 1149.505n 3.3v 1159.495n 3.3v 1159.505n 3.3v 1169.495n 3.3v 1169.505n 3.3v 1179.495n 3.3v 1179.505n 0.0v 1189.495n 0.0v 1189.505n 0.0v 1199.495n 0.0v 1199.505n 3.3v 1209.495n 3.3v 1209.505n 3.3v 1219.495n 3.3v 1219.505n 3.3v 1229.495n 3.3v 1229.505n 0.0v 1239.495n 0.0v 1239.505n 3.3v 1249.495n 3.3v 1249.505n 0.0v 1259.495n 0.0v 1259.505n 0.0v 1269.495n 0.0v 1269.505n 0.0v 1279.495n 0.0v 1279.505n 3.3v 1289.495n 3.3v 1289.505n 0.0v 1299.495n 0.0v 1299.505n 0.0v 1309.495n 0.0v 1309.505n 0.0v 1319.495n 0.0v 1319.505n 3.3v 1329.495n 3.3v 1329.505n 0.0v 1339.495n 0.0v 1339.505n 3.3v 1349.495n 3.3v 1349.505n 0.0v 1359.495n 0.0v 1359.505n 0.0v 1369.495n 0.0v 1369.505n 3.3v 1379.495n 3.3v 1379.505n 3.3v 1389.495n 3.3v 1389.505n 3.3v 1399.495n 3.3v 1399.505n 3.3v 1409.495n 3.3v 1409.505n 3.3v 1419.495n 3.3v 1419.505n 0.0v 1429.495n 0.0v 1429.505n 0.0v 1439.495n 0.0v 1439.505n 3.3v 1449.495n 3.3v 1449.505n 0.0v 1459.495n 0.0v 1459.505n 0.0v 1469.495n 0.0v 1469.505n 0.0v 1479.495n 0.0v 1479.505n 3.3v 1489.495n 3.3v 1489.505n 3.3v 1499.495n 3.3v 1499.505n 3.3v 1509.495n 3.3v 1509.505n 3.3v 1519.495n 3.3v 1519.505n 3.3v 1529.495n 3.3v 1529.505n 3.3v 1539.495n 3.3v 1539.505n 3.3v 1549.495n 3.3v 1549.505n 3.3v 1559.495n 3.3v 1559.505n 0.0v 1569.495n 0.0v 1569.505n 3.3v 1579.495n 3.3v 1579.505n 0.0v 1589.495n 0.0v 1589.505n 3.3v 1599.495n 3.3v 1599.505n 3.3v 1609.495n 3.3v 1609.505n 0.0v 1619.495n 0.0v 1619.505n 0.0v 1629.495n 0.0v 1629.505n 0.0v 1639.495n 0.0v 1639.505n 0.0v 1649.495n 0.0v 1649.505n 0.0v 1659.495n 0.0v 1659.505n 0.0v 1669.495n 0.0v 1669.505n 0.0v 1679.495n 0.0v 1679.505n 0.0v 1689.495n 0.0v 1689.505n 0.0v 1699.495n 0.0v 1699.505n 0.0v 1709.495n 0.0v 1709.505n 0.0v 1719.495n 0.0v 1719.505n 0.0v 1729.495n 0.0v 1729.505n 3.3v 1739.495n 3.3v 1739.505n 0.0v 1749.495n 0.0v 1749.505n 3.3v 1759.495n 3.3v 1759.505n 0.0v 1769.495n 0.0v 1769.505n 3.3v 1779.495n 3.3v 1779.505n 0.0v 1789.495n 0.0v 1789.505n 0.0v 1799.495n 0.0v 1799.505n 3.3v 1809.495n 3.3v 1809.505n 0.0v 1819.495n 0.0v 1819.505n 3.3v 1829.495n 3.3v 1829.505n 3.3v 1839.495n 3.3v 1839.505n 3.3v 1849.495n 3.3v 1849.505n 3.3v 1859.495n 3.3v 1859.505n 0.0v 1869.495n 0.0v 1869.505n 3.3v 1879.495n 3.3v 1879.505n 3.3v 1889.495n 3.3v 1889.505n 3.3v 1899.495n 3.3v 1899.505n 0.0v 1909.495n 0.0v 1909.505n 0.0v 1919.495n 0.0v 1919.505n 0.0v 1929.495n 0.0v 1929.505n 0.0v 1939.495n 0.0v 1939.505n 3.3v 1949.495n 3.3v 1949.505n 3.3v 1959.495n 3.3v 1959.505n 3.3v 1969.495n 3.3v 1969.505n 0.0v 1979.495n 0.0v 1979.505n 3.3v 1989.495n 3.3v 1989.505n 3.3v 1999.495n 3.3v 1999.505n 0.0v 2009.495n 0.0v 2009.505n 3.3v 2019.495n 3.3v 2019.505n 3.3v 2029.495n 3.3v 2029.505n 0.0v 2039.495n 0.0v 2039.505n 0.0v 2049.495n 0.0v 2049.505n 0.0v )
* (time, data): [(0, 0), (10, 0), (20, 0), (30, 0), (40, 1), (50, 0), (60, 0), (70, 0), (80, 1), (90, 1), (100, 1), (110, 1), (120, 0), (130, 0), (140, 0), (150, 0), (160, 0), (170, 0), (180, 1), (190, 1), (200, 1), (210, 1), (220, 0), (230, 0), (240, 0), (250, 0), (260, 0), (270, 0), (280, 0), (290, 1), (300, 1), (310, 1), (320, 1), (330, 0), (340, 0), (350, 0), (360, 0), (370, 0), (380, 0), (390, 1), (400, 1), (410, 1), (420, 1), (430, 1), (440, 1), (450, 0), (460, 1), (470, 0), (480, 1), (490, 1), (500, 1), (510, 1), (520, 1), (530, 1), (540, 1), (550, 1), (560, 1), (570, 1), (580, 1), (590, 1), (600, 1), (610, 0), (620, 0), (630, 0), (640, 1), (650, 1), (660, 1), (670, 1), (680, 0), (690, 0), (700, 0), (710, 1), (720, 0), (730, 1), (740, 0), (750, 0), (760, 0), (770, 1), (780, 0), (790, 1), (800, 0), (810, 0), (820, 0), (830, 0), (840, 1), (850, 1), (860, 1), (870, 1), (880, 1), (890, 1), (900, 1), (910, 1), (920, 1), (930, 1), (940, 1), (950, 1), (960, 1), (970, 0), (980, 0), (990, 1), (1000, 1), (1010, 0), (1020, 1), (1030, 1), (1040, 1), (1050, 0), (1060, 0), (1070, 1), (1080, 0), (1090, 0), (1100, 0), (1110, 0), (1120, 1), (1130, 1), (1140, 1), (1150, 1), (1160, 1), (1170, 1), (1180, 0), (1190, 0), (1200, 1), (1210, 1), (1220, 1), (1230, 0), (1240, 1), (1250, 0), (1260, 0), (1270, 0), (1280, 1), (1290, 0), (1300, 0), (1310, 0), (1320, 1), (1330, 0), (1340, 1), (1350, 0), (1360, 0), (1370, 1), (1380, 1), (1390, 1), (1400, 1), (1410, 1), (1420, 0), (1430, 0), (1440, 1), (1450, 0), (1460, 0), (1470, 0), (1480, 1), (1490, 1), (1500, 1), (1510, 1), (1520, 1), (1530, 1), (1540, 1), (1550, 1), (1560, 0), (1570, 1), (1580, 0), (1590, 1), (1600, 1), (1610, 0), (1620, 0), (1630, 0), (1640, 0), (1650, 0), (1660, 0), (1670, 0), (1680, 0), (1690, 0), (1700, 0), (1710, 0), (1720, 0), (1730, 1), (1740, 0), (1750, 1), (1760, 0), (1770, 1), (1780, 0), (1790, 0), (1800, 1), (1810, 0), (1820, 1), (1830, 1), (1840, 1), (1850, 1), (1860, 0), (1870, 1), (1880, 1), (1890, 1), (1900, 0), (1910, 0), (1920, 0), (1930, 0), (1940, 1), (1950, 1), (1960, 1), (1970, 0), (1980, 1), (1990, 1), (2000, 0), (2010, 1), (2020, 1), (2030, 0), (2040, 0), (2050, 0)]
Va1_2  a1_2  0 PWL (0n 0.0v 9.495n 0.0v 9.505n 0.0v 19.495n 0.0v 19.505n 0.0v 29.495n 0.0v 29.505n 0.0v 39.495n 0.0v 39.505n 3.3v 49.495n 3.3v 49.505n 0.0v 59.495n 0.0v 59.505n 0.0v 69.495n 0.0v 69.505n 0.0v 79.495n 0.0v 79.505n 3.3v 89.495n 3.3v 89.505n 3.3v 99.495n 3.3v 99.505n 3.3v 109.495n 3.3v 109.505n 3.3v 119.495n 3.3v 119.505n 0.0v 129.495n 0.0v 129.505n 0.0v 139.495n 0.0v 139.505n 0.0v 149.495n 0.0v 149.505n 0.0v 159.495n 0.0v 159.505n 0.0v 169.495n 0.0v 169.505n 0.0v 179.495n 0.0v 179.505n 3.3v 189.495n 3.3v 189.505n 3.3v 199.495n 3.3v 199.505n 3.3v 209.495n 3.3v 209.505n 3.3v 219.495n 3.3v 219.505n 0.0v 229.495n 0.0v 229.505n 0.0v 239.495n 0.0v 239.505n 0.0v 249.495n 0.0v 249.505n 0.0v 259.495n 0.0v 259.505n 0.0v 269.495n 0.0v 269.505n 0.0v 279.495n 0.0v 279.505n 0.0v 289.495n 0.0v 289.505n 3.3v 299.495n 3.3v 299.505n 3.3v 309.495n 3.3v 309.505n 3.3v 319.495n 3.3v 319.505n 3.3v 329.495n 3.3v 329.505n 0.0v 339.495n 0.0v 339.505n 0.0v 349.495n 0.0v 349.505n 0.0v 359.495n 0.0v 359.505n 0.0v 369.495n 0.0v 369.505n 0.0v 379.495n 0.0v 379.505n 0.0v 389.495n 0.0v 389.505n 3.3v 399.495n 3.3v 399.505n 3.3v 409.495n 3.3v 409.505n 3.3v 419.495n 3.3v 419.505n 3.3v 429.495n 3.3v 429.505n 3.3v 439.495n 3.3v 439.505n 3.3v 449.495n 3.3v 449.505n 0.0v 459.495n 0.0v 459.505n 3.3v 469.495n 3.3v 469.505n 0.0v 479.495n 0.0v 479.505n 3.3v 489.495n 3.3v 489.505n 3.3v 499.495n 3.3v 499.505n 3.3v 509.495n 3.3v 509.505n 3.3v 519.495n 3.3v 519.505n 3.3v 529.495n 3.3v 529.505n 3.3v 539.495n 3.3v 539.505n 3.3v 549.495n 3.3v 549.505n 3.3v 559.495n 3.3v 559.505n 3.3v 569.495n 3.3v 569.505n 3.3v 579.495n 3.3v 579.505n 3.3v 589.495n 3.3v 589.505n 3.3v 599.495n 3.3v 599.505n 3.3v 609.495n 3.3v 609.505n 0.0v 619.495n 0.0v 619.505n 0.0v 629.495n 0.0v 629.505n 0.0v 639.495n 0.0v 639.505n 3.3v 649.495n 3.3v 649.505n 3.3v 659.495n 3.3v 659.505n 3.3v 669.495n 3.3v 669.505n 3.3v 679.495n 3.3v 679.505n 0.0v 689.495n 0.0v 689.505n 0.0v 699.495n 0.0v 699.505n 0.0v 709.495n 0.0v 709.505n 3.3v 719.495n 3.3v 719.505n 0.0v 729.495n 0.0v 729.505n 3.3v 739.495n 3.3v 739.505n 0.0v 749.495n 0.0v 749.505n 0.0v 759.495n 0.0v 759.505n 0.0v 769.495n 0.0v 769.505n 3.3v 779.495n 3.3v 779.505n 0.0v 789.495n 0.0v 789.505n 3.3v 799.495n 3.3v 799.505n 0.0v 809.495n 0.0v 809.505n 0.0v 819.495n 0.0v 819.505n 0.0v 829.495n 0.0v 829.505n 0.0v 839.495n 0.0v 839.505n 3.3v 849.495n 3.3v 849.505n 3.3v 859.495n 3.3v 859.505n 3.3v 869.495n 3.3v 869.505n 3.3v 879.495n 3.3v 879.505n 3.3v 889.495n 3.3v 889.505n 3.3v 899.495n 3.3v 899.505n 3.3v 909.495n 3.3v 909.505n 3.3v 919.495n 3.3v 919.505n 3.3v 929.495n 3.3v 929.505n 3.3v 939.495n 3.3v 939.505n 3.3v 949.495n 3.3v 949.505n 3.3v 959.495n 3.3v 959.505n 3.3v 969.495n 3.3v 969.505n 0.0v 979.495n 0.0v 979.505n 0.0v 989.495n 0.0v 989.505n 3.3v 999.495n 3.3v 999.505n 3.3v 1009.495n 3.3v 1009.505n 0.0v 1019.495n 0.0v 1019.505n 3.3v 1029.495n 3.3v 1029.505n 3.3v 1039.495n 3.3v 1039.505n 3.3v 1049.495n 3.3v 1049.505n 0.0v 1059.495n 0.0v 1059.505n 0.0v 1069.495n 0.0v 1069.505n 3.3v 1079.495n 3.3v 1079.505n 0.0v 1089.495n 0.0v 1089.505n 0.0v 1099.495n 0.0v 1099.505n 0.0v 1109.495n 0.0v 1109.505n 0.0v 1119.495n 0.0v 1119.505n 3.3v 1129.495n 3.3v 1129.505n 3.3v 1139.495n 3.3v 1139.505n 3.3v 1149.495n 3.3v 1149.505n 3.3v 1159.495n 3.3v 1159.505n 3.3v 1169.495n 3.3v 1169.505n 3.3v 1179.495n 3.3v 1179.505n 0.0v 1189.495n 0.0v 1189.505n 0.0v 1199.495n 0.0v 1199.505n 3.3v 1209.495n 3.3v 1209.505n 3.3v 1219.495n 3.3v 1219.505n 3.3v 1229.495n 3.3v 1229.505n 0.0v 1239.495n 0.0v 1239.505n 3.3v 1249.495n 3.3v 1249.505n 0.0v 1259.495n 0.0v 1259.505n 0.0v 1269.495n 0.0v 1269.505n 0.0v 1279.495n 0.0v 1279.505n 3.3v 1289.495n 3.3v 1289.505n 0.0v 1299.495n 0.0v 1299.505n 0.0v 1309.495n 0.0v 1309.505n 0.0v 1319.495n 0.0v 1319.505n 3.3v 1329.495n 3.3v 1329.505n 0.0v 1339.495n 0.0v 1339.505n 3.3v 1349.495n 3.3v 1349.505n 0.0v 1359.495n 0.0v 1359.505n 0.0v 1369.495n 0.0v 1369.505n 3.3v 1379.495n 3.3v 1379.505n 3.3v 1389.495n 3.3v 1389.505n 3.3v 1399.495n 3.3v 1399.505n 3.3v 1409.495n 3.3v 1409.505n 3.3v 1419.495n 3.3v 1419.505n 0.0v 1429.495n 0.0v 1429.505n 0.0v 1439.495n 0.0v 1439.505n 3.3v 1449.495n 3.3v 1449.505n 0.0v 1459.495n 0.0v 1459.505n 0.0v 1469.495n 0.0v 1469.505n 0.0v 1479.495n 0.0v 1479.505n 3.3v 1489.495n 3.3v 1489.505n 3.3v 1499.495n 3.3v 1499.505n 3.3v 1509.495n 3.3v 1509.505n 3.3v 1519.495n 3.3v 1519.505n 3.3v 1529.495n 3.3v 1529.505n 3.3v 1539.495n 3.3v 1539.505n 3.3v 1549.495n 3.3v 1549.505n 3.3v 1559.495n 3.3v 1559.505n 0.0v 1569.495n 0.0v 1569.505n 3.3v 1579.495n 3.3v 1579.505n 0.0v 1589.495n 0.0v 1589.505n 3.3v 1599.495n 3.3v 1599.505n 3.3v 1609.495n 3.3v 1609.505n 0.0v 1619.495n 0.0v 1619.505n 0.0v 1629.495n 0.0v 1629.505n 0.0v 1639.495n 0.0v 1639.505n 0.0v 1649.495n 0.0v 1649.505n 0.0v 1659.495n 0.0v 1659.505n 0.0v 1669.495n 0.0v 1669.505n 0.0v 1679.495n 0.0v 1679.505n 0.0v 1689.495n 0.0v 1689.505n 0.0v 1699.495n 0.0v 1699.505n 0.0v 1709.495n 0.0v 1709.505n 0.0v 1719.495n 0.0v 1719.505n 0.0v 1729.495n 0.0v 1729.505n 3.3v 1739.495n 3.3v 1739.505n 0.0v 1749.495n 0.0v 1749.505n 3.3v 1759.495n 3.3v 1759.505n 0.0v 1769.495n 0.0v 1769.505n 3.3v 1779.495n 3.3v 1779.505n 0.0v 1789.495n 0.0v 1789.505n 0.0v 1799.495n 0.0v 1799.505n 3.3v 1809.495n 3.3v 1809.505n 0.0v 1819.495n 0.0v 1819.505n 3.3v 1829.495n 3.3v 1829.505n 3.3v 1839.495n 3.3v 1839.505n 3.3v 1849.495n 3.3v 1849.505n 3.3v 1859.495n 3.3v 1859.505n 0.0v 1869.495n 0.0v 1869.505n 3.3v 1879.495n 3.3v 1879.505n 3.3v 1889.495n 3.3v 1889.505n 3.3v 1899.495n 3.3v 1899.505n 0.0v 1909.495n 0.0v 1909.505n 0.0v 1919.495n 0.0v 1919.505n 0.0v 1929.495n 0.0v 1929.505n 0.0v 1939.495n 0.0v 1939.505n 3.3v 1949.495n 3.3v 1949.505n 3.3v 1959.495n 3.3v 1959.505n 3.3v 1969.495n 3.3v 1969.505n 0.0v 1979.495n 0.0v 1979.505n 3.3v 1989.495n 3.3v 1989.505n 3.3v 1999.495n 3.3v 1999.505n 0.0v 2009.495n 0.0v 2009.505n 3.3v 2019.495n 3.3v 2019.505n 3.3v 2029.495n 3.3v 2029.505n 0.0v 2039.495n 0.0v 2039.505n 0.0v 2049.495n 0.0v 2049.505n 0.0v )
* (time, data): [(0, 0), (10, 0), (20, 0), (30, 0), (40, 1), (50, 0), (60, 0), (70, 0), (80, 1), (90, 1), (100, 1), (110, 1), (120, 0), (130, 0), (140, 0), (150, 0), (160, 0), (170, 0), (180, 1), (190, 1), (200, 1), (210, 1), (220, 0), (230, 0), (240, 0), (250, 0), (260, 0), (270, 0), (280, 0), (290, 1), (300, 1), (310, 1), (320, 1), (330, 0), (340, 0), (350, 0), (360, 0), (370, 0), (380, 0), (390, 1), (400, 1), (410, 1), (420, 1), (430, 1), (440, 1), (450, 0), (460, 1), (470, 0), (480, 1), (490, 1), (500, 1), (510, 1), (520, 1), (530, 1), (540, 1), (550, 1), (560, 1), (570, 1), (580, 1), (590, 1), (600, 1), (610, 0), (620, 0), (630, 0), (640, 1), (650, 1), (660, 1), (670, 1), (680, 0), (690, 0), (700, 0), (710, 1), (720, 0), (730, 1), (740, 0), (750, 0), (760, 0), (770, 1), (780, 0), (790, 1), (800, 0), (810, 0), (820, 0), (830, 0), (840, 1), (850, 1), (860, 1), (870, 1), (880, 1), (890, 1), (900, 1), (910, 1), (920, 1), (930, 1), (940, 1), (950, 1), (960, 1), (970, 0), (980, 0), (990, 1), (1000, 1), (1010, 0), (1020, 1), (1030, 1), (1040, 1), (1050, 0), (1060, 0), (1070, 1), (1080, 0), (1090, 0), (1100, 0), (1110, 0), (1120, 1), (1130, 1), (1140, 1), (1150, 1), (1160, 1), (1170, 1), (1180, 0), (1190, 0), (1200, 1), (1210, 1), (1220, 1), (1230, 0), (1240, 1), (1250, 0), (1260, 0), (1270, 0), (1280, 1), (1290, 0), (1300, 0), (1310, 0), (1320, 1), (1330, 0), (1340, 1), (1350, 0), (1360, 0), (1370, 1), (1380, 1), (1390, 1), (1400, 1), (1410, 1), (1420, 0), (1430, 0), (1440, 1), (1450, 0), (1460, 0), (1470, 0), (1480, 1), (1490, 1), (1500, 1), (1510, 1), (1520, 1), (1530, 1), (1540, 1), (1550, 1), (1560, 0), (1570, 1), (1580, 0), (1590, 1), (1600, 1), (1610, 0), (1620, 0), (1630, 0), (1640, 0), (1650, 0), (1660, 0), (1670, 0), (1680, 0), (1690, 0), (1700, 0), (1710, 0), (1720, 0), (1730, 1), (1740, 0), (1750, 1), (1760, 0), (1770, 1), (1780, 0), (1790, 0), (1800, 1), (1810, 0), (1820, 1), (1830, 1), (1840, 1), (1850, 1), (1860, 0), (1870, 1), (1880, 1), (1890, 1), (1900, 0), (1910, 0), (1920, 0), (1930, 0), (1940, 1), (1950, 1), (1960, 1), (1970, 0), (1980, 1), (1990, 1), (2000, 0), (2010, 1), (2020, 1), (2030, 0), (2040, 0), (2050, 0)]
Va1_3  a1_3  0 PWL (0n 0.0v 9.495n 0.0v 9.505n 0.0v 19.495n 0.0v 19.505n 0.0v 29.495n 0.0v 29.505n 0.0v 39.495n 0.0v 39.505n 3.3v 49.495n 3.3v 49.505n 0.0v 59.495n 0.0v 59.505n 0.0v 69.495n 0.0v 69.505n 0.0v 79.495n 0.0v 79.505n 3.3v 89.495n 3.3v 89.505n 3.3v 99.495n 3.3v 99.505n 3.3v 109.495n 3.3v 109.505n 3.3v 119.495n 3.3v 119.505n 0.0v 129.495n 0.0v 129.505n 0.0v 139.495n 0.0v 139.505n 0.0v 149.495n 0.0v 149.505n 0.0v 159.495n 0.0v 159.505n 0.0v 169.495n 0.0v 169.505n 0.0v 179.495n 0.0v 179.505n 3.3v 189.495n 3.3v 189.505n 3.3v 199.495n 3.3v 199.505n 3.3v 209.495n 3.3v 209.505n 3.3v 219.495n 3.3v 219.505n 0.0v 229.495n 0.0v 229.505n 0.0v 239.495n 0.0v 239.505n 0.0v 249.495n 0.0v 249.505n 0.0v 259.495n 0.0v 259.505n 0.0v 269.495n 0.0v 269.505n 0.0v 279.495n 0.0v 279.505n 0.0v 289.495n 0.0v 289.505n 3.3v 299.495n 3.3v 299.505n 3.3v 309.495n 3.3v 309.505n 3.3v 319.495n 3.3v 319.505n 3.3v 329.495n 3.3v 329.505n 0.0v 339.495n 0.0v 339.505n 0.0v 349.495n 0.0v 349.505n 0.0v 359.495n 0.0v 359.505n 0.0v 369.495n 0.0v 369.505n 0.0v 379.495n 0.0v 379.505n 0.0v 389.495n 0.0v 389.505n 3.3v 399.495n 3.3v 399.505n 3.3v 409.495n 3.3v 409.505n 3.3v 419.495n 3.3v 419.505n 3.3v 429.495n 3.3v 429.505n 3.3v 439.495n 3.3v 439.505n 3.3v 449.495n 3.3v 449.505n 0.0v 459.495n 0.0v 459.505n 3.3v 469.495n 3.3v 469.505n 0.0v 479.495n 0.0v 479.505n 3.3v 489.495n 3.3v 489.505n 3.3v 499.495n 3.3v 499.505n 3.3v 509.495n 3.3v 509.505n 3.3v 519.495n 3.3v 519.505n 3.3v 529.495n 3.3v 529.505n 3.3v 539.495n 3.3v 539.505n 3.3v 549.495n 3.3v 549.505n 3.3v 559.495n 3.3v 559.505n 3.3v 569.495n 3.3v 569.505n 3.3v 579.495n 3.3v 579.505n 3.3v 589.495n 3.3v 589.505n 3.3v 599.495n 3.3v 599.505n 3.3v 609.495n 3.3v 609.505n 0.0v 619.495n 0.0v 619.505n 0.0v 629.495n 0.0v 629.505n 0.0v 639.495n 0.0v 639.505n 3.3v 649.495n 3.3v 649.505n 3.3v 659.495n 3.3v 659.505n 3.3v 669.495n 3.3v 669.505n 3.3v 679.495n 3.3v 679.505n 0.0v 689.495n 0.0v 689.505n 0.0v 699.495n 0.0v 699.505n 0.0v 709.495n 0.0v 709.505n 3.3v 719.495n 3.3v 719.505n 0.0v 729.495n 0.0v 729.505n 3.3v 739.495n 3.3v 739.505n 0.0v 749.495n 0.0v 749.505n 0.0v 759.495n 0.0v 759.505n 0.0v 769.495n 0.0v 769.505n 3.3v 779.495n 3.3v 779.505n 0.0v 789.495n 0.0v 789.505n 3.3v 799.495n 3.3v 799.505n 0.0v 809.495n 0.0v 809.505n 0.0v 819.495n 0.0v 819.505n 0.0v 829.495n 0.0v 829.505n 0.0v 839.495n 0.0v 839.505n 3.3v 849.495n 3.3v 849.505n 3.3v 859.495n 3.3v 859.505n 3.3v 869.495n 3.3v 869.505n 3.3v 879.495n 3.3v 879.505n 3.3v 889.495n 3.3v 889.505n 3.3v 899.495n 3.3v 899.505n 3.3v 909.495n 3.3v 909.505n 3.3v 919.495n 3.3v 919.505n 3.3v 929.495n 3.3v 929.505n 3.3v 939.495n 3.3v 939.505n 3.3v 949.495n 3.3v 949.505n 3.3v 959.495n 3.3v 959.505n 3.3v 969.495n 3.3v 969.505n 0.0v 979.495n 0.0v 979.505n 0.0v 989.495n 0.0v 989.505n 3.3v 999.495n 3.3v 999.505n 3.3v 1009.495n 3.3v 1009.505n 0.0v 1019.495n 0.0v 1019.505n 3.3v 1029.495n 3.3v 1029.505n 3.3v 1039.495n 3.3v 1039.505n 3.3v 1049.495n 3.3v 1049.505n 0.0v 1059.495n 0.0v 1059.505n 0.0v 1069.495n 0.0v 1069.505n 3.3v 1079.495n 3.3v 1079.505n 0.0v 1089.495n 0.0v 1089.505n 0.0v 1099.495n 0.0v 1099.505n 0.0v 1109.495n 0.0v 1109.505n 0.0v 1119.495n 0.0v 1119.505n 3.3v 1129.495n 3.3v 1129.505n 3.3v 1139.495n 3.3v 1139.505n 3.3v 1149.495n 3.3v 1149.505n 3.3v 1159.495n 3.3v 1159.505n 3.3v 1169.495n 3.3v 1169.505n 3.3v 1179.495n 3.3v 1179.505n 0.0v 1189.495n 0.0v 1189.505n 0.0v 1199.495n 0.0v 1199.505n 3.3v 1209.495n 3.3v 1209.505n 3.3v 1219.495n 3.3v 1219.505n 3.3v 1229.495n 3.3v 1229.505n 0.0v 1239.495n 0.0v 1239.505n 3.3v 1249.495n 3.3v 1249.505n 0.0v 1259.495n 0.0v 1259.505n 0.0v 1269.495n 0.0v 1269.505n 0.0v 1279.495n 0.0v 1279.505n 3.3v 1289.495n 3.3v 1289.505n 0.0v 1299.495n 0.0v 1299.505n 0.0v 1309.495n 0.0v 1309.505n 0.0v 1319.495n 0.0v 1319.505n 3.3v 1329.495n 3.3v 1329.505n 0.0v 1339.495n 0.0v 1339.505n 3.3v 1349.495n 3.3v 1349.505n 0.0v 1359.495n 0.0v 1359.505n 0.0v 1369.495n 0.0v 1369.505n 3.3v 1379.495n 3.3v 1379.505n 3.3v 1389.495n 3.3v 1389.505n 3.3v 1399.495n 3.3v 1399.505n 3.3v 1409.495n 3.3v 1409.505n 3.3v 1419.495n 3.3v 1419.505n 0.0v 1429.495n 0.0v 1429.505n 0.0v 1439.495n 0.0v 1439.505n 3.3v 1449.495n 3.3v 1449.505n 0.0v 1459.495n 0.0v 1459.505n 0.0v 1469.495n 0.0v 1469.505n 0.0v 1479.495n 0.0v 1479.505n 3.3v 1489.495n 3.3v 1489.505n 3.3v 1499.495n 3.3v 1499.505n 3.3v 1509.495n 3.3v 1509.505n 3.3v 1519.495n 3.3v 1519.505n 3.3v 1529.495n 3.3v 1529.505n 3.3v 1539.495n 3.3v 1539.505n 3.3v 1549.495n 3.3v 1549.505n 3.3v 1559.495n 3.3v 1559.505n 0.0v 1569.495n 0.0v 1569.505n 3.3v 1579.495n 3.3v 1579.505n 0.0v 1589.495n 0.0v 1589.505n 3.3v 1599.495n 3.3v 1599.505n 3.3v 1609.495n 3.3v 1609.505n 0.0v 1619.495n 0.0v 1619.505n 0.0v 1629.495n 0.0v 1629.505n 0.0v 1639.495n 0.0v 1639.505n 0.0v 1649.495n 0.0v 1649.505n 0.0v 1659.495n 0.0v 1659.505n 0.0v 1669.495n 0.0v 1669.505n 0.0v 1679.495n 0.0v 1679.505n 0.0v 1689.495n 0.0v 1689.505n 0.0v 1699.495n 0.0v 1699.505n 0.0v 1709.495n 0.0v 1709.505n 0.0v 1719.495n 0.0v 1719.505n 0.0v 1729.495n 0.0v 1729.505n 3.3v 1739.495n 3.3v 1739.505n 0.0v 1749.495n 0.0v 1749.505n 3.3v 1759.495n 3.3v 1759.505n 0.0v 1769.495n 0.0v 1769.505n 3.3v 1779.495n 3.3v 1779.505n 0.0v 1789.495n 0.0v 1789.505n 0.0v 1799.495n 0.0v 1799.505n 3.3v 1809.495n 3.3v 1809.505n 0.0v 1819.495n 0.0v 1819.505n 3.3v 1829.495n 3.3v 1829.505n 3.3v 1839.495n 3.3v 1839.505n 3.3v 1849.495n 3.3v 1849.505n 3.3v 1859.495n 3.3v 1859.505n 0.0v 1869.495n 0.0v 1869.505n 3.3v 1879.495n 3.3v 1879.505n 3.3v 1889.495n 3.3v 1889.505n 3.3v 1899.495n 3.3v 1899.505n 0.0v 1909.495n 0.0v 1909.505n 0.0v 1919.495n 0.0v 1919.505n 0.0v 1929.495n 0.0v 1929.505n 0.0v 1939.495n 0.0v 1939.505n 3.3v 1949.495n 3.3v 1949.505n 3.3v 1959.495n 3.3v 1959.505n 3.3v 1969.495n 3.3v 1969.505n 0.0v 1979.495n 0.0v 1979.505n 3.3v 1989.495n 3.3v 1989.505n 3.3v 1999.495n 3.3v 1999.505n 0.0v 2009.495n 0.0v 2009.505n 3.3v 2019.495n 3.3v 2019.505n 3.3v 2029.495n 3.3v 2029.505n 0.0v 2039.495n 0.0v 2039.505n 0.0v 2049.495n 0.0v 2049.505n 0.0v )

 * Generation of control signals
* (time, data): [(0, 1), (10, 0), (20, 0), (30, 0), (40, 0), (50, 0), (60, 0), (70, 1), (80, 1), (90, 0), (100, 0), (110, 0), (120, 0), (130, 0), (140, 0), (150, 0), (160, 0), (170, 0), (180, 0), (190, 0), (200, 0), (210, 0), (220, 0), (230, 1), (240, 0), (250, 0), (260, 0), (270, 0), (280, 0), (290, 0), (300, 0), (310, 0), (320, 0), (330, 1), (340, 0), (350, 0), (360, 1), (370, 0), (380, 1), (390, 0), (400, 0), (410, 0), (420, 0), (430, 0), (440, 0), (450, 0), (460, 0), (470, 1), (480, 0), (490, 0), (500, 0), (510, 0), (520, 0), (530, 0), (540, 0), (550, 0), (560, 0), (570, 0), (580, 1), (590, 0), (600, 1), (610, 0), (620, 0), (630, 0), (640, 0), (650, 0), (660, 0), (670, 0), (680, 0), (690, 0), (700, 1), (710, 1), (720, 0), (730, 1), (740, 0), (750, 1), (760, 0), (770, 0), (780, 0), (790, 0), (800, 0), (810, 0), (820, 0), (830, 0), (840, 0), (850, 1), (860, 1), (870, 0), (880, 0), (890, 0), (900, 1), (910, 0), (920, 0), (930, 0), (940, 0), (950, 0), (960, 0), (970, 0), (980, 0), (990, 0), (1000, 0), (1010, 1), (1020, 0), (1030, 0), (1040, 0), (1050, 0), (1060, 0), (1070, 0), (1080, 1), (1090, 0), (1100, 0), (1110, 0), (1120, 0), (1130, 0), (1140, 0), (1150, 0), (1160, 0), (1170, 1), (1180, 0), (1190, 1), (1200, 1), (1210, 0), (1220, 0), (1230, 0), (1240, 0), (1250, 1), (1260, 0), (1270, 1), (1280, 1), (1290, 0), (1300, 0), (1310, 0), (1320, 0), (1330, 1), (1340, 0), (1350, 0), (1360, 0), (1370, 0), (1380, 0), (1390, 0), (1400, 0), (1410, 1), (1420, 0), (1430, 0), (1440, 0), (1450, 0), (1460, 0), (1470, 0), (1480, 0), (1490, 0), (1500, 0), (1510, 0), (1520, 0), (1530, 0), (1540, 0), (1550, 0), (1560, 1), (1570, 0), (1580, 1), (1590, 0), (1600, 0), (1610, 0), (1620, 0), (1630, 1), (1640, 0), (1650, 0), (1660, 0), (1670, 0), (1680, 1), (1690, 1), (1700, 0), (1710, 0), (1720, 0), (1730, 0), (1740, 0), (1750, 1), (1760, 0), (1770, 0), (1780, 0), (1790, 0), (1800, 0), (1810, 0), (1820, 0), (1830, 1), (1840, 0), (1850, 0), (1860, 1), (1870, 0), (1880, 0), (1890, 0), (1900, 0), (1910, 0), (1920, 0), (1930, 0), (1940, 0), (1950, 0), (1960, 0), (1970, 0), (1980, 0), (1990, 0), (2000, 0), (2010, 0), (2020, 0), (2030, 1), (2040, 0), (2050, 1)]
VCSB0 CSB0 0 PWL (0n 3.3v 9.495n 3.3v 9.505n 0.0v 19.495n 0.0v 19.505n 0.0v 29.495n 0.0v 29.505n 0.0v 39.495n 0.0v 39.505n 0.0v 49.495n 0.0v 49.505n 0.0v 59.495n 0.0v 59.505n 0.0v 69.495n 0.0v 69.505n 3.3v 79.495n 3.3v 79.505n 3.3v 89.495n 3.3v 89.505n 0.0v 99.495n 0.0v 99.505n 0.0v 109.495n 0.0v 109.505n 0.0v 119.495n 0.0v 119.505n 0.0v 129.495n 0.0v 129.505n 0.0v 139.495n 0.0v 139.505n 0.0v 149.495n 0.0v 149.505n 0.0v 159.495n 0.0v 159.505n 0.0v 169.495n 0.0v 169.505n 0.0v 179.495n 0.0v 179.505n 0.0v 189.495n 0.0v 189.505n 0.0v 199.495n 0.0v 199.505n 0.0v 209.495n 0.0v 209.505n 0.0v 219.495n 0.0v 219.505n 0.0v 229.495n 0.0v 229.505n 3.3v 239.495n 3.3v 239.505n 0.0v 249.495n 0.0v 249.505n 0.0v 259.495n 0.0v 259.505n 0.0v 269.495n 0.0v 269.505n 0.0v 279.495n 0.0v 279.505n 0.0v 289.495n 0.0v 289.505n 0.0v 299.495n 0.0v 299.505n 0.0v 309.495n 0.0v 309.505n 0.0v 319.495n 0.0v 319.505n 0.0v 329.495n 0.0v 329.505n 3.3v 339.495n 3.3v 339.505n 0.0v 349.495n 0.0v 349.505n 0.0v 359.495n 0.0v 359.505n 3.3v 369.495n 3.3v 369.505n 0.0v 379.495n 0.0v 379.505n 3.3v 389.495n 3.3v 389.505n 0.0v 399.495n 0.0v 399.505n 0.0v 409.495n 0.0v 409.505n 0.0v 419.495n 0.0v 419.505n 0.0v 429.495n 0.0v 429.505n 0.0v 439.495n 0.0v 439.505n 0.0v 449.495n 0.0v 449.505n 0.0v 459.495n 0.0v 459.505n 0.0v 469.495n 0.0v 469.505n 3.3v 479.495n 3.3v 479.505n 0.0v 489.495n 0.0v 489.505n 0.0v 499.495n 0.0v 499.505n 0.0v 509.495n 0.0v 509.505n 0.0v 519.495n 0.0v 519.505n 0.0v 529.495n 0.0v 529.505n 0.0v 539.495n 0.0v 539.505n 0.0v 549.495n 0.0v 549.505n 0.0v 559.495n 0.0v 559.505n 0.0v 569.495n 0.0v 569.505n 0.0v 579.495n 0.0v 579.505n 3.3v 589.495n 3.3v 589.505n 0.0v 599.495n 0.0v 599.505n 3.3v 609.495n 3.3v 609.505n 0.0v 619.495n 0.0v 619.505n 0.0v 629.495n 0.0v 629.505n 0.0v 639.495n 0.0v 639.505n 0.0v 649.495n 0.0v 649.505n 0.0v 659.495n 0.0v 659.505n 0.0v 669.495n 0.0v 669.505n 0.0v 679.495n 0.0v 679.505n 0.0v 689.495n 0.0v 689.505n 0.0v 699.495n 0.0v 699.505n 3.3v 709.495n 3.3v 709.505n 3.3v 719.495n 3.3v 719.505n 0.0v 729.495n 0.0v 729.505n 3.3v 739.495n 3.3v 739.505n 0.0v 749.495n 0.0v 749.505n 3.3v 759.495n 3.3v 759.505n 0.0v 769.495n 0.0v 769.505n 0.0v 779.495n 0.0v 779.505n 0.0v 789.495n 0.0v 789.505n 0.0v 799.495n 0.0v 799.505n 0.0v 809.495n 0.0v 809.505n 0.0v 819.495n 0.0v 819.505n 0.0v 829.495n 0.0v 829.505n 0.0v 839.495n 0.0v 839.505n 0.0v 849.495n 0.0v 849.505n 3.3v 859.495n 3.3v 859.505n 3.3v 869.495n 3.3v 869.505n 0.0v 879.495n 0.0v 879.505n 0.0v 889.495n 0.0v 889.505n 0.0v 899.495n 0.0v 899.505n 3.3v 909.495n 3.3v 909.505n 0.0v 919.495n 0.0v 919.505n 0.0v 929.495n 0.0v 929.505n 0.0v 939.495n 0.0v 939.505n 0.0v 949.495n 0.0v 949.505n 0.0v 959.495n 0.0v 959.505n 0.0v 969.495n 0.0v 969.505n 0.0v 979.495n 0.0v 979.505n 0.0v 989.495n 0.0v 989.505n 0.0v 999.495n 0.0v 999.505n 0.0v 1009.495n 0.0v 1009.505n 3.3v 1019.495n 3.3v 1019.505n 0.0v 1029.495n 0.0v 1029.505n 0.0v 1039.495n 0.0v 1039.505n 0.0v 1049.495n 0.0v 1049.505n 0.0v 1059.495n 0.0v 1059.505n 0.0v 1069.495n 0.0v 1069.505n 0.0v 1079.495n 0.0v 1079.505n 3.3v 1089.495n 3.3v 1089.505n 0.0v 1099.495n 0.0v 1099.505n 0.0v 1109.495n 0.0v 1109.505n 0.0v 1119.495n 0.0v 1119.505n 0.0v 1129.495n 0.0v 1129.505n 0.0v 1139.495n 0.0v 1139.505n 0.0v 1149.495n 0.0v 1149.505n 0.0v 1159.495n 0.0v 1159.505n 0.0v 1169.495n 0.0v 1169.505n 3.3v 1179.495n 3.3v 1179.505n 0.0v 1189.495n 0.0v 1189.505n 3.3v 1199.495n 3.3v 1199.505n 3.3v 1209.495n 3.3v 1209.505n 0.0v 1219.495n 0.0v 1219.505n 0.0v 1229.495n 0.0v 1229.505n 0.0v 1239.495n 0.0v 1239.505n 0.0v 1249.495n 0.0v 1249.505n 3.3v 1259.495n 3.3v 1259.505n 0.0v 1269.495n 0.0v 1269.505n 3.3v 1279.495n 3.3v 1279.505n 3.3v 1289.495n 3.3v 1289.505n 0.0v 1299.495n 0.0v 1299.505n 0.0v 1309.495n 0.0v 1309.505n 0.0v 1319.495n 0.0v 1319.505n 0.0v 1329.495n 0.0v 1329.505n 3.3v 1339.495n 3.3v 1339.505n 0.0v 1349.495n 0.0v 1349.505n 0.0v 1359.495n 0.0v 1359.505n 0.0v 1369.495n 0.0v 1369.505n 0.0v 1379.495n 0.0v 1379.505n 0.0v 1389.495n 0.0v 1389.505n 0.0v 1399.495n 0.0v 1399.505n 0.0v 1409.495n 0.0v 1409.505n 3.3v 1419.495n 3.3v 1419.505n 0.0v 1429.495n 0.0v 1429.505n 0.0v 1439.495n 0.0v 1439.505n 0.0v 1449.495n 0.0v 1449.505n 0.0v 1459.495n 0.0v 1459.505n 0.0v 1469.495n 0.0v 1469.505n 0.0v 1479.495n 0.0v 1479.505n 0.0v 1489.495n 0.0v 1489.505n 0.0v 1499.495n 0.0v 1499.505n 0.0v 1509.495n 0.0v 1509.505n 0.0v 1519.495n 0.0v 1519.505n 0.0v 1529.495n 0.0v 1529.505n 0.0v 1539.495n 0.0v 1539.505n 0.0v 1549.495n 0.0v 1549.505n 0.0v 1559.495n 0.0v 1559.505n 3.3v 1569.495n 3.3v 1569.505n 0.0v 1579.495n 0.0v 1579.505n 3.3v 1589.495n 3.3v 1589.505n 0.0v 1599.495n 0.0v 1599.505n 0.0v 1609.495n 0.0v 1609.505n 0.0v 1619.495n 0.0v 1619.505n 0.0v 1629.495n 0.0v 1629.505n 3.3v 1639.495n 3.3v 1639.505n 0.0v 1649.495n 0.0v 1649.505n 0.0v 1659.495n 0.0v 1659.505n 0.0v 1669.495n 0.0v 1669.505n 0.0v 1679.495n 0.0v 1679.505n 3.3v 1689.495n 3.3v 1689.505n 3.3v 1699.495n 3.3v 1699.505n 0.0v 1709.495n 0.0v 1709.505n 0.0v 1719.495n 0.0v 1719.505n 0.0v 1729.495n 0.0v 1729.505n 0.0v 1739.495n 0.0v 1739.505n 0.0v 1749.495n 0.0v 1749.505n 3.3v 1759.495n 3.3v 1759.505n 0.0v 1769.495n 0.0v 1769.505n 0.0v 1779.495n 0.0v 1779.505n 0.0v 1789.495n 0.0v 1789.505n 0.0v 1799.495n 0.0v 1799.505n 0.0v 1809.495n 0.0v 1809.505n 0.0v 1819.495n 0.0v 1819.505n 0.0v 1829.495n 0.0v 1829.505n 3.3v 1839.495n 3.3v 1839.505n 0.0v 1849.495n 0.0v 1849.505n 0.0v 1859.495n 0.0v 1859.505n 3.3v 1869.495n 3.3v 1869.505n 0.0v 1879.495n 0.0v 1879.505n 0.0v 1889.495n 0.0v 1889.505n 0.0v 1899.495n 0.0v 1899.505n 0.0v 1909.495n 0.0v 1909.505n 0.0v 1919.495n 0.0v 1919.505n 0.0v 1929.495n 0.0v 1929.505n 0.0v 1939.495n 0.0v 1939.505n 0.0v 1949.495n 0.0v 1949.505n 0.0v 1959.495n 0.0v 1959.505n 0.0v 1969.495n 0.0v 1969.505n 0.0v 1979.495n 0.0v 1979.505n 0.0v 1989.495n 0.0v 1989.505n 0.0v 1999.495n 0.0v 1999.505n 0.0v 2009.495n 0.0v 2009.505n 0.0v 2019.495n 0.0v 2019.505n 0.0v 2029.495n 0.0v 2029.505n 3.3v 2039.495n 3.3v 2039.505n 0.0v 2049.495n 0.0v 2049.505n 3.3v )
* (time, data): [(0, 1), (10, 0), (20, 0), (30, 0), (40, 0), (50, 0), (60, 0), (70, 0), (80, 0), (90, 1), (100, 0), (110, 1), (120, 0), (130, 0), (140, 1), (150, 0), (160, 0), (170, 1), (180, 0), (190, 1), (200, 1), (210, 1), (220, 0), (230, 0), (240, 1), (250, 1), (260, 1), (270, 0), (280, 1), (290, 0), (300, 0), (310, 0), (320, 1), (330, 0), (340, 1), (350, 1), (360, 0), (370, 1), (380, 0), (390, 0), (400, 1), (410, 0), (420, 0), (430, 1), (440, 0), (450, 0), (460, 0), (470, 0), (480, 0), (490, 1), (500, 0), (510, 1), (520, 1), (530, 1), (540, 0), (550, 1), (560, 1), (570, 1), (580, 0), (590, 1), (600, 1), (610, 0), (620, 0), (630, 0), (640, 0), (650, 1), (660, 0), (670, 1), (680, 0), (690, 0), (700, 0), (710, 0), (720, 0), (730, 0), (740, 0), (750, 0), (760, 1), (770, 0), (780, 0), (790, 0), (800, 0), (810, 0), (820, 0), (830, 0), (840, 0), (850, 1), (860, 0), (870, 0), (880, 1), (890, 1), (900, 0), (910, 0), (920, 1), (930, 0), (940, 0), (950, 1), (960, 0), (970, 0), (980, 1), (990, 0), (1000, 0), (1010, 0), (1020, 0), (1030, 1), (1040, 1), (1050, 0), (1060, 1), (1070, 0), (1080, 0), (1090, 0), (1100, 0), (1110, 1), (1120, 0), (1130, 0), (1140, 1), (1150, 0), (1160, 1), (1170, 1), (1180, 0), (1190, 0), (1200, 0), (1210, 1), (1220, 1), (1230, 0), (1240, 0), (1250, 0), (1260, 0), (1270, 1), (1280, 0), (1290, 0), (1300, 1), (1310, 0), (1320, 0), (1330, 0), (1340, 0), (1350, 0), (1360, 0), (1370, 0), (1380, 1), (1390, 0), (1400, 0), (1410, 0), (1420, 0), (1430, 0), (1440, 0), (1450, 0), (1460, 1), (1470, 0), (1480, 0), (1490, 0), (1500, 1), (1510, 1), (1520, 1), (1530, 0), (1540, 0), (1550, 0), (1560, 0), (1570, 0), (1580, 0), (1590, 0), (1600, 0), (1610, 0), (1620, 1), (1630, 0), (1640, 0), (1650, 0), (1660, 0), (1670, 1), (1680, 0), (1690, 0), (1700, 0), (1710, 1), (1720, 1), (1730, 0), (1740, 0), (1750, 0), (1760, 0), (1770, 0), (1780, 0), (1790, 0), (1800, 0), (1810, 0), (1820, 0), (1830, 0), (1840, 1), (1850, 1), (1860, 0), (1870, 0), (1880, 1), (1890, 1), (1900, 0), (1910, 0), (1920, 0), (1930, 1), (1940, 0), (1950, 0), (1960, 1), (1970, 0), (1980, 0), (1990, 0), (2000, 0), (2010, 0), (2020, 0), (2030, 0), (2040, 1), (2050, 1)]
VCSB1 CSB1 0 PWL (0n 3.3v 9.495n 3.3v 9.505n 0.0v 19.495n 0.0v 19.505n 0.0v 29.495n 0.0v 29.505n 0.0v 39.495n 0.0v 39.505n 0.0v 49.495n 0.0v 49.505n 0.0v 59.495n 0.0v 59.505n 0.0v 69.495n 0.0v 69.505n 0.0v 79.495n 0.0v 79.505n 0.0v 89.495n 0.0v 89.505n 3.3v 99.495n 3.3v 99.505n 0.0v 109.495n 0.0v 109.505n 3.3v 119.495n 3.3v 119.505n 0.0v 129.495n 0.0v 129.505n 0.0v 139.495n 0.0v 139.505n 3.3v 149.495n 3.3v 149.505n 0.0v 159.495n 0.0v 159.505n 0.0v 169.495n 0.0v 169.505n 3.3v 179.495n 3.3v 179.505n 0.0v 189.495n 0.0v 189.505n 3.3v 199.495n 3.3v 199.505n 3.3v 209.495n 3.3v 209.505n 3.3v 219.495n 3.3v 219.505n 0.0v 229.495n 0.0v 229.505n 0.0v 239.495n 0.0v 239.505n 3.3v 249.495n 3.3v 249.505n 3.3v 259.495n 3.3v 259.505n 3.3v 269.495n 3.3v 269.505n 0.0v 279.495n 0.0v 279.505n 3.3v 289.495n 3.3v 289.505n 0.0v 299.495n 0.0v 299.505n 0.0v 309.495n 0.0v 309.505n 0.0v 319.495n 0.0v 319.505n 3.3v 329.495n 3.3v 329.505n 0.0v 339.495n 0.0v 339.505n 3.3v 349.495n 3.3v 349.505n 3.3v 359.495n 3.3v 359.505n 0.0v 369.495n 0.0v 369.505n 3.3v 379.495n 3.3v 379.505n 0.0v 389.495n 0.0v 389.505n 0.0v 399.495n 0.0v 399.505n 3.3v 409.495n 3.3v 409.505n 0.0v 419.495n 0.0v 419.505n 0.0v 429.495n 0.0v 429.505n 3.3v 439.495n 3.3v 439.505n 0.0v 449.495n 0.0v 449.505n 0.0v 459.495n 0.0v 459.505n 0.0v 469.495n 0.0v 469.505n 0.0v 479.495n 0.0v 479.505n 0.0v 489.495n 0.0v 489.505n 3.3v 499.495n 3.3v 499.505n 0.0v 509.495n 0.0v 509.505n 3.3v 519.495n 3.3v 519.505n 3.3v 529.495n 3.3v 529.505n 3.3v 539.495n 3.3v 539.505n 0.0v 549.495n 0.0v 549.505n 3.3v 559.495n 3.3v 559.505n 3.3v 569.495n 3.3v 569.505n 3.3v 579.495n 3.3v 579.505n 0.0v 589.495n 0.0v 589.505n 3.3v 599.495n 3.3v 599.505n 3.3v 609.495n 3.3v 609.505n 0.0v 619.495n 0.0v 619.505n 0.0v 629.495n 0.0v 629.505n 0.0v 639.495n 0.0v 639.505n 0.0v 649.495n 0.0v 649.505n 3.3v 659.495n 3.3v 659.505n 0.0v 669.495n 0.0v 669.505n 3.3v 679.495n 3.3v 679.505n 0.0v 689.495n 0.0v 689.505n 0.0v 699.495n 0.0v 699.505n 0.0v 709.495n 0.0v 709.505n 0.0v 719.495n 0.0v 719.505n 0.0v 729.495n 0.0v 729.505n 0.0v 739.495n 0.0v 739.505n 0.0v 749.495n 0.0v 749.505n 0.0v 759.495n 0.0v 759.505n 3.3v 769.495n 3.3v 769.505n 0.0v 779.495n 0.0v 779.505n 0.0v 789.495n 0.0v 789.505n 0.0v 799.495n 0.0v 799.505n 0.0v 809.495n 0.0v 809.505n 0.0v 819.495n 0.0v 819.505n 0.0v 829.495n 0.0v 829.505n 0.0v 839.495n 0.0v 839.505n 0.0v 849.495n 0.0v 849.505n 3.3v 859.495n 3.3v 859.505n 0.0v 869.495n 0.0v 869.505n 0.0v 879.495n 0.0v 879.505n 3.3v 889.495n 3.3v 889.505n 3.3v 899.495n 3.3v 899.505n 0.0v 909.495n 0.0v 909.505n 0.0v 919.495n 0.0v 919.505n 3.3v 929.495n 3.3v 929.505n 0.0v 939.495n 0.0v 939.505n 0.0v 949.495n 0.0v 949.505n 3.3v 959.495n 3.3v 959.505n 0.0v 969.495n 0.0v 969.505n 0.0v 979.495n 0.0v 979.505n 3.3v 989.495n 3.3v 989.505n 0.0v 999.495n 0.0v 999.505n 0.0v 1009.495n 0.0v 1009.505n 0.0v 1019.495n 0.0v 1019.505n 0.0v 1029.495n 0.0v 1029.505n 3.3v 1039.495n 3.3v 1039.505n 3.3v 1049.495n 3.3v 1049.505n 0.0v 1059.495n 0.0v 1059.505n 3.3v 1069.495n 3.3v 1069.505n 0.0v 1079.495n 0.0v 1079.505n 0.0v 1089.495n 0.0v 1089.505n 0.0v 1099.495n 0.0v 1099.505n 0.0v 1109.495n 0.0v 1109.505n 3.3v 1119.495n 3.3v 1119.505n 0.0v 1129.495n 0.0v 1129.505n 0.0v 1139.495n 0.0v 1139.505n 3.3v 1149.495n 3.3v 1149.505n 0.0v 1159.495n 0.0v 1159.505n 3.3v 1169.495n 3.3v 1169.505n 3.3v 1179.495n 3.3v 1179.505n 0.0v 1189.495n 0.0v 1189.505n 0.0v 1199.495n 0.0v 1199.505n 0.0v 1209.495n 0.0v 1209.505n 3.3v 1219.495n 3.3v 1219.505n 3.3v 1229.495n 3.3v 1229.505n 0.0v 1239.495n 0.0v 1239.505n 0.0v 1249.495n 0.0v 1249.505n 0.0v 1259.495n 0.0v 1259.505n 0.0v 1269.495n 0.0v 1269.505n 3.3v 1279.495n 3.3v 1279.505n 0.0v 1289.495n 0.0v 1289.505n 0.0v 1299.495n 0.0v 1299.505n 3.3v 1309.495n 3.3v 1309.505n 0.0v 1319.495n 0.0v 1319.505n 0.0v 1329.495n 0.0v 1329.505n 0.0v 1339.495n 0.0v 1339.505n 0.0v 1349.495n 0.0v 1349.505n 0.0v 1359.495n 0.0v 1359.505n 0.0v 1369.495n 0.0v 1369.505n 0.0v 1379.495n 0.0v 1379.505n 3.3v 1389.495n 3.3v 1389.505n 0.0v 1399.495n 0.0v 1399.505n 0.0v 1409.495n 0.0v 1409.505n 0.0v 1419.495n 0.0v 1419.505n 0.0v 1429.495n 0.0v 1429.505n 0.0v 1439.495n 0.0v 1439.505n 0.0v 1449.495n 0.0v 1449.505n 0.0v 1459.495n 0.0v 1459.505n 3.3v 1469.495n 3.3v 1469.505n 0.0v 1479.495n 0.0v 1479.505n 0.0v 1489.495n 0.0v 1489.505n 0.0v 1499.495n 0.0v 1499.505n 3.3v 1509.495n 3.3v 1509.505n 3.3v 1519.495n 3.3v 1519.505n 3.3v 1529.495n 3.3v 1529.505n 0.0v 1539.495n 0.0v 1539.505n 0.0v 1549.495n 0.0v 1549.505n 0.0v 1559.495n 0.0v 1559.505n 0.0v 1569.495n 0.0v 1569.505n 0.0v 1579.495n 0.0v 1579.505n 0.0v 1589.495n 0.0v 1589.505n 0.0v 1599.495n 0.0v 1599.505n 0.0v 1609.495n 0.0v 1609.505n 0.0v 1619.495n 0.0v 1619.505n 3.3v 1629.495n 3.3v 1629.505n 0.0v 1639.495n 0.0v 1639.505n 0.0v 1649.495n 0.0v 1649.505n 0.0v 1659.495n 0.0v 1659.505n 0.0v 1669.495n 0.0v 1669.505n 3.3v 1679.495n 3.3v 1679.505n 0.0v 1689.495n 0.0v 1689.505n 0.0v 1699.495n 0.0v 1699.505n 0.0v 1709.495n 0.0v 1709.505n 3.3v 1719.495n 3.3v 1719.505n 3.3v 1729.495n 3.3v 1729.505n 0.0v 1739.495n 0.0v 1739.505n 0.0v 1749.495n 0.0v 1749.505n 0.0v 1759.495n 0.0v 1759.505n 0.0v 1769.495n 0.0v 1769.505n 0.0v 1779.495n 0.0v 1779.505n 0.0v 1789.495n 0.0v 1789.505n 0.0v 1799.495n 0.0v 1799.505n 0.0v 1809.495n 0.0v 1809.505n 0.0v 1819.495n 0.0v 1819.505n 0.0v 1829.495n 0.0v 1829.505n 0.0v 1839.495n 0.0v 1839.505n 3.3v 1849.495n 3.3v 1849.505n 3.3v 1859.495n 3.3v 1859.505n 0.0v 1869.495n 0.0v 1869.505n 0.0v 1879.495n 0.0v 1879.505n 3.3v 1889.495n 3.3v 1889.505n 3.3v 1899.495n 3.3v 1899.505n 0.0v 1909.495n 0.0v 1909.505n 0.0v 1919.495n 0.0v 1919.505n 0.0v 1929.495n 0.0v 1929.505n 3.3v 1939.495n 3.3v 1939.505n 0.0v 1949.495n 0.0v 1949.505n 0.0v 1959.495n 0.0v 1959.505n 3.3v 1969.495n 3.3v 1969.505n 0.0v 1979.495n 0.0v 1979.505n 0.0v 1989.495n 0.0v 1989.505n 0.0v 1999.495n 0.0v 1999.505n 0.0v 2009.495n 0.0v 2009.505n 0.0v 2019.495n 0.0v 2019.505n 0.0v 2029.495n 0.0v 2029.505n 0.0v 2039.495n 0.0v 2039.505n 3.3v 2049.495n 3.3v 2049.505n 3.3v )
* (time, data): [(0, 1), (10, 0), (20, 0), (30, 0), (40, 1), (50, 1), (60, 1), (70, 1), (80, 1), (90, 1), (100, 1), (110, 1), (120, 0), (130, 1), (140, 0), (150, 0), (160, 1), (170, 0), (180, 0), (190, 0), (200, 0), (210, 0), (220, 0), (230, 1), (240, 0), (250, 0), (260, 1), (270, 0), (280, 1), (290, 1), (300, 1), (310, 0), (320, 0), (330, 1), (340, 1), (350, 0), (360, 1), (370, 1), (380, 1), (390, 1), (400, 1), (410, 1), (420, 0), (430, 0), (440, 1), (450, 0), (460, 1), (470, 1), (480, 1), (490, 0), (500, 0), (510, 0), (520, 0), (530, 1), (540, 1), (550, 0), (560, 0), (570, 0), (580, 1), (590, 1), (600, 1), (610, 1), (620, 1), (630, 1), (640, 1), (650, 0), (660, 1), (670, 0), (680, 1), (690, 1), (700, 1), (710, 1), (720, 1), (730, 1), (740, 0), (750, 1), (760, 1), (770, 1), (780, 1), (790, 1), (800, 1), (810, 1), (820, 1), (830, 1), (840, 0), (850, 1), (860, 1), (870, 1), (880, 0), (890, 0), (900, 1), (910, 1), (920, 0), (930, 0), (940, 1), (950, 0), (960, 1), (970, 1), (980, 0), (990, 1), (1000, 1), (1010, 1), (1020, 1), (1030, 0), (1040, 0), (1050, 1), (1060, 1), (1070, 1), (1080, 1), (1090, 1), (1100, 1), (1110, 0), (1120, 1), (1130, 1), (1140, 1), (1150, 1), (1160, 1), (1170, 1), (1180, 0), (1190, 1), (1200, 1), (1210, 1), (1220, 0), (1230, 1), (1240, 1), (1250, 1), (1260, 0), (1270, 1), (1280, 1), (1290, 1), (1300, 1), (1310, 1), (1320, 1), (1330, 1), (1340, 1), (1350, 1), (1360, 0), (1370, 0), (1380, 1), (1390, 1), (1400, 1), (1410, 1), (1420, 1), (1430, 1), (1440, 0), (1450, 1), (1460, 0), (1470, 1), (1480, 1), (1490, 1), (1500, 0), (1510, 0), (1520, 1), (1530, 0), (1540, 1), (1550, 1), (1560, 1), (1570, 1), (1580, 1), (1590, 0), (1600, 1), (1610, 1), (1620, 0), (1630, 1), (1640, 1), (1650, 1), (1660, 0), (1670, 1), (1680, 1), (1690, 1), (1700, 0), (1710, 0), (1720, 0), (1730, 1), (1740, 1), (1750, 1), (1760, 1), (1770, 0), (1780, 0), (1790, 1), (1800, 1), (1810, 1), (1820, 1), (1830, 1), (1840, 0), (1850, 0), (1860, 1), (1870, 1), (1880, 0), (1890, 0), (1900, 1), (1910, 1), (1920, 1), (1930, 0), (1940, 1), (1950, 1), (1960, 1), (1970, 1), (1980, 0), (1990, 1), (2000, 1), (2010, 0), (2020, 1), (2030, 1), (2040, 1), (2050, 1)]
VWEB0 WEB0 0 PWL (0n 3.3v 9.495n 3.3v 9.505n 0.0v 19.495n 0.0v 19.505n 0.0v 29.495n 0.0v 29.505n 0.0v 39.495n 0.0v 39.505n 3.3v 49.495n 3.3v 49.505n 3.3v 59.495n 3.3v 59.505n 3.3v 69.495n 3.3v 69.505n 3.3v 79.495n 3.3v 79.505n 3.3v 89.495n 3.3v 89.505n 3.3v 99.495n 3.3v 99.505n 3.3v 109.495n 3.3v 109.505n 3.3v 119.495n 3.3v 119.505n 0.0v 129.495n 0.0v 129.505n 3.3v 139.495n 3.3v 139.505n 0.0v 149.495n 0.0v 149.505n 0.0v 159.495n 0.0v 159.505n 3.3v 169.495n 3.3v 169.505n 0.0v 179.495n 0.0v 179.505n 0.0v 189.495n 0.0v 189.505n 0.0v 199.495n 0.0v 199.505n 0.0v 209.495n 0.0v 209.505n 0.0v 219.495n 0.0v 219.505n 0.0v 229.495n 0.0v 229.505n 3.3v 239.495n 3.3v 239.505n 0.0v 249.495n 0.0v 249.505n 0.0v 259.495n 0.0v 259.505n 3.3v 269.495n 3.3v 269.505n 0.0v 279.495n 0.0v 279.505n 3.3v 289.495n 3.3v 289.505n 3.3v 299.495n 3.3v 299.505n 3.3v 309.495n 3.3v 309.505n 0.0v 319.495n 0.0v 319.505n 0.0v 329.495n 0.0v 329.505n 3.3v 339.495n 3.3v 339.505n 3.3v 349.495n 3.3v 349.505n 0.0v 359.495n 0.0v 359.505n 3.3v 369.495n 3.3v 369.505n 3.3v 379.495n 3.3v 379.505n 3.3v 389.495n 3.3v 389.505n 3.3v 399.495n 3.3v 399.505n 3.3v 409.495n 3.3v 409.505n 3.3v 419.495n 3.3v 419.505n 0.0v 429.495n 0.0v 429.505n 0.0v 439.495n 0.0v 439.505n 3.3v 449.495n 3.3v 449.505n 0.0v 459.495n 0.0v 459.505n 3.3v 469.495n 3.3v 469.505n 3.3v 479.495n 3.3v 479.505n 3.3v 489.495n 3.3v 489.505n 0.0v 499.495n 0.0v 499.505n 0.0v 509.495n 0.0v 509.505n 0.0v 519.495n 0.0v 519.505n 0.0v 529.495n 0.0v 529.505n 3.3v 539.495n 3.3v 539.505n 3.3v 549.495n 3.3v 549.505n 0.0v 559.495n 0.0v 559.505n 0.0v 569.495n 0.0v 569.505n 0.0v 579.495n 0.0v 579.505n 3.3v 589.495n 3.3v 589.505n 3.3v 599.495n 3.3v 599.505n 3.3v 609.495n 3.3v 609.505n 3.3v 619.495n 3.3v 619.505n 3.3v 629.495n 3.3v 629.505n 3.3v 639.495n 3.3v 639.505n 3.3v 649.495n 3.3v 649.505n 0.0v 659.495n 0.0v 659.505n 3.3v 669.495n 3.3v 669.505n 0.0v 679.495n 0.0v 679.505n 3.3v 689.495n 3.3v 689.505n 3.3v 699.495n 3.3v 699.505n 3.3v 709.495n 3.3v 709.505n 3.3v 719.495n 3.3v 719.505n 3.3v 729.495n 3.3v 729.505n 3.3v 739.495n 3.3v 739.505n 0.0v 749.495n 0.0v 749.505n 3.3v 759.495n 3.3v 759.505n 3.3v 769.495n 3.3v 769.505n 3.3v 779.495n 3.3v 779.505n 3.3v 789.495n 3.3v 789.505n 3.3v 799.495n 3.3v 799.505n 3.3v 809.495n 3.3v 809.505n 3.3v 819.495n 3.3v 819.505n 3.3v 829.495n 3.3v 829.505n 3.3v 839.495n 3.3v 839.505n 0.0v 849.495n 0.0v 849.505n 3.3v 859.495n 3.3v 859.505n 3.3v 869.495n 3.3v 869.505n 3.3v 879.495n 3.3v 879.505n 0.0v 889.495n 0.0v 889.505n 0.0v 899.495n 0.0v 899.505n 3.3v 909.495n 3.3v 909.505n 3.3v 919.495n 3.3v 919.505n 0.0v 929.495n 0.0v 929.505n 0.0v 939.495n 0.0v 939.505n 3.3v 949.495n 3.3v 949.505n 0.0v 959.495n 0.0v 959.505n 3.3v 969.495n 3.3v 969.505n 3.3v 979.495n 3.3v 979.505n 0.0v 989.495n 0.0v 989.505n 3.3v 999.495n 3.3v 999.505n 3.3v 1009.495n 3.3v 1009.505n 3.3v 1019.495n 3.3v 1019.505n 3.3v 1029.495n 3.3v 1029.505n 0.0v 1039.495n 0.0v 1039.505n 0.0v 1049.495n 0.0v 1049.505n 3.3v 1059.495n 3.3v 1059.505n 3.3v 1069.495n 3.3v 1069.505n 3.3v 1079.495n 3.3v 1079.505n 3.3v 1089.495n 3.3v 1089.505n 3.3v 1099.495n 3.3v 1099.505n 3.3v 1109.495n 3.3v 1109.505n 0.0v 1119.495n 0.0v 1119.505n 3.3v 1129.495n 3.3v 1129.505n 3.3v 1139.495n 3.3v 1139.505n 3.3v 1149.495n 3.3v 1149.505n 3.3v 1159.495n 3.3v 1159.505n 3.3v 1169.495n 3.3v 1169.505n 3.3v 1179.495n 3.3v 1179.505n 0.0v 1189.495n 0.0v 1189.505n 3.3v 1199.495n 3.3v 1199.505n 3.3v 1209.495n 3.3v 1209.505n 3.3v 1219.495n 3.3v 1219.505n 0.0v 1229.495n 0.0v 1229.505n 3.3v 1239.495n 3.3v 1239.505n 3.3v 1249.495n 3.3v 1249.505n 3.3v 1259.495n 3.3v 1259.505n 0.0v 1269.495n 0.0v 1269.505n 3.3v 1279.495n 3.3v 1279.505n 3.3v 1289.495n 3.3v 1289.505n 3.3v 1299.495n 3.3v 1299.505n 3.3v 1309.495n 3.3v 1309.505n 3.3v 1319.495n 3.3v 1319.505n 3.3v 1329.495n 3.3v 1329.505n 3.3v 1339.495n 3.3v 1339.505n 3.3v 1349.495n 3.3v 1349.505n 3.3v 1359.495n 3.3v 1359.505n 0.0v 1369.495n 0.0v 1369.505n 0.0v 1379.495n 0.0v 1379.505n 3.3v 1389.495n 3.3v 1389.505n 3.3v 1399.495n 3.3v 1399.505n 3.3v 1409.495n 3.3v 1409.505n 3.3v 1419.495n 3.3v 1419.505n 3.3v 1429.495n 3.3v 1429.505n 3.3v 1439.495n 3.3v 1439.505n 0.0v 1449.495n 0.0v 1449.505n 3.3v 1459.495n 3.3v 1459.505n 0.0v 1469.495n 0.0v 1469.505n 3.3v 1479.495n 3.3v 1479.505n 3.3v 1489.495n 3.3v 1489.505n 3.3v 1499.495n 3.3v 1499.505n 0.0v 1509.495n 0.0v 1509.505n 0.0v 1519.495n 0.0v 1519.505n 3.3v 1529.495n 3.3v 1529.505n 0.0v 1539.495n 0.0v 1539.505n 3.3v 1549.495n 3.3v 1549.505n 3.3v 1559.495n 3.3v 1559.505n 3.3v 1569.495n 3.3v 1569.505n 3.3v 1579.495n 3.3v 1579.505n 3.3v 1589.495n 3.3v 1589.505n 0.0v 1599.495n 0.0v 1599.505n 3.3v 1609.495n 3.3v 1609.505n 3.3v 1619.495n 3.3v 1619.505n 0.0v 1629.495n 0.0v 1629.505n 3.3v 1639.495n 3.3v 1639.505n 3.3v 1649.495n 3.3v 1649.505n 3.3v 1659.495n 3.3v 1659.505n 0.0v 1669.495n 0.0v 1669.505n 3.3v 1679.495n 3.3v 1679.505n 3.3v 1689.495n 3.3v 1689.505n 3.3v 1699.495n 3.3v 1699.505n 0.0v 1709.495n 0.0v 1709.505n 0.0v 1719.495n 0.0v 1719.505n 0.0v 1729.495n 0.0v 1729.505n 3.3v 1739.495n 3.3v 1739.505n 3.3v 1749.495n 3.3v 1749.505n 3.3v 1759.495n 3.3v 1759.505n 3.3v 1769.495n 3.3v 1769.505n 0.0v 1779.495n 0.0v 1779.505n 0.0v 1789.495n 0.0v 1789.505n 3.3v 1799.495n 3.3v 1799.505n 3.3v 1809.495n 3.3v 1809.505n 3.3v 1819.495n 3.3v 1819.505n 3.3v 1829.495n 3.3v 1829.505n 3.3v 1839.495n 3.3v 1839.505n 0.0v 1849.495n 0.0v 1849.505n 0.0v 1859.495n 0.0v 1859.505n 3.3v 1869.495n 3.3v 1869.505n 3.3v 1879.495n 3.3v 1879.505n 0.0v 1889.495n 0.0v 1889.505n 0.0v 1899.495n 0.0v 1899.505n 3.3v 1909.495n 3.3v 1909.505n 3.3v 1919.495n 3.3v 1919.505n 3.3v 1929.495n 3.3v 1929.505n 0.0v 1939.495n 0.0v 1939.505n 3.3v 1949.495n 3.3v 1949.505n 3.3v 1959.495n 3.3v 1959.505n 3.3v 1969.495n 3.3v 1969.505n 3.3v 1979.495n 3.3v 1979.505n 0.0v 1989.495n 0.0v 1989.505n 3.3v 1999.495n 3.3v 1999.505n 3.3v 2009.495n 3.3v 2009.505n 0.0v 2019.495n 0.0v 2019.505n 3.3v 2029.495n 3.3v 2029.505n 3.3v 2039.495n 3.3v 2039.505n 3.3v 2049.495n 3.3v 2049.505n 3.3v )
* (time, data): [(0, 1), (10, 0), (20, 0), (30, 0), (40, 1), (50, 0), (60, 0), (70, 0), (80, 1), (90, 1), (100, 0), (110, 1), (120, 1), (130, 1), (140, 1), (150, 0), (160, 0), (170, 1), (180, 0), (190, 1), (200, 1), (210, 1), (220, 1), (230, 0), (240, 1), (250, 1), (260, 1), (270, 1), (280, 1), (290, 1), (300, 1), (310, 1), (320, 1), (330, 0), (340, 1), (350, 1), (360, 0), (370, 1), (380, 1), (390, 1), (400, 1), (410, 1), (420, 1), (430, 1), (440, 0), (450, 1), (460, 1), (470, 1), (480, 1), (490, 1), (500, 1), (510, 1), (520, 1), (530, 1), (540, 0), (550, 1), (560, 1), (570, 1), (580, 1), (590, 1), (600, 1), (610, 0), (620, 1), (630, 0), (640, 1), (650, 1), (660, 1), (670, 1), (680, 1), (690, 0), (700, 1), (710, 1), (720, 1), (730, 1), (740, 0), (750, 0), (760, 1), (770, 0), (780, 1), (790, 1), (800, 0), (810, 1), (820, 0), (830, 1), (840, 0), (850, 1), (860, 1), (870, 1), (880, 1), (890, 1), (900, 1), (910, 0), (920, 1), (930, 1), (940, 0), (950, 1), (960, 0), (970, 1), (980, 1), (990, 1), (1000, 0), (1010, 1), (1020, 1), (1030, 1), (1040, 1), (1050, 1), (1060, 1), (1070, 1), (1080, 0), (1090, 0), (1100, 1), (1110, 1), (1120, 1), (1130, 1), (1140, 1), (1150, 1), (1160, 1), (1170, 1), (1180, 1), (1190, 1), (1200, 1), (1210, 1), (1220, 1), (1230, 1), (1240, 0), (1250, 0), (1260, 1), (1270, 1), (1280, 0), (1290, 1), (1300, 1), (1310, 1), (1320, 0), (1330, 1), (1340, 0), (1350, 1), (1360, 0), (1370, 1), (1380, 1), (1390, 0), (1400, 1), (1410, 1), (1420, 1), (1430, 0), (1440, 0), (1450, 1), (1460, 1), (1470, 0), (1480, 0), (1490, 1), (1500, 1), (1510, 1), (1520, 1), (1530, 1), (1540, 1), (1550, 0), (1560, 1), (1570, 0), (1580, 1), (1590, 1), (1600, 1), (1610, 0), (1620, 1), (1630, 0), (1640, 1), (1650, 1), (1660, 0), (1670, 1), (1680, 0), (1690, 1), (1700, 1), (1710, 1), (1720, 1), (1730, 1), (1740, 1), (1750, 1), (1760, 1), (1770, 0), (1780, 1), (1790, 0), (1800, 1), (1810, 1), (1820, 1), (1830, 1), (1840, 1), (1850, 1), (1860, 1), (1870, 1), (1880, 1), (1890, 1), (1900, 1), (1910, 1), (1920, 1), (1930, 1), (1940, 1), (1950, 0), (1960, 1), (1970, 1), (1980, 0), (1990, 1), (2000, 1), (2010, 1), (2020, 0), (2030, 0), (2040, 1), (2050, 1)]
VWEB1 WEB1 0 PWL (0n 3.3v 9.495n 3.3v 9.505n 0.0v 19.495n 0.0v 19.505n 0.0v 29.495n 0.0v 29.505n 0.0v 39.495n 0.0v 39.505n 3.3v 49.495n 3.3v 49.505n 0.0v 59.495n 0.0v 59.505n 0.0v 69.495n 0.0v 69.505n 0.0v 79.495n 0.0v 79.505n 3.3v 89.495n 3.3v 89.505n 3.3v 99.495n 3.3v 99.505n 0.0v 109.495n 0.0v 109.505n 3.3v 119.495n 3.3v 119.505n 3.3v 129.495n 3.3v 129.505n 3.3v 139.495n 3.3v 139.505n 3.3v 149.495n 3.3v 149.505n 0.0v 159.495n 0.0v 159.505n 0.0v 169.495n 0.0v 169.505n 3.3v 179.495n 3.3v 179.505n 0.0v 189.495n 0.0v 189.505n 3.3v 199.495n 3.3v 199.505n 3.3v 209.495n 3.3v 209.505n 3.3v 219.495n 3.3v 219.505n 3.3v 229.495n 3.3v 229.505n 0.0v 239.495n 0.0v 239.505n 3.3v 249.495n 3.3v 249.505n 3.3v 259.495n 3.3v 259.505n 3.3v 269.495n 3.3v 269.505n 3.3v 279.495n 3.3v 279.505n 3.3v 289.495n 3.3v 289.505n 3.3v 299.495n 3.3v 299.505n 3.3v 309.495n 3.3v 309.505n 3.3v 319.495n 3.3v 319.505n 3.3v 329.495n 3.3v 329.505n 0.0v 339.495n 0.0v 339.505n 3.3v 349.495n 3.3v 349.505n 3.3v 359.495n 3.3v 359.505n 0.0v 369.495n 0.0v 369.505n 3.3v 379.495n 3.3v 379.505n 3.3v 389.495n 3.3v 389.505n 3.3v 399.495n 3.3v 399.505n 3.3v 409.495n 3.3v 409.505n 3.3v 419.495n 3.3v 419.505n 3.3v 429.495n 3.3v 429.505n 3.3v 439.495n 3.3v 439.505n 0.0v 449.495n 0.0v 449.505n 3.3v 459.495n 3.3v 459.505n 3.3v 469.495n 3.3v 469.505n 3.3v 479.495n 3.3v 479.505n 3.3v 489.495n 3.3v 489.505n 3.3v 499.495n 3.3v 499.505n 3.3v 509.495n 3.3v 509.505n 3.3v 519.495n 3.3v 519.505n 3.3v 529.495n 3.3v 529.505n 3.3v 539.495n 3.3v 539.505n 0.0v 549.495n 0.0v 549.505n 3.3v 559.495n 3.3v 559.505n 3.3v 569.495n 3.3v 569.505n 3.3v 579.495n 3.3v 579.505n 3.3v 589.495n 3.3v 589.505n 3.3v 599.495n 3.3v 599.505n 3.3v 609.495n 3.3v 609.505n 0.0v 619.495n 0.0v 619.505n 3.3v 629.495n 3.3v 629.505n 0.0v 639.495n 0.0v 639.505n 3.3v 649.495n 3.3v 649.505n 3.3v 659.495n 3.3v 659.505n 3.3v 669.495n 3.3v 669.505n 3.3v 679.495n 3.3v 679.505n 3.3v 689.495n 3.3v 689.505n 0.0v 699.495n 0.0v 699.505n 3.3v 709.495n 3.3v 709.505n 3.3v 719.495n 3.3v 719.505n 3.3v 729.495n 3.3v 729.505n 3.3v 739.495n 3.3v 739.505n 0.0v 749.495n 0.0v 749.505n 0.0v 759.495n 0.0v 759.505n 3.3v 769.495n 3.3v 769.505n 0.0v 779.495n 0.0v 779.505n 3.3v 789.495n 3.3v 789.505n 3.3v 799.495n 3.3v 799.505n 0.0v 809.495n 0.0v 809.505n 3.3v 819.495n 3.3v 819.505n 0.0v 829.495n 0.0v 829.505n 3.3v 839.495n 3.3v 839.505n 0.0v 849.495n 0.0v 849.505n 3.3v 859.495n 3.3v 859.505n 3.3v 869.495n 3.3v 869.505n 3.3v 879.495n 3.3v 879.505n 3.3v 889.495n 3.3v 889.505n 3.3v 899.495n 3.3v 899.505n 3.3v 909.495n 3.3v 909.505n 0.0v 919.495n 0.0v 919.505n 3.3v 929.495n 3.3v 929.505n 3.3v 939.495n 3.3v 939.505n 0.0v 949.495n 0.0v 949.505n 3.3v 959.495n 3.3v 959.505n 0.0v 969.495n 0.0v 969.505n 3.3v 979.495n 3.3v 979.505n 3.3v 989.495n 3.3v 989.505n 3.3v 999.495n 3.3v 999.505n 0.0v 1009.495n 0.0v 1009.505n 3.3v 1019.495n 3.3v 1019.505n 3.3v 1029.495n 3.3v 1029.505n 3.3v 1039.495n 3.3v 1039.505n 3.3v 1049.495n 3.3v 1049.505n 3.3v 1059.495n 3.3v 1059.505n 3.3v 1069.495n 3.3v 1069.505n 3.3v 1079.495n 3.3v 1079.505n 0.0v 1089.495n 0.0v 1089.505n 0.0v 1099.495n 0.0v 1099.505n 3.3v 1109.495n 3.3v 1109.505n 3.3v 1119.495n 3.3v 1119.505n 3.3v 1129.495n 3.3v 1129.505n 3.3v 1139.495n 3.3v 1139.505n 3.3v 1149.495n 3.3v 1149.505n 3.3v 1159.495n 3.3v 1159.505n 3.3v 1169.495n 3.3v 1169.505n 3.3v 1179.495n 3.3v 1179.505n 3.3v 1189.495n 3.3v 1189.505n 3.3v 1199.495n 3.3v 1199.505n 3.3v 1209.495n 3.3v 1209.505n 3.3v 1219.495n 3.3v 1219.505n 3.3v 1229.495n 3.3v 1229.505n 3.3v 1239.495n 3.3v 1239.505n 0.0v 1249.495n 0.0v 1249.505n 0.0v 1259.495n 0.0v 1259.505n 3.3v 1269.495n 3.3v 1269.505n 3.3v 1279.495n 3.3v 1279.505n 0.0v 1289.495n 0.0v 1289.505n 3.3v 1299.495n 3.3v 1299.505n 3.3v 1309.495n 3.3v 1309.505n 3.3v 1319.495n 3.3v 1319.505n 0.0v 1329.495n 0.0v 1329.505n 3.3v 1339.495n 3.3v 1339.505n 0.0v 1349.495n 0.0v 1349.505n 3.3v 1359.495n 3.3v 1359.505n 0.0v 1369.495n 0.0v 1369.505n 3.3v 1379.495n 3.3v 1379.505n 3.3v 1389.495n 3.3v 1389.505n 0.0v 1399.495n 0.0v 1399.505n 3.3v 1409.495n 3.3v 1409.505n 3.3v 1419.495n 3.3v 1419.505n 3.3v 1429.495n 3.3v 1429.505n 0.0v 1439.495n 0.0v 1439.505n 0.0v 1449.495n 0.0v 1449.505n 3.3v 1459.495n 3.3v 1459.505n 3.3v 1469.495n 3.3v 1469.505n 0.0v 1479.495n 0.0v 1479.505n 0.0v 1489.495n 0.0v 1489.505n 3.3v 1499.495n 3.3v 1499.505n 3.3v 1509.495n 3.3v 1509.505n 3.3v 1519.495n 3.3v 1519.505n 3.3v 1529.495n 3.3v 1529.505n 3.3v 1539.495n 3.3v 1539.505n 3.3v 1549.495n 3.3v 1549.505n 0.0v 1559.495n 0.0v 1559.505n 3.3v 1569.495n 3.3v 1569.505n 0.0v 1579.495n 0.0v 1579.505n 3.3v 1589.495n 3.3v 1589.505n 3.3v 1599.495n 3.3v 1599.505n 3.3v 1609.495n 3.3v 1609.505n 0.0v 1619.495n 0.0v 1619.505n 3.3v 1629.495n 3.3v 1629.505n 0.0v 1639.495n 0.0v 1639.505n 3.3v 1649.495n 3.3v 1649.505n 3.3v 1659.495n 3.3v 1659.505n 0.0v 1669.495n 0.0v 1669.505n 3.3v 1679.495n 3.3v 1679.505n 0.0v 1689.495n 0.0v 1689.505n 3.3v 1699.495n 3.3v 1699.505n 3.3v 1709.495n 3.3v 1709.505n 3.3v 1719.495n 3.3v 1719.505n 3.3v 1729.495n 3.3v 1729.505n 3.3v 1739.495n 3.3v 1739.505n 3.3v 1749.495n 3.3v 1749.505n 3.3v 1759.495n 3.3v 1759.505n 3.3v 1769.495n 3.3v 1769.505n 0.0v 1779.495n 0.0v 1779.505n 3.3v 1789.495n 3.3v 1789.505n 0.0v 1799.495n 0.0v 1799.505n 3.3v 1809.495n 3.3v 1809.505n 3.3v 1819.495n 3.3v 1819.505n 3.3v 1829.495n 3.3v 1829.505n 3.3v 1839.495n 3.3v 1839.505n 3.3v 1849.495n 3.3v 1849.505n 3.3v 1859.495n 3.3v 1859.505n 3.3v 1869.495n 3.3v 1869.505n 3.3v 1879.495n 3.3v 1879.505n 3.3v 1889.495n 3.3v 1889.505n 3.3v 1899.495n 3.3v 1899.505n 3.3v 1909.495n 3.3v 1909.505n 3.3v 1919.495n 3.3v 1919.505n 3.3v 1929.495n 3.3v 1929.505n 3.3v 1939.495n 3.3v 1939.505n 3.3v 1949.495n 3.3v 1949.505n 0.0v 1959.495n 0.0v 1959.505n 3.3v 1969.495n 3.3v 1969.505n 3.3v 1979.495n 3.3v 1979.505n 0.0v 1989.495n 0.0v 1989.505n 3.3v 1999.495n 3.3v 1999.505n 3.3v 2009.495n 3.3v 2009.505n 3.3v 2019.495n 3.3v 2019.505n 0.0v 2029.495n 0.0v 2029.505n 0.0v 2039.495n 0.0v 2039.505n 3.3v 2049.495n 3.3v 2049.505n 3.3v )
* PULSE: period=10
Vclk0 clk0 0 PULSE (0 3.3 9.995n 0.01n 0.01n 4.99n 10n)
* PULSE: period=10
Vclk1 clk1 0 PULSE (0 3.3 9.995n 0.01n 0.01n 4.99n 10n)

 * Generation of dout measurements
* CHECK dout0_0 vdout0_0ck4 = 3.3 time = 50
* CHECK dout0_1 vdout0_1ck4 = 3.3 time = 50
* CHECK dout0_2 vdout0_2ck4 = 0 time = 50
* CHECK dout0_3 vdout0_3ck4 = 0 time = 50
* CHECK dout0_4 vdout0_4ck4 = 3.3 time = 50
* CHECK dout0_5 vdout0_5ck4 = 3.3 time = 50
* CHECK dout0_6 vdout0_6ck4 = 3.3 time = 50
* CHECK dout0_7 vdout0_7ck4 = 0 time = 50
* CHECK dout0_8 vdout0_8ck4 = 3.3 time = 50
* CHECK dout0_9 vdout0_9ck4 = 3.3 time = 50
* CHECK dout0_10 vdout0_10ck4 = 0 time = 50
* CHECK dout0_11 vdout0_11ck4 = 0 time = 50
* CHECK dout0_12 vdout0_12ck4 = 3.3 time = 50
* CHECK dout0_13 vdout0_13ck4 = 0 time = 50
* CHECK dout0_14 vdout0_14ck4 = 0 time = 50
* CHECK dout0_15 vdout0_15ck4 = 3.3 time = 50
* CHECK dout0_16 vdout0_16ck4 = 3.3 time = 50
* CHECK dout0_17 vdout0_17ck4 = 3.3 time = 50
* CHECK dout0_18 vdout0_18ck4 = 3.3 time = 50
* CHECK dout0_19 vdout0_19ck4 = 0 time = 50
* CHECK dout0_20 vdout0_20ck4 = 0 time = 50
* CHECK dout0_21 vdout0_21ck4 = 0 time = 50
* CHECK dout0_22 vdout0_22ck4 = 0 time = 50
* CHECK dout0_23 vdout0_23ck4 = 3.3 time = 50
* CHECK dout0_24 vdout0_24ck4 = 0 time = 50
* CHECK dout0_25 vdout0_25ck4 = 3.3 time = 50
* CHECK dout0_26 vdout0_26ck4 = 0 time = 50
* CHECK dout0_27 vdout0_27ck4 = 0 time = 50
* CHECK dout0_28 vdout0_28ck4 = 0 time = 50
* CHECK dout0_29 vdout0_29ck4 = 0 time = 50
* CHECK dout0_30 vdout0_30ck4 = 0 time = 50
* CHECK dout0_31 vdout0_31ck4 = 3.3 time = 50
* CHECK dout1_0 vdout1_0ck4 = 3.3 time = 50
* CHECK dout1_1 vdout1_1ck4 = 3.3 time = 50
* CHECK dout1_2 vdout1_2ck4 = 0 time = 50
* CHECK dout1_3 vdout1_3ck4 = 0 time = 50
* CHECK dout1_4 vdout1_4ck4 = 3.3 time = 50
* CHECK dout1_5 vdout1_5ck4 = 3.3 time = 50
* CHECK dout1_6 vdout1_6ck4 = 3.3 time = 50
* CHECK dout1_7 vdout1_7ck4 = 0 time = 50
* CHECK dout1_8 vdout1_8ck4 = 3.3 time = 50
* CHECK dout1_9 vdout1_9ck4 = 3.3 time = 50
* CHECK dout1_10 vdout1_10ck4 = 0 time = 50
* CHECK dout1_11 vdout1_11ck4 = 0 time = 50
* CHECK dout1_12 vdout1_12ck4 = 3.3 time = 50
* CHECK dout1_13 vdout1_13ck4 = 0 time = 50
* CHECK dout1_14 vdout1_14ck4 = 0 time = 50
* CHECK dout1_15 vdout1_15ck4 = 3.3 time = 50
* CHECK dout1_16 vdout1_16ck4 = 3.3 time = 50
* CHECK dout1_17 vdout1_17ck4 = 3.3 time = 50
* CHECK dout1_18 vdout1_18ck4 = 3.3 time = 50
* CHECK dout1_19 vdout1_19ck4 = 0 time = 50
* CHECK dout1_20 vdout1_20ck4 = 0 time = 50
* CHECK dout1_21 vdout1_21ck4 = 0 time = 50
* CHECK dout1_22 vdout1_22ck4 = 0 time = 50
* CHECK dout1_23 vdout1_23ck4 = 3.3 time = 50
* CHECK dout1_24 vdout1_24ck4 = 0 time = 50
* CHECK dout1_25 vdout1_25ck4 = 3.3 time = 50
* CHECK dout1_26 vdout1_26ck4 = 0 time = 50
* CHECK dout1_27 vdout1_27ck4 = 0 time = 50
* CHECK dout1_28 vdout1_28ck4 = 0 time = 50
* CHECK dout1_29 vdout1_29ck4 = 0 time = 50
* CHECK dout1_30 vdout1_30ck4 = 0 time = 50
* CHECK dout1_31 vdout1_31ck4 = 3.3 time = 50
* CHECK dout0_0 vdout0_0ck5 = 3.3 time = 60
* CHECK dout0_1 vdout0_1ck5 = 3.3 time = 60
* CHECK dout0_2 vdout0_2ck5 = 0 time = 60
* CHECK dout0_3 vdout0_3ck5 = 0 time = 60
* CHECK dout0_4 vdout0_4ck5 = 3.3 time = 60
* CHECK dout0_5 vdout0_5ck5 = 3.3 time = 60
* CHECK dout0_6 vdout0_6ck5 = 3.3 time = 60
* CHECK dout0_7 vdout0_7ck5 = 0 time = 60
* CHECK dout0_8 vdout0_8ck5 = 3.3 time = 60
* CHECK dout0_9 vdout0_9ck5 = 3.3 time = 60
* CHECK dout0_10 vdout0_10ck5 = 0 time = 60
* CHECK dout0_11 vdout0_11ck5 = 0 time = 60
* CHECK dout0_12 vdout0_12ck5 = 3.3 time = 60
* CHECK dout0_13 vdout0_13ck5 = 0 time = 60
* CHECK dout0_14 vdout0_14ck5 = 0 time = 60
* CHECK dout0_15 vdout0_15ck5 = 3.3 time = 60
* CHECK dout0_16 vdout0_16ck5 = 3.3 time = 60
* CHECK dout0_17 vdout0_17ck5 = 3.3 time = 60
* CHECK dout0_18 vdout0_18ck5 = 3.3 time = 60
* CHECK dout0_19 vdout0_19ck5 = 0 time = 60
* CHECK dout0_20 vdout0_20ck5 = 0 time = 60
* CHECK dout0_21 vdout0_21ck5 = 0 time = 60
* CHECK dout0_22 vdout0_22ck5 = 0 time = 60
* CHECK dout0_23 vdout0_23ck5 = 3.3 time = 60
* CHECK dout0_24 vdout0_24ck5 = 0 time = 60
* CHECK dout0_25 vdout0_25ck5 = 3.3 time = 60
* CHECK dout0_26 vdout0_26ck5 = 0 time = 60
* CHECK dout0_27 vdout0_27ck5 = 0 time = 60
* CHECK dout0_28 vdout0_28ck5 = 0 time = 60
* CHECK dout0_29 vdout0_29ck5 = 0 time = 60
* CHECK dout0_30 vdout0_30ck5 = 0 time = 60
* CHECK dout0_31 vdout0_31ck5 = 3.3 time = 60
* CHECK dout0_0 vdout0_0ck6 = 3.3 time = 70
* CHECK dout0_1 vdout0_1ck6 = 3.3 time = 70
* CHECK dout0_2 vdout0_2ck6 = 0 time = 70
* CHECK dout0_3 vdout0_3ck6 = 0 time = 70
* CHECK dout0_4 vdout0_4ck6 = 0 time = 70
* CHECK dout0_5 vdout0_5ck6 = 0 time = 70
* CHECK dout0_6 vdout0_6ck6 = 3.3 time = 70
* CHECK dout0_7 vdout0_7ck6 = 0 time = 70
* CHECK dout0_8 vdout0_8ck6 = 0 time = 70
* CHECK dout0_9 vdout0_9ck6 = 0 time = 70
* CHECK dout0_10 vdout0_10ck6 = 0 time = 70
* CHECK dout0_11 vdout0_11ck6 = 0 time = 70
* CHECK dout0_12 vdout0_12ck6 = 3.3 time = 70
* CHECK dout0_13 vdout0_13ck6 = 3.3 time = 70
* CHECK dout0_14 vdout0_14ck6 = 0 time = 70
* CHECK dout0_15 vdout0_15ck6 = 3.3 time = 70
* CHECK dout0_16 vdout0_16ck6 = 0 time = 70
* CHECK dout0_17 vdout0_17ck6 = 3.3 time = 70
* CHECK dout0_18 vdout0_18ck6 = 0 time = 70
* CHECK dout0_19 vdout0_19ck6 = 3.3 time = 70
* CHECK dout0_20 vdout0_20ck6 = 3.3 time = 70
* CHECK dout0_21 vdout0_21ck6 = 3.3 time = 70
* CHECK dout0_22 vdout0_22ck6 = 0 time = 70
* CHECK dout0_23 vdout0_23ck6 = 0 time = 70
* CHECK dout0_24 vdout0_24ck6 = 3.3 time = 70
* CHECK dout0_25 vdout0_25ck6 = 3.3 time = 70
* CHECK dout0_26 vdout0_26ck6 = 0 time = 70
* CHECK dout0_27 vdout0_27ck6 = 3.3 time = 70
* CHECK dout0_28 vdout0_28ck6 = 3.3 time = 70
* CHECK dout0_29 vdout0_29ck6 = 0 time = 70
* CHECK dout0_30 vdout0_30ck6 = 3.3 time = 70
* CHECK dout0_31 vdout0_31ck6 = 3.3 time = 70
* CHECK dout1_0 vdout1_0ck8 = 3.3 time = 90
* CHECK dout1_1 vdout1_1ck8 = 3.3 time = 90
* CHECK dout1_2 vdout1_2ck8 = 0 time = 90
* CHECK dout1_3 vdout1_3ck8 = 0 time = 90
* CHECK dout1_4 vdout1_4ck8 = 3.3 time = 90
* CHECK dout1_5 vdout1_5ck8 = 3.3 time = 90
* CHECK dout1_6 vdout1_6ck8 = 3.3 time = 90
* CHECK dout1_7 vdout1_7ck8 = 0 time = 90
* CHECK dout1_8 vdout1_8ck8 = 3.3 time = 90
* CHECK dout1_9 vdout1_9ck8 = 3.3 time = 90
* CHECK dout1_10 vdout1_10ck8 = 0 time = 90
* CHECK dout1_11 vdout1_11ck8 = 0 time = 90
* CHECK dout1_12 vdout1_12ck8 = 3.3 time = 90
* CHECK dout1_13 vdout1_13ck8 = 0 time = 90
* CHECK dout1_14 vdout1_14ck8 = 0 time = 90
* CHECK dout1_15 vdout1_15ck8 = 3.3 time = 90
* CHECK dout1_16 vdout1_16ck8 = 3.3 time = 90
* CHECK dout1_17 vdout1_17ck8 = 3.3 time = 90
* CHECK dout1_18 vdout1_18ck8 = 3.3 time = 90
* CHECK dout1_19 vdout1_19ck8 = 0 time = 90
* CHECK dout1_20 vdout1_20ck8 = 0 time = 90
* CHECK dout1_21 vdout1_21ck8 = 0 time = 90
* CHECK dout1_22 vdout1_22ck8 = 0 time = 90
* CHECK dout1_23 vdout1_23ck8 = 3.3 time = 90
* CHECK dout1_24 vdout1_24ck8 = 0 time = 90
* CHECK dout1_25 vdout1_25ck8 = 3.3 time = 90
* CHECK dout1_26 vdout1_26ck8 = 0 time = 90
* CHECK dout1_27 vdout1_27ck8 = 0 time = 90
* CHECK dout1_28 vdout1_28ck8 = 0 time = 90
* CHECK dout1_29 vdout1_29ck8 = 0 time = 90
* CHECK dout1_30 vdout1_30ck8 = 0 time = 90
* CHECK dout1_31 vdout1_31ck8 = 3.3 time = 90
* CHECK dout0_0 vdout0_0ck9 = 0 time = 100
* CHECK dout0_1 vdout0_1ck9 = 3.3 time = 100
* CHECK dout0_2 vdout0_2ck9 = 0 time = 100
* CHECK dout0_3 vdout0_3ck9 = 3.3 time = 100
* CHECK dout0_4 vdout0_4ck9 = 3.3 time = 100
* CHECK dout0_5 vdout0_5ck9 = 0 time = 100
* CHECK dout0_6 vdout0_6ck9 = 0 time = 100
* CHECK dout0_7 vdout0_7ck9 = 0 time = 100
* CHECK dout0_8 vdout0_8ck9 = 3.3 time = 100
* CHECK dout0_9 vdout0_9ck9 = 3.3 time = 100
* CHECK dout0_10 vdout0_10ck9 = 0 time = 100
* CHECK dout0_11 vdout0_11ck9 = 3.3 time = 100
* CHECK dout0_12 vdout0_12ck9 = 0 time = 100
* CHECK dout0_13 vdout0_13ck9 = 0 time = 100
* CHECK dout0_14 vdout0_14ck9 = 0 time = 100
* CHECK dout0_15 vdout0_15ck9 = 3.3 time = 100
* CHECK dout0_16 vdout0_16ck9 = 3.3 time = 100
* CHECK dout0_17 vdout0_17ck9 = 0 time = 100
* CHECK dout0_18 vdout0_18ck9 = 0 time = 100
* CHECK dout0_19 vdout0_19ck9 = 0 time = 100
* CHECK dout0_20 vdout0_20ck9 = 3.3 time = 100
* CHECK dout0_21 vdout0_21ck9 = 0 time = 100
* CHECK dout0_22 vdout0_22ck9 = 3.3 time = 100
* CHECK dout0_23 vdout0_23ck9 = 0 time = 100
* CHECK dout0_24 vdout0_24ck9 = 0 time = 100
* CHECK dout0_25 vdout0_25ck9 = 3.3 time = 100
* CHECK dout0_26 vdout0_26ck9 = 0 time = 100
* CHECK dout0_27 vdout0_27ck9 = 3.3 time = 100
* CHECK dout0_28 vdout0_28ck9 = 3.3 time = 100
* CHECK dout0_29 vdout0_29ck9 = 3.3 time = 100
* CHECK dout0_30 vdout0_30ck9 = 3.3 time = 100
* CHECK dout0_31 vdout0_31ck9 = 0 time = 100
* CHECK dout0_0 vdout0_0ck10 = 3.3 time = 110
* CHECK dout0_1 vdout0_1ck10 = 3.3 time = 110
* CHECK dout0_2 vdout0_2ck10 = 0 time = 110
* CHECK dout0_3 vdout0_3ck10 = 0 time = 110
* CHECK dout0_4 vdout0_4ck10 = 3.3 time = 110
* CHECK dout0_5 vdout0_5ck10 = 3.3 time = 110
* CHECK dout0_6 vdout0_6ck10 = 3.3 time = 110
* CHECK dout0_7 vdout0_7ck10 = 0 time = 110
* CHECK dout0_8 vdout0_8ck10 = 3.3 time = 110
* CHECK dout0_9 vdout0_9ck10 = 3.3 time = 110
* CHECK dout0_10 vdout0_10ck10 = 0 time = 110
* CHECK dout0_11 vdout0_11ck10 = 0 time = 110
* CHECK dout0_12 vdout0_12ck10 = 3.3 time = 110
* CHECK dout0_13 vdout0_13ck10 = 0 time = 110
* CHECK dout0_14 vdout0_14ck10 = 0 time = 110
* CHECK dout0_15 vdout0_15ck10 = 3.3 time = 110
* CHECK dout0_16 vdout0_16ck10 = 3.3 time = 110
* CHECK dout0_17 vdout0_17ck10 = 3.3 time = 110
* CHECK dout0_18 vdout0_18ck10 = 3.3 time = 110
* CHECK dout0_19 vdout0_19ck10 = 0 time = 110
* CHECK dout0_20 vdout0_20ck10 = 0 time = 110
* CHECK dout0_21 vdout0_21ck10 = 0 time = 110
* CHECK dout0_22 vdout0_22ck10 = 0 time = 110
* CHECK dout0_23 vdout0_23ck10 = 3.3 time = 110
* CHECK dout0_24 vdout0_24ck10 = 0 time = 110
* CHECK dout0_25 vdout0_25ck10 = 3.3 time = 110
* CHECK dout0_26 vdout0_26ck10 = 0 time = 110
* CHECK dout0_27 vdout0_27ck10 = 0 time = 110
* CHECK dout0_28 vdout0_28ck10 = 0 time = 110
* CHECK dout0_29 vdout0_29ck10 = 0 time = 110
* CHECK dout0_30 vdout0_30ck10 = 0 time = 110
* CHECK dout0_31 vdout0_31ck10 = 3.3 time = 110
* CHECK dout0_0 vdout0_0ck11 = 0 time = 120
* CHECK dout0_1 vdout0_1ck11 = 3.3 time = 120
* CHECK dout0_2 vdout0_2ck11 = 0 time = 120
* CHECK dout0_3 vdout0_3ck11 = 3.3 time = 120
* CHECK dout0_4 vdout0_4ck11 = 3.3 time = 120
* CHECK dout0_5 vdout0_5ck11 = 0 time = 120
* CHECK dout0_6 vdout0_6ck11 = 0 time = 120
* CHECK dout0_7 vdout0_7ck11 = 0 time = 120
* CHECK dout0_8 vdout0_8ck11 = 3.3 time = 120
* CHECK dout0_9 vdout0_9ck11 = 3.3 time = 120
* CHECK dout0_10 vdout0_10ck11 = 0 time = 120
* CHECK dout0_11 vdout0_11ck11 = 3.3 time = 120
* CHECK dout0_12 vdout0_12ck11 = 0 time = 120
* CHECK dout0_13 vdout0_13ck11 = 0 time = 120
* CHECK dout0_14 vdout0_14ck11 = 0 time = 120
* CHECK dout0_15 vdout0_15ck11 = 3.3 time = 120
* CHECK dout0_16 vdout0_16ck11 = 3.3 time = 120
* CHECK dout0_17 vdout0_17ck11 = 0 time = 120
* CHECK dout0_18 vdout0_18ck11 = 0 time = 120
* CHECK dout0_19 vdout0_19ck11 = 0 time = 120
* CHECK dout0_20 vdout0_20ck11 = 3.3 time = 120
* CHECK dout0_21 vdout0_21ck11 = 0 time = 120
* CHECK dout0_22 vdout0_22ck11 = 3.3 time = 120
* CHECK dout0_23 vdout0_23ck11 = 0 time = 120
* CHECK dout0_24 vdout0_24ck11 = 0 time = 120
* CHECK dout0_25 vdout0_25ck11 = 3.3 time = 120
* CHECK dout0_26 vdout0_26ck11 = 0 time = 120
* CHECK dout0_27 vdout0_27ck11 = 3.3 time = 120
* CHECK dout0_28 vdout0_28ck11 = 3.3 time = 120
* CHECK dout0_29 vdout0_29ck11 = 3.3 time = 120
* CHECK dout0_30 vdout0_30ck11 = 3.3 time = 120
* CHECK dout0_31 vdout0_31ck11 = 0 time = 120
* CHECK dout1_0 vdout1_0ck12 = 0 time = 130
* CHECK dout1_1 vdout1_1ck12 = 3.3 time = 130
* CHECK dout1_2 vdout1_2ck12 = 0 time = 130
* CHECK dout1_3 vdout1_3ck12 = 3.3 time = 130
* CHECK dout1_4 vdout1_4ck12 = 3.3 time = 130
* CHECK dout1_5 vdout1_5ck12 = 0 time = 130
* CHECK dout1_6 vdout1_6ck12 = 0 time = 130
* CHECK dout1_7 vdout1_7ck12 = 0 time = 130
* CHECK dout1_8 vdout1_8ck12 = 3.3 time = 130
* CHECK dout1_9 vdout1_9ck12 = 3.3 time = 130
* CHECK dout1_10 vdout1_10ck12 = 0 time = 130
* CHECK dout1_11 vdout1_11ck12 = 3.3 time = 130
* CHECK dout1_12 vdout1_12ck12 = 0 time = 130
* CHECK dout1_13 vdout1_13ck12 = 0 time = 130
* CHECK dout1_14 vdout1_14ck12 = 0 time = 130
* CHECK dout1_15 vdout1_15ck12 = 3.3 time = 130
* CHECK dout1_16 vdout1_16ck12 = 3.3 time = 130
* CHECK dout1_17 vdout1_17ck12 = 0 time = 130
* CHECK dout1_18 vdout1_18ck12 = 0 time = 130
* CHECK dout1_19 vdout1_19ck12 = 0 time = 130
* CHECK dout1_20 vdout1_20ck12 = 3.3 time = 130
* CHECK dout1_21 vdout1_21ck12 = 0 time = 130
* CHECK dout1_22 vdout1_22ck12 = 3.3 time = 130
* CHECK dout1_23 vdout1_23ck12 = 0 time = 130
* CHECK dout1_24 vdout1_24ck12 = 0 time = 130
* CHECK dout1_25 vdout1_25ck12 = 3.3 time = 130
* CHECK dout1_26 vdout1_26ck12 = 0 time = 130
* CHECK dout1_27 vdout1_27ck12 = 3.3 time = 130
* CHECK dout1_28 vdout1_28ck12 = 3.3 time = 130
* CHECK dout1_29 vdout1_29ck12 = 3.3 time = 130
* CHECK dout1_30 vdout1_30ck12 = 3.3 time = 130
* CHECK dout1_31 vdout1_31ck12 = 0 time = 130
* CHECK dout0_0 vdout0_0ck13 = 0 time = 140
* CHECK dout0_1 vdout0_1ck13 = 3.3 time = 140
* CHECK dout0_2 vdout0_2ck13 = 0 time = 140
* CHECK dout0_3 vdout0_3ck13 = 3.3 time = 140
* CHECK dout0_4 vdout0_4ck13 = 3.3 time = 140
* CHECK dout0_5 vdout0_5ck13 = 0 time = 140
* CHECK dout0_6 vdout0_6ck13 = 0 time = 140
* CHECK dout0_7 vdout0_7ck13 = 0 time = 140
* CHECK dout0_8 vdout0_8ck13 = 3.3 time = 140
* CHECK dout0_9 vdout0_9ck13 = 3.3 time = 140
* CHECK dout0_10 vdout0_10ck13 = 0 time = 140
* CHECK dout0_11 vdout0_11ck13 = 3.3 time = 140
* CHECK dout0_12 vdout0_12ck13 = 0 time = 140
* CHECK dout0_13 vdout0_13ck13 = 0 time = 140
* CHECK dout0_14 vdout0_14ck13 = 0 time = 140
* CHECK dout0_15 vdout0_15ck13 = 3.3 time = 140
* CHECK dout0_16 vdout0_16ck13 = 3.3 time = 140
* CHECK dout0_17 vdout0_17ck13 = 0 time = 140
* CHECK dout0_18 vdout0_18ck13 = 0 time = 140
* CHECK dout0_19 vdout0_19ck13 = 0 time = 140
* CHECK dout0_20 vdout0_20ck13 = 3.3 time = 140
* CHECK dout0_21 vdout0_21ck13 = 0 time = 140
* CHECK dout0_22 vdout0_22ck13 = 3.3 time = 140
* CHECK dout0_23 vdout0_23ck13 = 0 time = 140
* CHECK dout0_24 vdout0_24ck13 = 0 time = 140
* CHECK dout0_25 vdout0_25ck13 = 3.3 time = 140
* CHECK dout0_26 vdout0_26ck13 = 0 time = 140
* CHECK dout0_27 vdout0_27ck13 = 3.3 time = 140
* CHECK dout0_28 vdout0_28ck13 = 3.3 time = 140
* CHECK dout0_29 vdout0_29ck13 = 3.3 time = 140
* CHECK dout0_30 vdout0_30ck13 = 3.3 time = 140
* CHECK dout0_31 vdout0_31ck13 = 0 time = 140
* CHECK dout1_0 vdout1_0ck13 = 0 time = 140
* CHECK dout1_1 vdout1_1ck13 = 3.3 time = 140
* CHECK dout1_2 vdout1_2ck13 = 0 time = 140
* CHECK dout1_3 vdout1_3ck13 = 3.3 time = 140
* CHECK dout1_4 vdout1_4ck13 = 3.3 time = 140
* CHECK dout1_5 vdout1_5ck13 = 0 time = 140
* CHECK dout1_6 vdout1_6ck13 = 0 time = 140
* CHECK dout1_7 vdout1_7ck13 = 0 time = 140
* CHECK dout1_8 vdout1_8ck13 = 3.3 time = 140
* CHECK dout1_9 vdout1_9ck13 = 3.3 time = 140
* CHECK dout1_10 vdout1_10ck13 = 0 time = 140
* CHECK dout1_11 vdout1_11ck13 = 3.3 time = 140
* CHECK dout1_12 vdout1_12ck13 = 0 time = 140
* CHECK dout1_13 vdout1_13ck13 = 0 time = 140
* CHECK dout1_14 vdout1_14ck13 = 0 time = 140
* CHECK dout1_15 vdout1_15ck13 = 3.3 time = 140
* CHECK dout1_16 vdout1_16ck13 = 3.3 time = 140
* CHECK dout1_17 vdout1_17ck13 = 0 time = 140
* CHECK dout1_18 vdout1_18ck13 = 0 time = 140
* CHECK dout1_19 vdout1_19ck13 = 0 time = 140
* CHECK dout1_20 vdout1_20ck13 = 3.3 time = 140
* CHECK dout1_21 vdout1_21ck13 = 0 time = 140
* CHECK dout1_22 vdout1_22ck13 = 3.3 time = 140
* CHECK dout1_23 vdout1_23ck13 = 0 time = 140
* CHECK dout1_24 vdout1_24ck13 = 0 time = 140
* CHECK dout1_25 vdout1_25ck13 = 3.3 time = 140
* CHECK dout1_26 vdout1_26ck13 = 0 time = 140
* CHECK dout1_27 vdout1_27ck13 = 3.3 time = 140
* CHECK dout1_28 vdout1_28ck13 = 3.3 time = 140
* CHECK dout1_29 vdout1_29ck13 = 3.3 time = 140
* CHECK dout1_30 vdout1_30ck13 = 3.3 time = 140
* CHECK dout1_31 vdout1_31ck13 = 0 time = 140
* CHECK dout0_0 vdout0_0ck16 = 3.3 time = 170
* CHECK dout0_1 vdout0_1ck16 = 0 time = 170
* CHECK dout0_2 vdout0_2ck16 = 3.3 time = 170
* CHECK dout0_3 vdout0_3ck16 = 3.3 time = 170
* CHECK dout0_4 vdout0_4ck16 = 0 time = 170
* CHECK dout0_5 vdout0_5ck16 = 3.3 time = 170
* CHECK dout0_6 vdout0_6ck16 = 0 time = 170
* CHECK dout0_7 vdout0_7ck16 = 3.3 time = 170
* CHECK dout0_8 vdout0_8ck16 = 0 time = 170
* CHECK dout0_9 vdout0_9ck16 = 0 time = 170
* CHECK dout0_10 vdout0_10ck16 = 0 time = 170
* CHECK dout0_11 vdout0_11ck16 = 0 time = 170
* CHECK dout0_12 vdout0_12ck16 = 3.3 time = 170
* CHECK dout0_13 vdout0_13ck16 = 0 time = 170
* CHECK dout0_14 vdout0_14ck16 = 0 time = 170
* CHECK dout0_15 vdout0_15ck16 = 3.3 time = 170
* CHECK dout0_16 vdout0_16ck16 = 0 time = 170
* CHECK dout0_17 vdout0_17ck16 = 0 time = 170
* CHECK dout0_18 vdout0_18ck16 = 3.3 time = 170
* CHECK dout0_19 vdout0_19ck16 = 3.3 time = 170
* CHECK dout0_20 vdout0_20ck16 = 0 time = 170
* CHECK dout0_21 vdout0_21ck16 = 3.3 time = 170
* CHECK dout0_22 vdout0_22ck16 = 0 time = 170
* CHECK dout0_23 vdout0_23ck16 = 0 time = 170
* CHECK dout0_24 vdout0_24ck16 = 3.3 time = 170
* CHECK dout0_25 vdout0_25ck16 = 3.3 time = 170
* CHECK dout0_26 vdout0_26ck16 = 3.3 time = 170
* CHECK dout0_27 vdout0_27ck16 = 3.3 time = 170
* CHECK dout0_28 vdout0_28ck16 = 0 time = 170
* CHECK dout0_29 vdout0_29ck16 = 3.3 time = 170
* CHECK dout0_30 vdout0_30ck16 = 0 time = 170
* CHECK dout0_31 vdout0_31ck16 = 0 time = 170
* CHECK dout1_0 vdout1_0ck22 = 3.3 time = 230
* CHECK dout1_1 vdout1_1ck22 = 3.3 time = 230
* CHECK dout1_2 vdout1_2ck22 = 3.3 time = 230
* CHECK dout1_3 vdout1_3ck22 = 3.3 time = 230
* CHECK dout1_4 vdout1_4ck22 = 0 time = 230
* CHECK dout1_5 vdout1_5ck22 = 0 time = 230
* CHECK dout1_6 vdout1_6ck22 = 0 time = 230
* CHECK dout1_7 vdout1_7ck22 = 3.3 time = 230
* CHECK dout1_8 vdout1_8ck22 = 3.3 time = 230
* CHECK dout1_9 vdout1_9ck22 = 3.3 time = 230
* CHECK dout1_10 vdout1_10ck22 = 0 time = 230
* CHECK dout1_11 vdout1_11ck22 = 3.3 time = 230
* CHECK dout1_12 vdout1_12ck22 = 3.3 time = 230
* CHECK dout1_13 vdout1_13ck22 = 0 time = 230
* CHECK dout1_14 vdout1_14ck22 = 3.3 time = 230
* CHECK dout1_15 vdout1_15ck22 = 0 time = 230
* CHECK dout1_16 vdout1_16ck22 = 3.3 time = 230
* CHECK dout1_17 vdout1_17ck22 = 3.3 time = 230
* CHECK dout1_18 vdout1_18ck22 = 3.3 time = 230
* CHECK dout1_19 vdout1_19ck22 = 3.3 time = 230
* CHECK dout1_20 vdout1_20ck22 = 3.3 time = 230
* CHECK dout1_21 vdout1_21ck22 = 3.3 time = 230
* CHECK dout1_22 vdout1_22ck22 = 3.3 time = 230
* CHECK dout1_23 vdout1_23ck22 = 3.3 time = 230
* CHECK dout1_24 vdout1_24ck22 = 0 time = 230
* CHECK dout1_25 vdout1_25ck22 = 0 time = 230
* CHECK dout1_26 vdout1_26ck22 = 3.3 time = 230
* CHECK dout1_27 vdout1_27ck22 = 3.3 time = 230
* CHECK dout1_28 vdout1_28ck22 = 0 time = 230
* CHECK dout1_29 vdout1_29ck22 = 3.3 time = 230
* CHECK dout1_30 vdout1_30ck22 = 0 time = 230
* CHECK dout1_31 vdout1_31ck22 = 0 time = 230
* CHECK dout0_0 vdout0_0ck26 = 3.3 time = 270
* CHECK dout0_1 vdout0_1ck26 = 0 time = 270
* CHECK dout0_2 vdout0_2ck26 = 3.3 time = 270
* CHECK dout0_3 vdout0_3ck26 = 3.3 time = 270
* CHECK dout0_4 vdout0_4ck26 = 3.3 time = 270
* CHECK dout0_5 vdout0_5ck26 = 0 time = 270
* CHECK dout0_6 vdout0_6ck26 = 3.3 time = 270
* CHECK dout0_7 vdout0_7ck26 = 3.3 time = 270
* CHECK dout0_8 vdout0_8ck26 = 3.3 time = 270
* CHECK dout0_9 vdout0_9ck26 = 0 time = 270
* CHECK dout0_10 vdout0_10ck26 = 0 time = 270
* CHECK dout0_11 vdout0_11ck26 = 0 time = 270
* CHECK dout0_12 vdout0_12ck26 = 0 time = 270
* CHECK dout0_13 vdout0_13ck26 = 3.3 time = 270
* CHECK dout0_14 vdout0_14ck26 = 3.3 time = 270
* CHECK dout0_15 vdout0_15ck26 = 0 time = 270
* CHECK dout0_16 vdout0_16ck26 = 3.3 time = 270
* CHECK dout0_17 vdout0_17ck26 = 0 time = 270
* CHECK dout0_18 vdout0_18ck26 = 0 time = 270
* CHECK dout0_19 vdout0_19ck26 = 0 time = 270
* CHECK dout0_20 vdout0_20ck26 = 3.3 time = 270
* CHECK dout0_21 vdout0_21ck26 = 3.3 time = 270
* CHECK dout0_22 vdout0_22ck26 = 3.3 time = 270
* CHECK dout0_23 vdout0_23ck26 = 0 time = 270
* CHECK dout0_24 vdout0_24ck26 = 3.3 time = 270
* CHECK dout0_25 vdout0_25ck26 = 3.3 time = 270
* CHECK dout0_26 vdout0_26ck26 = 3.3 time = 270
* CHECK dout0_27 vdout0_27ck26 = 3.3 time = 270
* CHECK dout0_28 vdout0_28ck26 = 3.3 time = 270
* CHECK dout0_29 vdout0_29ck26 = 3.3 time = 270
* CHECK dout0_30 vdout0_30ck26 = 0 time = 270
* CHECK dout0_31 vdout0_31ck26 = 0 time = 270
* CHECK dout1_0 vdout1_0ck27 = 0 time = 280
* CHECK dout1_1 vdout1_1ck27 = 3.3 time = 280
* CHECK dout1_2 vdout1_2ck27 = 0 time = 280
* CHECK dout1_3 vdout1_3ck27 = 0 time = 280
* CHECK dout1_4 vdout1_4ck27 = 0 time = 280
* CHECK dout1_5 vdout1_5ck27 = 3.3 time = 280
* CHECK dout1_6 vdout1_6ck27 = 0 time = 280
* CHECK dout1_7 vdout1_7ck27 = 3.3 time = 280
* CHECK dout1_8 vdout1_8ck27 = 3.3 time = 280
* CHECK dout1_9 vdout1_9ck27 = 3.3 time = 280
* CHECK dout1_10 vdout1_10ck27 = 3.3 time = 280
* CHECK dout1_11 vdout1_11ck27 = 0 time = 280
* CHECK dout1_12 vdout1_12ck27 = 0 time = 280
* CHECK dout1_13 vdout1_13ck27 = 3.3 time = 280
* CHECK dout1_14 vdout1_14ck27 = 0 time = 280
* CHECK dout1_15 vdout1_15ck27 = 0 time = 280
* CHECK dout1_16 vdout1_16ck27 = 3.3 time = 280
* CHECK dout1_17 vdout1_17ck27 = 0 time = 280
* CHECK dout1_18 vdout1_18ck27 = 3.3 time = 280
* CHECK dout1_19 vdout1_19ck27 = 0 time = 280
* CHECK dout1_20 vdout1_20ck27 = 0 time = 280
* CHECK dout1_21 vdout1_21ck27 = 0 time = 280
* CHECK dout1_22 vdout1_22ck27 = 3.3 time = 280
* CHECK dout1_23 vdout1_23ck27 = 0 time = 280
* CHECK dout1_24 vdout1_24ck27 = 0 time = 280
* CHECK dout1_25 vdout1_25ck27 = 3.3 time = 280
* CHECK dout1_26 vdout1_26ck27 = 3.3 time = 280
* CHECK dout1_27 vdout1_27ck27 = 3.3 time = 280
* CHECK dout1_28 vdout1_28ck27 = 0 time = 280
* CHECK dout1_29 vdout1_29ck27 = 0 time = 280
* CHECK dout1_30 vdout1_30ck27 = 3.3 time = 280
* CHECK dout1_31 vdout1_31ck27 = 0 time = 280
* CHECK dout0_0 vdout0_0ck28 = 0 time = 290
* CHECK dout0_1 vdout0_1ck28 = 3.3 time = 290
* CHECK dout0_2 vdout0_2ck28 = 0 time = 290
* CHECK dout0_3 vdout0_3ck28 = 0 time = 290
* CHECK dout0_4 vdout0_4ck28 = 0 time = 290
* CHECK dout0_5 vdout0_5ck28 = 3.3 time = 290
* CHECK dout0_6 vdout0_6ck28 = 0 time = 290
* CHECK dout0_7 vdout0_7ck28 = 3.3 time = 290
* CHECK dout0_8 vdout0_8ck28 = 3.3 time = 290
* CHECK dout0_9 vdout0_9ck28 = 3.3 time = 290
* CHECK dout0_10 vdout0_10ck28 = 3.3 time = 290
* CHECK dout0_11 vdout0_11ck28 = 0 time = 290
* CHECK dout0_12 vdout0_12ck28 = 0 time = 290
* CHECK dout0_13 vdout0_13ck28 = 3.3 time = 290
* CHECK dout0_14 vdout0_14ck28 = 0 time = 290
* CHECK dout0_15 vdout0_15ck28 = 0 time = 290
* CHECK dout0_16 vdout0_16ck28 = 3.3 time = 290
* CHECK dout0_17 vdout0_17ck28 = 0 time = 290
* CHECK dout0_18 vdout0_18ck28 = 3.3 time = 290
* CHECK dout0_19 vdout0_19ck28 = 0 time = 290
* CHECK dout0_20 vdout0_20ck28 = 0 time = 290
* CHECK dout0_21 vdout0_21ck28 = 0 time = 290
* CHECK dout0_22 vdout0_22ck28 = 3.3 time = 290
* CHECK dout0_23 vdout0_23ck28 = 0 time = 290
* CHECK dout0_24 vdout0_24ck28 = 0 time = 290
* CHECK dout0_25 vdout0_25ck28 = 3.3 time = 290
* CHECK dout0_26 vdout0_26ck28 = 3.3 time = 290
* CHECK dout0_27 vdout0_27ck28 = 3.3 time = 290
* CHECK dout0_28 vdout0_28ck28 = 0 time = 290
* CHECK dout0_29 vdout0_29ck28 = 0 time = 290
* CHECK dout0_30 vdout0_30ck28 = 3.3 time = 290
* CHECK dout0_31 vdout0_31ck28 = 0 time = 290
* CHECK dout0_0 vdout0_0ck29 = 0 time = 300
* CHECK dout0_1 vdout0_1ck29 = 3.3 time = 300
* CHECK dout0_2 vdout0_2ck29 = 0 time = 300
* CHECK dout0_3 vdout0_3ck29 = 0 time = 300
* CHECK dout0_4 vdout0_4ck29 = 3.3 time = 300
* CHECK dout0_5 vdout0_5ck29 = 0 time = 300
* CHECK dout0_6 vdout0_6ck29 = 3.3 time = 300
* CHECK dout0_7 vdout0_7ck29 = 0 time = 300
* CHECK dout0_8 vdout0_8ck29 = 0 time = 300
* CHECK dout0_9 vdout0_9ck29 = 0 time = 300
* CHECK dout0_10 vdout0_10ck29 = 0 time = 300
* CHECK dout0_11 vdout0_11ck29 = 0 time = 300
* CHECK dout0_12 vdout0_12ck29 = 0 time = 300
* CHECK dout0_13 vdout0_13ck29 = 0 time = 300
* CHECK dout0_14 vdout0_14ck29 = 3.3 time = 300
* CHECK dout0_15 vdout0_15ck29 = 3.3 time = 300
* CHECK dout0_16 vdout0_16ck29 = 3.3 time = 300
* CHECK dout0_17 vdout0_17ck29 = 3.3 time = 300
* CHECK dout0_18 vdout0_18ck29 = 3.3 time = 300
* CHECK dout0_19 vdout0_19ck29 = 3.3 time = 300
* CHECK dout0_20 vdout0_20ck29 = 3.3 time = 300
* CHECK dout0_21 vdout0_21ck29 = 3.3 time = 300
* CHECK dout0_22 vdout0_22ck29 = 0 time = 300
* CHECK dout0_23 vdout0_23ck29 = 0 time = 300
* CHECK dout0_24 vdout0_24ck29 = 0 time = 300
* CHECK dout0_25 vdout0_25ck29 = 0 time = 300
* CHECK dout0_26 vdout0_26ck29 = 3.3 time = 300
* CHECK dout0_27 vdout0_27ck29 = 3.3 time = 300
* CHECK dout0_28 vdout0_28ck29 = 0 time = 300
* CHECK dout0_29 vdout0_29ck29 = 0 time = 300
* CHECK dout0_30 vdout0_30ck29 = 3.3 time = 300
* CHECK dout0_31 vdout0_31ck29 = 3.3 time = 300
* CHECK dout1_0 vdout1_0ck29 = 0 time = 300
* CHECK dout1_1 vdout1_1ck29 = 3.3 time = 300
* CHECK dout1_2 vdout1_2ck29 = 0 time = 300
* CHECK dout1_3 vdout1_3ck29 = 0 time = 300
* CHECK dout1_4 vdout1_4ck29 = 3.3 time = 300
* CHECK dout1_5 vdout1_5ck29 = 0 time = 300
* CHECK dout1_6 vdout1_6ck29 = 3.3 time = 300
* CHECK dout1_7 vdout1_7ck29 = 0 time = 300
* CHECK dout1_8 vdout1_8ck29 = 0 time = 300
* CHECK dout1_9 vdout1_9ck29 = 0 time = 300
* CHECK dout1_10 vdout1_10ck29 = 0 time = 300
* CHECK dout1_11 vdout1_11ck29 = 0 time = 300
* CHECK dout1_12 vdout1_12ck29 = 0 time = 300
* CHECK dout1_13 vdout1_13ck29 = 0 time = 300
* CHECK dout1_14 vdout1_14ck29 = 3.3 time = 300
* CHECK dout1_15 vdout1_15ck29 = 3.3 time = 300
* CHECK dout1_16 vdout1_16ck29 = 3.3 time = 300
* CHECK dout1_17 vdout1_17ck29 = 3.3 time = 300
* CHECK dout1_18 vdout1_18ck29 = 3.3 time = 300
* CHECK dout1_19 vdout1_19ck29 = 3.3 time = 300
* CHECK dout1_20 vdout1_20ck29 = 3.3 time = 300
* CHECK dout1_21 vdout1_21ck29 = 3.3 time = 300
* CHECK dout1_22 vdout1_22ck29 = 0 time = 300
* CHECK dout1_23 vdout1_23ck29 = 0 time = 300
* CHECK dout1_24 vdout1_24ck29 = 0 time = 300
* CHECK dout1_25 vdout1_25ck29 = 0 time = 300
* CHECK dout1_26 vdout1_26ck29 = 3.3 time = 300
* CHECK dout1_27 vdout1_27ck29 = 3.3 time = 300
* CHECK dout1_28 vdout1_28ck29 = 0 time = 300
* CHECK dout1_29 vdout1_29ck29 = 0 time = 300
* CHECK dout1_30 vdout1_30ck29 = 3.3 time = 300
* CHECK dout1_31 vdout1_31ck29 = 3.3 time = 300
* CHECK dout0_0 vdout0_0ck30 = 0 time = 310
* CHECK dout0_1 vdout0_1ck30 = 3.3 time = 310
* CHECK dout0_2 vdout0_2ck30 = 0 time = 310
* CHECK dout0_3 vdout0_3ck30 = 0 time = 310
* CHECK dout0_4 vdout0_4ck30 = 3.3 time = 310
* CHECK dout0_5 vdout0_5ck30 = 0 time = 310
* CHECK dout0_6 vdout0_6ck30 = 3.3 time = 310
* CHECK dout0_7 vdout0_7ck30 = 0 time = 310
* CHECK dout0_8 vdout0_8ck30 = 0 time = 310
* CHECK dout0_9 vdout0_9ck30 = 0 time = 310
* CHECK dout0_10 vdout0_10ck30 = 0 time = 310
* CHECK dout0_11 vdout0_11ck30 = 0 time = 310
* CHECK dout0_12 vdout0_12ck30 = 0 time = 310
* CHECK dout0_13 vdout0_13ck30 = 0 time = 310
* CHECK dout0_14 vdout0_14ck30 = 3.3 time = 310
* CHECK dout0_15 vdout0_15ck30 = 3.3 time = 310
* CHECK dout0_16 vdout0_16ck30 = 3.3 time = 310
* CHECK dout0_17 vdout0_17ck30 = 3.3 time = 310
* CHECK dout0_18 vdout0_18ck30 = 3.3 time = 310
* CHECK dout0_19 vdout0_19ck30 = 3.3 time = 310
* CHECK dout0_20 vdout0_20ck30 = 3.3 time = 310
* CHECK dout0_21 vdout0_21ck30 = 3.3 time = 310
* CHECK dout0_22 vdout0_22ck30 = 0 time = 310
* CHECK dout0_23 vdout0_23ck30 = 0 time = 310
* CHECK dout0_24 vdout0_24ck30 = 0 time = 310
* CHECK dout0_25 vdout0_25ck30 = 0 time = 310
* CHECK dout0_26 vdout0_26ck30 = 3.3 time = 310
* CHECK dout0_27 vdout0_27ck30 = 3.3 time = 310
* CHECK dout0_28 vdout0_28ck30 = 0 time = 310
* CHECK dout0_29 vdout0_29ck30 = 0 time = 310
* CHECK dout0_30 vdout0_30ck30 = 3.3 time = 310
* CHECK dout0_31 vdout0_31ck30 = 3.3 time = 310
* CHECK dout1_0 vdout1_0ck30 = 0 time = 310
* CHECK dout1_1 vdout1_1ck30 = 3.3 time = 310
* CHECK dout1_2 vdout1_2ck30 = 0 time = 310
* CHECK dout1_3 vdout1_3ck30 = 0 time = 310
* CHECK dout1_4 vdout1_4ck30 = 3.3 time = 310
* CHECK dout1_5 vdout1_5ck30 = 0 time = 310
* CHECK dout1_6 vdout1_6ck30 = 3.3 time = 310
* CHECK dout1_7 vdout1_7ck30 = 0 time = 310
* CHECK dout1_8 vdout1_8ck30 = 0 time = 310
* CHECK dout1_9 vdout1_9ck30 = 0 time = 310
* CHECK dout1_10 vdout1_10ck30 = 0 time = 310
* CHECK dout1_11 vdout1_11ck30 = 0 time = 310
* CHECK dout1_12 vdout1_12ck30 = 0 time = 310
* CHECK dout1_13 vdout1_13ck30 = 0 time = 310
* CHECK dout1_14 vdout1_14ck30 = 3.3 time = 310
* CHECK dout1_15 vdout1_15ck30 = 3.3 time = 310
* CHECK dout1_16 vdout1_16ck30 = 3.3 time = 310
* CHECK dout1_17 vdout1_17ck30 = 3.3 time = 310
* CHECK dout1_18 vdout1_18ck30 = 3.3 time = 310
* CHECK dout1_19 vdout1_19ck30 = 3.3 time = 310
* CHECK dout1_20 vdout1_20ck30 = 3.3 time = 310
* CHECK dout1_21 vdout1_21ck30 = 3.3 time = 310
* CHECK dout1_22 vdout1_22ck30 = 0 time = 310
* CHECK dout1_23 vdout1_23ck30 = 0 time = 310
* CHECK dout1_24 vdout1_24ck30 = 0 time = 310
* CHECK dout1_25 vdout1_25ck30 = 0 time = 310
* CHECK dout1_26 vdout1_26ck30 = 3.3 time = 310
* CHECK dout1_27 vdout1_27ck30 = 3.3 time = 310
* CHECK dout1_28 vdout1_28ck30 = 0 time = 310
* CHECK dout1_29 vdout1_29ck30 = 0 time = 310
* CHECK dout1_30 vdout1_30ck30 = 3.3 time = 310
* CHECK dout1_31 vdout1_31ck30 = 3.3 time = 310
* CHECK dout1_0 vdout1_0ck31 = 0 time = 320
* CHECK dout1_1 vdout1_1ck31 = 3.3 time = 320
* CHECK dout1_2 vdout1_2ck31 = 0 time = 320
* CHECK dout1_3 vdout1_3ck31 = 0 time = 320
* CHECK dout1_4 vdout1_4ck31 = 3.3 time = 320
* CHECK dout1_5 vdout1_5ck31 = 0 time = 320
* CHECK dout1_6 vdout1_6ck31 = 3.3 time = 320
* CHECK dout1_7 vdout1_7ck31 = 0 time = 320
* CHECK dout1_8 vdout1_8ck31 = 0 time = 320
* CHECK dout1_9 vdout1_9ck31 = 0 time = 320
* CHECK dout1_10 vdout1_10ck31 = 0 time = 320
* CHECK dout1_11 vdout1_11ck31 = 0 time = 320
* CHECK dout1_12 vdout1_12ck31 = 0 time = 320
* CHECK dout1_13 vdout1_13ck31 = 0 time = 320
* CHECK dout1_14 vdout1_14ck31 = 3.3 time = 320
* CHECK dout1_15 vdout1_15ck31 = 3.3 time = 320
* CHECK dout1_16 vdout1_16ck31 = 3.3 time = 320
* CHECK dout1_17 vdout1_17ck31 = 3.3 time = 320
* CHECK dout1_18 vdout1_18ck31 = 3.3 time = 320
* CHECK dout1_19 vdout1_19ck31 = 3.3 time = 320
* CHECK dout1_20 vdout1_20ck31 = 3.3 time = 320
* CHECK dout1_21 vdout1_21ck31 = 3.3 time = 320
* CHECK dout1_22 vdout1_22ck31 = 0 time = 320
* CHECK dout1_23 vdout1_23ck31 = 0 time = 320
* CHECK dout1_24 vdout1_24ck31 = 0 time = 320
* CHECK dout1_25 vdout1_25ck31 = 0 time = 320
* CHECK dout1_26 vdout1_26ck31 = 3.3 time = 320
* CHECK dout1_27 vdout1_27ck31 = 3.3 time = 320
* CHECK dout1_28 vdout1_28ck31 = 0 time = 320
* CHECK dout1_29 vdout1_29ck31 = 0 time = 320
* CHECK dout1_30 vdout1_30ck31 = 3.3 time = 320
* CHECK dout1_31 vdout1_31ck31 = 3.3 time = 320
* CHECK dout0_0 vdout0_0ck34 = 0 time = 350
* CHECK dout0_1 vdout0_1ck34 = 3.3 time = 350
* CHECK dout0_2 vdout0_2ck34 = 0 time = 350
* CHECK dout0_3 vdout0_3ck34 = 0 time = 350
* CHECK dout0_4 vdout0_4ck34 = 3.3 time = 350
* CHECK dout0_5 vdout0_5ck34 = 0 time = 350
* CHECK dout0_6 vdout0_6ck34 = 3.3 time = 350
* CHECK dout0_7 vdout0_7ck34 = 0 time = 350
* CHECK dout0_8 vdout0_8ck34 = 0 time = 350
* CHECK dout0_9 vdout0_9ck34 = 0 time = 350
* CHECK dout0_10 vdout0_10ck34 = 0 time = 350
* CHECK dout0_11 vdout0_11ck34 = 0 time = 350
* CHECK dout0_12 vdout0_12ck34 = 0 time = 350
* CHECK dout0_13 vdout0_13ck34 = 0 time = 350
* CHECK dout0_14 vdout0_14ck34 = 3.3 time = 350
* CHECK dout0_15 vdout0_15ck34 = 3.3 time = 350
* CHECK dout0_16 vdout0_16ck34 = 3.3 time = 350
* CHECK dout0_17 vdout0_17ck34 = 3.3 time = 350
* CHECK dout0_18 vdout0_18ck34 = 3.3 time = 350
* CHECK dout0_19 vdout0_19ck34 = 3.3 time = 350
* CHECK dout0_20 vdout0_20ck34 = 3.3 time = 350
* CHECK dout0_21 vdout0_21ck34 = 3.3 time = 350
* CHECK dout0_22 vdout0_22ck34 = 0 time = 350
* CHECK dout0_23 vdout0_23ck34 = 0 time = 350
* CHECK dout0_24 vdout0_24ck34 = 0 time = 350
* CHECK dout0_25 vdout0_25ck34 = 0 time = 350
* CHECK dout0_26 vdout0_26ck34 = 3.3 time = 350
* CHECK dout0_27 vdout0_27ck34 = 3.3 time = 350
* CHECK dout0_28 vdout0_28ck34 = 0 time = 350
* CHECK dout0_29 vdout0_29ck34 = 0 time = 350
* CHECK dout0_30 vdout0_30ck34 = 3.3 time = 350
* CHECK dout0_31 vdout0_31ck34 = 3.3 time = 350
* CHECK dout0_0 vdout0_0ck37 = 0 time = 380
* CHECK dout0_1 vdout0_1ck37 = 0 time = 380
* CHECK dout0_2 vdout0_2ck37 = 0 time = 380
* CHECK dout0_3 vdout0_3ck37 = 0 time = 380
* CHECK dout0_4 vdout0_4ck37 = 0 time = 380
* CHECK dout0_5 vdout0_5ck37 = 0 time = 380
* CHECK dout0_6 vdout0_6ck37 = 3.3 time = 380
* CHECK dout0_7 vdout0_7ck37 = 0 time = 380
* CHECK dout0_8 vdout0_8ck37 = 3.3 time = 380
* CHECK dout0_9 vdout0_9ck37 = 0 time = 380
* CHECK dout0_10 vdout0_10ck37 = 0 time = 380
* CHECK dout0_11 vdout0_11ck37 = 0 time = 380
* CHECK dout0_12 vdout0_12ck37 = 0 time = 380
* CHECK dout0_13 vdout0_13ck37 = 0 time = 380
* CHECK dout0_14 vdout0_14ck37 = 0 time = 380
* CHECK dout0_15 vdout0_15ck37 = 0 time = 380
* CHECK dout0_16 vdout0_16ck37 = 0 time = 380
* CHECK dout0_17 vdout0_17ck37 = 3.3 time = 380
* CHECK dout0_18 vdout0_18ck37 = 3.3 time = 380
* CHECK dout0_19 vdout0_19ck37 = 0 time = 380
* CHECK dout0_20 vdout0_20ck37 = 3.3 time = 380
* CHECK dout0_21 vdout0_21ck37 = 0 time = 380
* CHECK dout0_22 vdout0_22ck37 = 0 time = 380
* CHECK dout0_23 vdout0_23ck37 = 0 time = 380
* CHECK dout0_24 vdout0_24ck37 = 3.3 time = 380
* CHECK dout0_25 vdout0_25ck37 = 0 time = 380
* CHECK dout0_26 vdout0_26ck37 = 0 time = 380
* CHECK dout0_27 vdout0_27ck37 = 0 time = 380
* CHECK dout0_28 vdout0_28ck37 = 0 time = 380
* CHECK dout0_29 vdout0_29ck37 = 3.3 time = 380
* CHECK dout0_30 vdout0_30ck37 = 3.3 time = 380
* CHECK dout0_31 vdout0_31ck37 = 0 time = 380
* CHECK dout1_0 vdout1_0ck38 = 3.3 time = 390
* CHECK dout1_1 vdout1_1ck38 = 0 time = 390
* CHECK dout1_2 vdout1_2ck38 = 0 time = 390
* CHECK dout1_3 vdout1_3ck38 = 0 time = 390
* CHECK dout1_4 vdout1_4ck38 = 3.3 time = 390
* CHECK dout1_5 vdout1_5ck38 = 3.3 time = 390
* CHECK dout1_6 vdout1_6ck38 = 0 time = 390
* CHECK dout1_7 vdout1_7ck38 = 3.3 time = 390
* CHECK dout1_8 vdout1_8ck38 = 0 time = 390
* CHECK dout1_9 vdout1_9ck38 = 3.3 time = 390
* CHECK dout1_10 vdout1_10ck38 = 0 time = 390
* CHECK dout1_11 vdout1_11ck38 = 3.3 time = 390
* CHECK dout1_12 vdout1_12ck38 = 0 time = 390
* CHECK dout1_13 vdout1_13ck38 = 3.3 time = 390
* CHECK dout1_14 vdout1_14ck38 = 3.3 time = 390
* CHECK dout1_15 vdout1_15ck38 = 3.3 time = 390
* CHECK dout1_16 vdout1_16ck38 = 0 time = 390
* CHECK dout1_17 vdout1_17ck38 = 3.3 time = 390
* CHECK dout1_18 vdout1_18ck38 = 0 time = 390
* CHECK dout1_19 vdout1_19ck38 = 0 time = 390
* CHECK dout1_20 vdout1_20ck38 = 0 time = 390
* CHECK dout1_21 vdout1_21ck38 = 0 time = 390
* CHECK dout1_22 vdout1_22ck38 = 0 time = 390
* CHECK dout1_23 vdout1_23ck38 = 3.3 time = 390
* CHECK dout1_24 vdout1_24ck38 = 3.3 time = 390
* CHECK dout1_25 vdout1_25ck38 = 0 time = 390
* CHECK dout1_26 vdout1_26ck38 = 0 time = 390
* CHECK dout1_27 vdout1_27ck38 = 3.3 time = 390
* CHECK dout1_28 vdout1_28ck38 = 3.3 time = 390
* CHECK dout1_29 vdout1_29ck38 = 3.3 time = 390
* CHECK dout1_30 vdout1_30ck38 = 3.3 time = 390
* CHECK dout1_31 vdout1_31ck38 = 3.3 time = 390
* CHECK dout0_0 vdout0_0ck39 = 3.3 time = 400
* CHECK dout0_1 vdout0_1ck39 = 0 time = 400
* CHECK dout0_2 vdout0_2ck39 = 0 time = 400
* CHECK dout0_3 vdout0_3ck39 = 0 time = 400
* CHECK dout0_4 vdout0_4ck39 = 3.3 time = 400
* CHECK dout0_5 vdout0_5ck39 = 3.3 time = 400
* CHECK dout0_6 vdout0_6ck39 = 0 time = 400
* CHECK dout0_7 vdout0_7ck39 = 3.3 time = 400
* CHECK dout0_8 vdout0_8ck39 = 0 time = 400
* CHECK dout0_9 vdout0_9ck39 = 3.3 time = 400
* CHECK dout0_10 vdout0_10ck39 = 0 time = 400
* CHECK dout0_11 vdout0_11ck39 = 3.3 time = 400
* CHECK dout0_12 vdout0_12ck39 = 0 time = 400
* CHECK dout0_13 vdout0_13ck39 = 3.3 time = 400
* CHECK dout0_14 vdout0_14ck39 = 3.3 time = 400
* CHECK dout0_15 vdout0_15ck39 = 3.3 time = 400
* CHECK dout0_16 vdout0_16ck39 = 0 time = 400
* CHECK dout0_17 vdout0_17ck39 = 3.3 time = 400
* CHECK dout0_18 vdout0_18ck39 = 0 time = 400
* CHECK dout0_19 vdout0_19ck39 = 0 time = 400
* CHECK dout0_20 vdout0_20ck39 = 0 time = 400
* CHECK dout0_21 vdout0_21ck39 = 0 time = 400
* CHECK dout0_22 vdout0_22ck39 = 0 time = 400
* CHECK dout0_23 vdout0_23ck39 = 3.3 time = 400
* CHECK dout0_24 vdout0_24ck39 = 3.3 time = 400
* CHECK dout0_25 vdout0_25ck39 = 0 time = 400
* CHECK dout0_26 vdout0_26ck39 = 0 time = 400
* CHECK dout0_27 vdout0_27ck39 = 3.3 time = 400
* CHECK dout0_28 vdout0_28ck39 = 3.3 time = 400
* CHECK dout0_29 vdout0_29ck39 = 3.3 time = 400
* CHECK dout0_30 vdout0_30ck39 = 3.3 time = 400
* CHECK dout0_31 vdout0_31ck39 = 3.3 time = 400
* CHECK dout1_0 vdout1_0ck39 = 0 time = 400
* CHECK dout1_1 vdout1_1ck39 = 0 time = 400
* CHECK dout1_2 vdout1_2ck39 = 0 time = 400
* CHECK dout1_3 vdout1_3ck39 = 0 time = 400
* CHECK dout1_4 vdout1_4ck39 = 0 time = 400
* CHECK dout1_5 vdout1_5ck39 = 0 time = 400
* CHECK dout1_6 vdout1_6ck39 = 3.3 time = 400
* CHECK dout1_7 vdout1_7ck39 = 0 time = 400
* CHECK dout1_8 vdout1_8ck39 = 3.3 time = 400
* CHECK dout1_9 vdout1_9ck39 = 0 time = 400
* CHECK dout1_10 vdout1_10ck39 = 0 time = 400
* CHECK dout1_11 vdout1_11ck39 = 0 time = 400
* CHECK dout1_12 vdout1_12ck39 = 0 time = 400
* CHECK dout1_13 vdout1_13ck39 = 0 time = 400
* CHECK dout1_14 vdout1_14ck39 = 0 time = 400
* CHECK dout1_15 vdout1_15ck39 = 0 time = 400
* CHECK dout1_16 vdout1_16ck39 = 0 time = 400
* CHECK dout1_17 vdout1_17ck39 = 3.3 time = 400
* CHECK dout1_18 vdout1_18ck39 = 3.3 time = 400
* CHECK dout1_19 vdout1_19ck39 = 0 time = 400
* CHECK dout1_20 vdout1_20ck39 = 3.3 time = 400
* CHECK dout1_21 vdout1_21ck39 = 0 time = 400
* CHECK dout1_22 vdout1_22ck39 = 0 time = 400
* CHECK dout1_23 vdout1_23ck39 = 0 time = 400
* CHECK dout1_24 vdout1_24ck39 = 3.3 time = 400
* CHECK dout1_25 vdout1_25ck39 = 0 time = 400
* CHECK dout1_26 vdout1_26ck39 = 0 time = 400
* CHECK dout1_27 vdout1_27ck39 = 0 time = 400
* CHECK dout1_28 vdout1_28ck39 = 0 time = 400
* CHECK dout1_29 vdout1_29ck39 = 3.3 time = 400
* CHECK dout1_30 vdout1_30ck39 = 3.3 time = 400
* CHECK dout1_31 vdout1_31ck39 = 0 time = 400
* CHECK dout0_0 vdout0_0ck40 = 3.3 time = 410
* CHECK dout0_1 vdout0_1ck40 = 0 time = 410
* CHECK dout0_2 vdout0_2ck40 = 0 time = 410
* CHECK dout0_3 vdout0_3ck40 = 0 time = 410
* CHECK dout0_4 vdout0_4ck40 = 3.3 time = 410
* CHECK dout0_5 vdout0_5ck40 = 3.3 time = 410
* CHECK dout0_6 vdout0_6ck40 = 0 time = 410
* CHECK dout0_7 vdout0_7ck40 = 3.3 time = 410
* CHECK dout0_8 vdout0_8ck40 = 0 time = 410
* CHECK dout0_9 vdout0_9ck40 = 3.3 time = 410
* CHECK dout0_10 vdout0_10ck40 = 0 time = 410
* CHECK dout0_11 vdout0_11ck40 = 3.3 time = 410
* CHECK dout0_12 vdout0_12ck40 = 0 time = 410
* CHECK dout0_13 vdout0_13ck40 = 3.3 time = 410
* CHECK dout0_14 vdout0_14ck40 = 3.3 time = 410
* CHECK dout0_15 vdout0_15ck40 = 3.3 time = 410
* CHECK dout0_16 vdout0_16ck40 = 0 time = 410
* CHECK dout0_17 vdout0_17ck40 = 3.3 time = 410
* CHECK dout0_18 vdout0_18ck40 = 0 time = 410
* CHECK dout0_19 vdout0_19ck40 = 0 time = 410
* CHECK dout0_20 vdout0_20ck40 = 0 time = 410
* CHECK dout0_21 vdout0_21ck40 = 0 time = 410
* CHECK dout0_22 vdout0_22ck40 = 0 time = 410
* CHECK dout0_23 vdout0_23ck40 = 3.3 time = 410
* CHECK dout0_24 vdout0_24ck40 = 3.3 time = 410
* CHECK dout0_25 vdout0_25ck40 = 0 time = 410
* CHECK dout0_26 vdout0_26ck40 = 0 time = 410
* CHECK dout0_27 vdout0_27ck40 = 3.3 time = 410
* CHECK dout0_28 vdout0_28ck40 = 3.3 time = 410
* CHECK dout0_29 vdout0_29ck40 = 3.3 time = 410
* CHECK dout0_30 vdout0_30ck40 = 3.3 time = 410
* CHECK dout0_31 vdout0_31ck40 = 3.3 time = 410
* CHECK dout0_0 vdout0_0ck41 = 0 time = 420
* CHECK dout0_1 vdout0_1ck41 = 0 time = 420
* CHECK dout0_2 vdout0_2ck41 = 0 time = 420
* CHECK dout0_3 vdout0_3ck41 = 0 time = 420
* CHECK dout0_4 vdout0_4ck41 = 0 time = 420
* CHECK dout0_5 vdout0_5ck41 = 0 time = 420
* CHECK dout0_6 vdout0_6ck41 = 3.3 time = 420
* CHECK dout0_7 vdout0_7ck41 = 0 time = 420
* CHECK dout0_8 vdout0_8ck41 = 3.3 time = 420
* CHECK dout0_9 vdout0_9ck41 = 0 time = 420
* CHECK dout0_10 vdout0_10ck41 = 0 time = 420
* CHECK dout0_11 vdout0_11ck41 = 0 time = 420
* CHECK dout0_12 vdout0_12ck41 = 0 time = 420
* CHECK dout0_13 vdout0_13ck41 = 0 time = 420
* CHECK dout0_14 vdout0_14ck41 = 0 time = 420
* CHECK dout0_15 vdout0_15ck41 = 0 time = 420
* CHECK dout0_16 vdout0_16ck41 = 0 time = 420
* CHECK dout0_17 vdout0_17ck41 = 3.3 time = 420
* CHECK dout0_18 vdout0_18ck41 = 3.3 time = 420
* CHECK dout0_19 vdout0_19ck41 = 0 time = 420
* CHECK dout0_20 vdout0_20ck41 = 3.3 time = 420
* CHECK dout0_21 vdout0_21ck41 = 0 time = 420
* CHECK dout0_22 vdout0_22ck41 = 0 time = 420
* CHECK dout0_23 vdout0_23ck41 = 0 time = 420
* CHECK dout0_24 vdout0_24ck41 = 3.3 time = 420
* CHECK dout0_25 vdout0_25ck41 = 0 time = 420
* CHECK dout0_26 vdout0_26ck41 = 0 time = 420
* CHECK dout0_27 vdout0_27ck41 = 0 time = 420
* CHECK dout0_28 vdout0_28ck41 = 0 time = 420
* CHECK dout0_29 vdout0_29ck41 = 3.3 time = 420
* CHECK dout0_30 vdout0_30ck41 = 3.3 time = 420
* CHECK dout0_31 vdout0_31ck41 = 0 time = 420
* CHECK dout1_0 vdout1_0ck41 = 0 time = 420
* CHECK dout1_1 vdout1_1ck41 = 0 time = 420
* CHECK dout1_2 vdout1_2ck41 = 0 time = 420
* CHECK dout1_3 vdout1_3ck41 = 0 time = 420
* CHECK dout1_4 vdout1_4ck41 = 0 time = 420
* CHECK dout1_5 vdout1_5ck41 = 0 time = 420
* CHECK dout1_6 vdout1_6ck41 = 3.3 time = 420
* CHECK dout1_7 vdout1_7ck41 = 0 time = 420
* CHECK dout1_8 vdout1_8ck41 = 3.3 time = 420
* CHECK dout1_9 vdout1_9ck41 = 0 time = 420
* CHECK dout1_10 vdout1_10ck41 = 0 time = 420
* CHECK dout1_11 vdout1_11ck41 = 0 time = 420
* CHECK dout1_12 vdout1_12ck41 = 0 time = 420
* CHECK dout1_13 vdout1_13ck41 = 0 time = 420
* CHECK dout1_14 vdout1_14ck41 = 0 time = 420
* CHECK dout1_15 vdout1_15ck41 = 0 time = 420
* CHECK dout1_16 vdout1_16ck41 = 0 time = 420
* CHECK dout1_17 vdout1_17ck41 = 3.3 time = 420
* CHECK dout1_18 vdout1_18ck41 = 3.3 time = 420
* CHECK dout1_19 vdout1_19ck41 = 0 time = 420
* CHECK dout1_20 vdout1_20ck41 = 3.3 time = 420
* CHECK dout1_21 vdout1_21ck41 = 0 time = 420
* CHECK dout1_22 vdout1_22ck41 = 0 time = 420
* CHECK dout1_23 vdout1_23ck41 = 0 time = 420
* CHECK dout1_24 vdout1_24ck41 = 3.3 time = 420
* CHECK dout1_25 vdout1_25ck41 = 0 time = 420
* CHECK dout1_26 vdout1_26ck41 = 0 time = 420
* CHECK dout1_27 vdout1_27ck41 = 0 time = 420
* CHECK dout1_28 vdout1_28ck41 = 0 time = 420
* CHECK dout1_29 vdout1_29ck41 = 3.3 time = 420
* CHECK dout1_30 vdout1_30ck41 = 3.3 time = 420
* CHECK dout1_31 vdout1_31ck41 = 0 time = 420
* CHECK dout1_0 vdout1_0ck42 = 0 time = 430
* CHECK dout1_1 vdout1_1ck42 = 0 time = 430
* CHECK dout1_2 vdout1_2ck42 = 0 time = 430
* CHECK dout1_3 vdout1_3ck42 = 0 time = 430
* CHECK dout1_4 vdout1_4ck42 = 0 time = 430
* CHECK dout1_5 vdout1_5ck42 = 0 time = 430
* CHECK dout1_6 vdout1_6ck42 = 3.3 time = 430
* CHECK dout1_7 vdout1_7ck42 = 0 time = 430
* CHECK dout1_8 vdout1_8ck42 = 3.3 time = 430
* CHECK dout1_9 vdout1_9ck42 = 0 time = 430
* CHECK dout1_10 vdout1_10ck42 = 0 time = 430
* CHECK dout1_11 vdout1_11ck42 = 0 time = 430
* CHECK dout1_12 vdout1_12ck42 = 0 time = 430
* CHECK dout1_13 vdout1_13ck42 = 0 time = 430
* CHECK dout1_14 vdout1_14ck42 = 0 time = 430
* CHECK dout1_15 vdout1_15ck42 = 0 time = 430
* CHECK dout1_16 vdout1_16ck42 = 0 time = 430
* CHECK dout1_17 vdout1_17ck42 = 3.3 time = 430
* CHECK dout1_18 vdout1_18ck42 = 3.3 time = 430
* CHECK dout1_19 vdout1_19ck42 = 0 time = 430
* CHECK dout1_20 vdout1_20ck42 = 3.3 time = 430
* CHECK dout1_21 vdout1_21ck42 = 0 time = 430
* CHECK dout1_22 vdout1_22ck42 = 0 time = 430
* CHECK dout1_23 vdout1_23ck42 = 0 time = 430
* CHECK dout1_24 vdout1_24ck42 = 3.3 time = 430
* CHECK dout1_25 vdout1_25ck42 = 0 time = 430
* CHECK dout1_26 vdout1_26ck42 = 0 time = 430
* CHECK dout1_27 vdout1_27ck42 = 0 time = 430
* CHECK dout1_28 vdout1_28ck42 = 0 time = 430
* CHECK dout1_29 vdout1_29ck42 = 3.3 time = 430
* CHECK dout1_30 vdout1_30ck42 = 3.3 time = 430
* CHECK dout1_31 vdout1_31ck42 = 0 time = 430
* CHECK dout0_0 vdout0_0ck44 = 0 time = 450
* CHECK dout0_1 vdout0_1ck44 = 0 time = 450
* CHECK dout0_2 vdout0_2ck44 = 0 time = 450
* CHECK dout0_3 vdout0_3ck44 = 3.3 time = 450
* CHECK dout0_4 vdout0_4ck44 = 0 time = 450
* CHECK dout0_5 vdout0_5ck44 = 0 time = 450
* CHECK dout0_6 vdout0_6ck44 = 0 time = 450
* CHECK dout0_7 vdout0_7ck44 = 0 time = 450
* CHECK dout0_8 vdout0_8ck44 = 0 time = 450
* CHECK dout0_9 vdout0_9ck44 = 0 time = 450
* CHECK dout0_10 vdout0_10ck44 = 0 time = 450
* CHECK dout0_11 vdout0_11ck44 = 3.3 time = 450
* CHECK dout0_12 vdout0_12ck44 = 0 time = 450
* CHECK dout0_13 vdout0_13ck44 = 0 time = 450
* CHECK dout0_14 vdout0_14ck44 = 3.3 time = 450
* CHECK dout0_15 vdout0_15ck44 = 3.3 time = 450
* CHECK dout0_16 vdout0_16ck44 = 3.3 time = 450
* CHECK dout0_17 vdout0_17ck44 = 3.3 time = 450
* CHECK dout0_18 vdout0_18ck44 = 3.3 time = 450
* CHECK dout0_19 vdout0_19ck44 = 0 time = 450
* CHECK dout0_20 vdout0_20ck44 = 3.3 time = 450
* CHECK dout0_21 vdout0_21ck44 = 3.3 time = 450
* CHECK dout0_22 vdout0_22ck44 = 3.3 time = 450
* CHECK dout0_23 vdout0_23ck44 = 0 time = 450
* CHECK dout0_24 vdout0_24ck44 = 3.3 time = 450
* CHECK dout0_25 vdout0_25ck44 = 3.3 time = 450
* CHECK dout0_26 vdout0_26ck44 = 3.3 time = 450
* CHECK dout0_27 vdout0_27ck44 = 0 time = 450
* CHECK dout0_28 vdout0_28ck44 = 3.3 time = 450
* CHECK dout0_29 vdout0_29ck44 = 3.3 time = 450
* CHECK dout0_30 vdout0_30ck44 = 0 time = 450
* CHECK dout0_31 vdout0_31ck44 = 0 time = 450
* CHECK dout1_0 vdout1_0ck45 = 0 time = 460
* CHECK dout1_1 vdout1_1ck45 = 0 time = 460
* CHECK dout1_2 vdout1_2ck45 = 0 time = 460
* CHECK dout1_3 vdout1_3ck45 = 3.3 time = 460
* CHECK dout1_4 vdout1_4ck45 = 0 time = 460
* CHECK dout1_5 vdout1_5ck45 = 0 time = 460
* CHECK dout1_6 vdout1_6ck45 = 0 time = 460
* CHECK dout1_7 vdout1_7ck45 = 0 time = 460
* CHECK dout1_8 vdout1_8ck45 = 0 time = 460
* CHECK dout1_9 vdout1_9ck45 = 0 time = 460
* CHECK dout1_10 vdout1_10ck45 = 0 time = 460
* CHECK dout1_11 vdout1_11ck45 = 3.3 time = 460
* CHECK dout1_12 vdout1_12ck45 = 0 time = 460
* CHECK dout1_13 vdout1_13ck45 = 0 time = 460
* CHECK dout1_14 vdout1_14ck45 = 3.3 time = 460
* CHECK dout1_15 vdout1_15ck45 = 3.3 time = 460
* CHECK dout1_16 vdout1_16ck45 = 3.3 time = 460
* CHECK dout1_17 vdout1_17ck45 = 3.3 time = 460
* CHECK dout1_18 vdout1_18ck45 = 3.3 time = 460
* CHECK dout1_19 vdout1_19ck45 = 0 time = 460
* CHECK dout1_20 vdout1_20ck45 = 3.3 time = 460
* CHECK dout1_21 vdout1_21ck45 = 3.3 time = 460
* CHECK dout1_22 vdout1_22ck45 = 3.3 time = 460
* CHECK dout1_23 vdout1_23ck45 = 0 time = 460
* CHECK dout1_24 vdout1_24ck45 = 3.3 time = 460
* CHECK dout1_25 vdout1_25ck45 = 3.3 time = 460
* CHECK dout1_26 vdout1_26ck45 = 3.3 time = 460
* CHECK dout1_27 vdout1_27ck45 = 0 time = 460
* CHECK dout1_28 vdout1_28ck45 = 3.3 time = 460
* CHECK dout1_29 vdout1_29ck45 = 3.3 time = 460
* CHECK dout1_30 vdout1_30ck45 = 0 time = 460
* CHECK dout1_31 vdout1_31ck45 = 0 time = 460
* CHECK dout0_0 vdout0_0ck46 = 0 time = 470
* CHECK dout0_1 vdout0_1ck46 = 0 time = 470
* CHECK dout0_2 vdout0_2ck46 = 0 time = 470
* CHECK dout0_3 vdout0_3ck46 = 3.3 time = 470
* CHECK dout0_4 vdout0_4ck46 = 0 time = 470
* CHECK dout0_5 vdout0_5ck46 = 0 time = 470
* CHECK dout0_6 vdout0_6ck46 = 0 time = 470
* CHECK dout0_7 vdout0_7ck46 = 0 time = 470
* CHECK dout0_8 vdout0_8ck46 = 0 time = 470
* CHECK dout0_9 vdout0_9ck46 = 0 time = 470
* CHECK dout0_10 vdout0_10ck46 = 0 time = 470
* CHECK dout0_11 vdout0_11ck46 = 3.3 time = 470
* CHECK dout0_12 vdout0_12ck46 = 0 time = 470
* CHECK dout0_13 vdout0_13ck46 = 0 time = 470
* CHECK dout0_14 vdout0_14ck46 = 3.3 time = 470
* CHECK dout0_15 vdout0_15ck46 = 3.3 time = 470
* CHECK dout0_16 vdout0_16ck46 = 3.3 time = 470
* CHECK dout0_17 vdout0_17ck46 = 3.3 time = 470
* CHECK dout0_18 vdout0_18ck46 = 3.3 time = 470
* CHECK dout0_19 vdout0_19ck46 = 0 time = 470
* CHECK dout0_20 vdout0_20ck46 = 3.3 time = 470
* CHECK dout0_21 vdout0_21ck46 = 3.3 time = 470
* CHECK dout0_22 vdout0_22ck46 = 3.3 time = 470
* CHECK dout0_23 vdout0_23ck46 = 0 time = 470
* CHECK dout0_24 vdout0_24ck46 = 3.3 time = 470
* CHECK dout0_25 vdout0_25ck46 = 3.3 time = 470
* CHECK dout0_26 vdout0_26ck46 = 3.3 time = 470
* CHECK dout0_27 vdout0_27ck46 = 0 time = 470
* CHECK dout0_28 vdout0_28ck46 = 3.3 time = 470
* CHECK dout0_29 vdout0_29ck46 = 3.3 time = 470
* CHECK dout0_30 vdout0_30ck46 = 0 time = 470
* CHECK dout0_31 vdout0_31ck46 = 0 time = 470
* CHECK dout1_0 vdout1_0ck46 = 3.3 time = 470
* CHECK dout1_1 vdout1_1ck46 = 0 time = 470
* CHECK dout1_2 vdout1_2ck46 = 0 time = 470
* CHECK dout1_3 vdout1_3ck46 = 0 time = 470
* CHECK dout1_4 vdout1_4ck46 = 0 time = 470
* CHECK dout1_5 vdout1_5ck46 = 0 time = 470
* CHECK dout1_6 vdout1_6ck46 = 0 time = 470
* CHECK dout1_7 vdout1_7ck46 = 3.3 time = 470
* CHECK dout1_8 vdout1_8ck46 = 0 time = 470
* CHECK dout1_9 vdout1_9ck46 = 0 time = 470
* CHECK dout1_10 vdout1_10ck46 = 0 time = 470
* CHECK dout1_11 vdout1_11ck46 = 3.3 time = 470
* CHECK dout1_12 vdout1_12ck46 = 3.3 time = 470
* CHECK dout1_13 vdout1_13ck46 = 3.3 time = 470
* CHECK dout1_14 vdout1_14ck46 = 3.3 time = 470
* CHECK dout1_15 vdout1_15ck46 = 3.3 time = 470
* CHECK dout1_16 vdout1_16ck46 = 3.3 time = 470
* CHECK dout1_17 vdout1_17ck46 = 0 time = 470
* CHECK dout1_18 vdout1_18ck46 = 3.3 time = 470
* CHECK dout1_19 vdout1_19ck46 = 0 time = 470
* CHECK dout1_20 vdout1_20ck46 = 3.3 time = 470
* CHECK dout1_21 vdout1_21ck46 = 3.3 time = 470
* CHECK dout1_22 vdout1_22ck46 = 0 time = 470
* CHECK dout1_23 vdout1_23ck46 = 0 time = 470
* CHECK dout1_24 vdout1_24ck46 = 0 time = 470
* CHECK dout1_25 vdout1_25ck46 = 0 time = 470
* CHECK dout1_26 vdout1_26ck46 = 0 time = 470
* CHECK dout1_27 vdout1_27ck46 = 3.3 time = 470
* CHECK dout1_28 vdout1_28ck46 = 3.3 time = 470
* CHECK dout1_29 vdout1_29ck46 = 0 time = 470
* CHECK dout1_30 vdout1_30ck46 = 0 time = 470
* CHECK dout1_31 vdout1_31ck46 = 0 time = 470
* CHECK dout1_0 vdout1_0ck47 = 0 time = 480
* CHECK dout1_1 vdout1_1ck47 = 0 time = 480
* CHECK dout1_2 vdout1_2ck47 = 0 time = 480
* CHECK dout1_3 vdout1_3ck47 = 3.3 time = 480
* CHECK dout1_4 vdout1_4ck47 = 0 time = 480
* CHECK dout1_5 vdout1_5ck47 = 0 time = 480
* CHECK dout1_6 vdout1_6ck47 = 0 time = 480
* CHECK dout1_7 vdout1_7ck47 = 0 time = 480
* CHECK dout1_8 vdout1_8ck47 = 0 time = 480
* CHECK dout1_9 vdout1_9ck47 = 0 time = 480
* CHECK dout1_10 vdout1_10ck47 = 0 time = 480
* CHECK dout1_11 vdout1_11ck47 = 3.3 time = 480
* CHECK dout1_12 vdout1_12ck47 = 0 time = 480
* CHECK dout1_13 vdout1_13ck47 = 0 time = 480
* CHECK dout1_14 vdout1_14ck47 = 3.3 time = 480
* CHECK dout1_15 vdout1_15ck47 = 3.3 time = 480
* CHECK dout1_16 vdout1_16ck47 = 3.3 time = 480
* CHECK dout1_17 vdout1_17ck47 = 3.3 time = 480
* CHECK dout1_18 vdout1_18ck47 = 3.3 time = 480
* CHECK dout1_19 vdout1_19ck47 = 0 time = 480
* CHECK dout1_20 vdout1_20ck47 = 3.3 time = 480
* CHECK dout1_21 vdout1_21ck47 = 3.3 time = 480
* CHECK dout1_22 vdout1_22ck47 = 3.3 time = 480
* CHECK dout1_23 vdout1_23ck47 = 0 time = 480
* CHECK dout1_24 vdout1_24ck47 = 3.3 time = 480
* CHECK dout1_25 vdout1_25ck47 = 3.3 time = 480
* CHECK dout1_26 vdout1_26ck47 = 3.3 time = 480
* CHECK dout1_27 vdout1_27ck47 = 0 time = 480
* CHECK dout1_28 vdout1_28ck47 = 3.3 time = 480
* CHECK dout1_29 vdout1_29ck47 = 3.3 time = 480
* CHECK dout1_30 vdout1_30ck47 = 0 time = 480
* CHECK dout1_31 vdout1_31ck47 = 0 time = 480
* CHECK dout0_0 vdout0_0ck48 = 0 time = 490
* CHECK dout0_1 vdout0_1ck48 = 0 time = 490
* CHECK dout0_2 vdout0_2ck48 = 0 time = 490
* CHECK dout0_3 vdout0_3ck48 = 3.3 time = 490
* CHECK dout0_4 vdout0_4ck48 = 0 time = 490
* CHECK dout0_5 vdout0_5ck48 = 0 time = 490
* CHECK dout0_6 vdout0_6ck48 = 0 time = 490
* CHECK dout0_7 vdout0_7ck48 = 0 time = 490
* CHECK dout0_8 vdout0_8ck48 = 0 time = 490
* CHECK dout0_9 vdout0_9ck48 = 0 time = 490
* CHECK dout0_10 vdout0_10ck48 = 0 time = 490
* CHECK dout0_11 vdout0_11ck48 = 3.3 time = 490
* CHECK dout0_12 vdout0_12ck48 = 0 time = 490
* CHECK dout0_13 vdout0_13ck48 = 0 time = 490
* CHECK dout0_14 vdout0_14ck48 = 3.3 time = 490
* CHECK dout0_15 vdout0_15ck48 = 3.3 time = 490
* CHECK dout0_16 vdout0_16ck48 = 3.3 time = 490
* CHECK dout0_17 vdout0_17ck48 = 3.3 time = 490
* CHECK dout0_18 vdout0_18ck48 = 3.3 time = 490
* CHECK dout0_19 vdout0_19ck48 = 0 time = 490
* CHECK dout0_20 vdout0_20ck48 = 3.3 time = 490
* CHECK dout0_21 vdout0_21ck48 = 3.3 time = 490
* CHECK dout0_22 vdout0_22ck48 = 3.3 time = 490
* CHECK dout0_23 vdout0_23ck48 = 0 time = 490
* CHECK dout0_24 vdout0_24ck48 = 3.3 time = 490
* CHECK dout0_25 vdout0_25ck48 = 3.3 time = 490
* CHECK dout0_26 vdout0_26ck48 = 3.3 time = 490
* CHECK dout0_27 vdout0_27ck48 = 0 time = 490
* CHECK dout0_28 vdout0_28ck48 = 3.3 time = 490
* CHECK dout0_29 vdout0_29ck48 = 3.3 time = 490
* CHECK dout0_30 vdout0_30ck48 = 0 time = 490
* CHECK dout0_31 vdout0_31ck48 = 0 time = 490
* CHECK dout1_0 vdout1_0ck48 = 3.3 time = 490
* CHECK dout1_1 vdout1_1ck48 = 0 time = 490
* CHECK dout1_2 vdout1_2ck48 = 0 time = 490
* CHECK dout1_3 vdout1_3ck48 = 0 time = 490
* CHECK dout1_4 vdout1_4ck48 = 0 time = 490
* CHECK dout1_5 vdout1_5ck48 = 0 time = 490
* CHECK dout1_6 vdout1_6ck48 = 0 time = 490
* CHECK dout1_7 vdout1_7ck48 = 3.3 time = 490
* CHECK dout1_8 vdout1_8ck48 = 0 time = 490
* CHECK dout1_9 vdout1_9ck48 = 0 time = 490
* CHECK dout1_10 vdout1_10ck48 = 0 time = 490
* CHECK dout1_11 vdout1_11ck48 = 3.3 time = 490
* CHECK dout1_12 vdout1_12ck48 = 3.3 time = 490
* CHECK dout1_13 vdout1_13ck48 = 3.3 time = 490
* CHECK dout1_14 vdout1_14ck48 = 3.3 time = 490
* CHECK dout1_15 vdout1_15ck48 = 3.3 time = 490
* CHECK dout1_16 vdout1_16ck48 = 3.3 time = 490
* CHECK dout1_17 vdout1_17ck48 = 0 time = 490
* CHECK dout1_18 vdout1_18ck48 = 3.3 time = 490
* CHECK dout1_19 vdout1_19ck48 = 0 time = 490
* CHECK dout1_20 vdout1_20ck48 = 3.3 time = 490
* CHECK dout1_21 vdout1_21ck48 = 3.3 time = 490
* CHECK dout1_22 vdout1_22ck48 = 0 time = 490
* CHECK dout1_23 vdout1_23ck48 = 0 time = 490
* CHECK dout1_24 vdout1_24ck48 = 0 time = 490
* CHECK dout1_25 vdout1_25ck48 = 0 time = 490
* CHECK dout1_26 vdout1_26ck48 = 0 time = 490
* CHECK dout1_27 vdout1_27ck48 = 3.3 time = 490
* CHECK dout1_28 vdout1_28ck48 = 3.3 time = 490
* CHECK dout1_29 vdout1_29ck48 = 0 time = 490
* CHECK dout1_30 vdout1_30ck48 = 0 time = 490
* CHECK dout1_31 vdout1_31ck48 = 0 time = 490
* CHECK dout1_0 vdout1_0ck50 = 3.3 time = 510
* CHECK dout1_1 vdout1_1ck50 = 0 time = 510
* CHECK dout1_2 vdout1_2ck50 = 0 time = 510
* CHECK dout1_3 vdout1_3ck50 = 0 time = 510
* CHECK dout1_4 vdout1_4ck50 = 0 time = 510
* CHECK dout1_5 vdout1_5ck50 = 0 time = 510
* CHECK dout1_6 vdout1_6ck50 = 0 time = 510
* CHECK dout1_7 vdout1_7ck50 = 3.3 time = 510
* CHECK dout1_8 vdout1_8ck50 = 0 time = 510
* CHECK dout1_9 vdout1_9ck50 = 0 time = 510
* CHECK dout1_10 vdout1_10ck50 = 0 time = 510
* CHECK dout1_11 vdout1_11ck50 = 3.3 time = 510
* CHECK dout1_12 vdout1_12ck50 = 3.3 time = 510
* CHECK dout1_13 vdout1_13ck50 = 3.3 time = 510
* CHECK dout1_14 vdout1_14ck50 = 3.3 time = 510
* CHECK dout1_15 vdout1_15ck50 = 3.3 time = 510
* CHECK dout1_16 vdout1_16ck50 = 3.3 time = 510
* CHECK dout1_17 vdout1_17ck50 = 0 time = 510
* CHECK dout1_18 vdout1_18ck50 = 3.3 time = 510
* CHECK dout1_19 vdout1_19ck50 = 0 time = 510
* CHECK dout1_20 vdout1_20ck50 = 3.3 time = 510
* CHECK dout1_21 vdout1_21ck50 = 3.3 time = 510
* CHECK dout1_22 vdout1_22ck50 = 0 time = 510
* CHECK dout1_23 vdout1_23ck50 = 0 time = 510
* CHECK dout1_24 vdout1_24ck50 = 0 time = 510
* CHECK dout1_25 vdout1_25ck50 = 0 time = 510
* CHECK dout1_26 vdout1_26ck50 = 0 time = 510
* CHECK dout1_27 vdout1_27ck50 = 3.3 time = 510
* CHECK dout1_28 vdout1_28ck50 = 3.3 time = 510
* CHECK dout1_29 vdout1_29ck50 = 0 time = 510
* CHECK dout1_30 vdout1_30ck50 = 0 time = 510
* CHECK dout1_31 vdout1_31ck50 = 0 time = 510
* CHECK dout0_0 vdout0_0ck53 = 3.3 time = 540
* CHECK dout0_1 vdout0_1ck53 = 3.3 time = 540
* CHECK dout0_2 vdout0_2ck53 = 0 time = 540
* CHECK dout0_3 vdout0_3ck53 = 0 time = 540
* CHECK dout0_4 vdout0_4ck53 = 3.3 time = 540
* CHECK dout0_5 vdout0_5ck53 = 0 time = 540
* CHECK dout0_6 vdout0_6ck53 = 3.3 time = 540
* CHECK dout0_7 vdout0_7ck53 = 3.3 time = 540
* CHECK dout0_8 vdout0_8ck53 = 0 time = 540
* CHECK dout0_9 vdout0_9ck53 = 3.3 time = 540
* CHECK dout0_10 vdout0_10ck53 = 0 time = 540
* CHECK dout0_11 vdout0_11ck53 = 0 time = 540
* CHECK dout0_12 vdout0_12ck53 = 0 time = 540
* CHECK dout0_13 vdout0_13ck53 = 3.3 time = 540
* CHECK dout0_14 vdout0_14ck53 = 3.3 time = 540
* CHECK dout0_15 vdout0_15ck53 = 0 time = 540
* CHECK dout0_16 vdout0_16ck53 = 3.3 time = 540
* CHECK dout0_17 vdout0_17ck53 = 0 time = 540
* CHECK dout0_18 vdout0_18ck53 = 0 time = 540
* CHECK dout0_19 vdout0_19ck53 = 3.3 time = 540
* CHECK dout0_20 vdout0_20ck53 = 0 time = 540
* CHECK dout0_21 vdout0_21ck53 = 3.3 time = 540
* CHECK dout0_22 vdout0_22ck53 = 0 time = 540
* CHECK dout0_23 vdout0_23ck53 = 0 time = 540
* CHECK dout0_24 vdout0_24ck53 = 3.3 time = 540
* CHECK dout0_25 vdout0_25ck53 = 3.3 time = 540
* CHECK dout0_26 vdout0_26ck53 = 0 time = 540
* CHECK dout0_27 vdout0_27ck53 = 3.3 time = 540
* CHECK dout0_28 vdout0_28ck53 = 3.3 time = 540
* CHECK dout0_29 vdout0_29ck53 = 0 time = 540
* CHECK dout0_30 vdout0_30ck53 = 0 time = 540
* CHECK dout0_31 vdout0_31ck53 = 3.3 time = 540
* CHECK dout0_0 vdout0_0ck54 = 0 time = 550
* CHECK dout0_1 vdout0_1ck54 = 3.3 time = 550
* CHECK dout0_2 vdout0_2ck54 = 3.3 time = 550
* CHECK dout0_3 vdout0_3ck54 = 3.3 time = 550
* CHECK dout0_4 vdout0_4ck54 = 0 time = 550
* CHECK dout0_5 vdout0_5ck54 = 3.3 time = 550
* CHECK dout0_6 vdout0_6ck54 = 0 time = 550
* CHECK dout0_7 vdout0_7ck54 = 3.3 time = 550
* CHECK dout0_8 vdout0_8ck54 = 3.3 time = 550
* CHECK dout0_9 vdout0_9ck54 = 0 time = 550
* CHECK dout0_10 vdout0_10ck54 = 0 time = 550
* CHECK dout0_11 vdout0_11ck54 = 3.3 time = 550
* CHECK dout0_12 vdout0_12ck54 = 3.3 time = 550
* CHECK dout0_13 vdout0_13ck54 = 0 time = 550
* CHECK dout0_14 vdout0_14ck54 = 0 time = 550
* CHECK dout0_15 vdout0_15ck54 = 0 time = 550
* CHECK dout0_16 vdout0_16ck54 = 0 time = 550
* CHECK dout0_17 vdout0_17ck54 = 3.3 time = 550
* CHECK dout0_18 vdout0_18ck54 = 3.3 time = 550
* CHECK dout0_19 vdout0_19ck54 = 0 time = 550
* CHECK dout0_20 vdout0_20ck54 = 3.3 time = 550
* CHECK dout0_21 vdout0_21ck54 = 0 time = 550
* CHECK dout0_22 vdout0_22ck54 = 0 time = 550
* CHECK dout0_23 vdout0_23ck54 = 0 time = 550
* CHECK dout0_24 vdout0_24ck54 = 3.3 time = 550
* CHECK dout0_25 vdout0_25ck54 = 0 time = 550
* CHECK dout0_26 vdout0_26ck54 = 3.3 time = 550
* CHECK dout0_27 vdout0_27ck54 = 3.3 time = 550
* CHECK dout0_28 vdout0_28ck54 = 3.3 time = 550
* CHECK dout0_29 vdout0_29ck54 = 0 time = 550
* CHECK dout0_30 vdout0_30ck54 = 3.3 time = 550
* CHECK dout0_31 vdout0_31ck54 = 3.3 time = 550
* CHECK dout1_0 vdout1_0ck58 = 3.3 time = 590
* CHECK dout1_1 vdout1_1ck58 = 0 time = 590
* CHECK dout1_2 vdout1_2ck58 = 3.3 time = 590
* CHECK dout1_3 vdout1_3ck58 = 3.3 time = 590
* CHECK dout1_4 vdout1_4ck58 = 3.3 time = 590
* CHECK dout1_5 vdout1_5ck58 = 3.3 time = 590
* CHECK dout1_6 vdout1_6ck58 = 3.3 time = 590
* CHECK dout1_7 vdout1_7ck58 = 0 time = 590
* CHECK dout1_8 vdout1_8ck58 = 3.3 time = 590
* CHECK dout1_9 vdout1_9ck58 = 3.3 time = 590
* CHECK dout1_10 vdout1_10ck58 = 0 time = 590
* CHECK dout1_11 vdout1_11ck58 = 3.3 time = 590
* CHECK dout1_12 vdout1_12ck58 = 0 time = 590
* CHECK dout1_13 vdout1_13ck58 = 0 time = 590
* CHECK dout1_14 vdout1_14ck58 = 3.3 time = 590
* CHECK dout1_15 vdout1_15ck58 = 3.3 time = 590
* CHECK dout1_16 vdout1_16ck58 = 0 time = 590
* CHECK dout1_17 vdout1_17ck58 = 0 time = 590
* CHECK dout1_18 vdout1_18ck58 = 0 time = 590
* CHECK dout1_19 vdout1_19ck58 = 0 time = 590
* CHECK dout1_20 vdout1_20ck58 = 3.3 time = 590
* CHECK dout1_21 vdout1_21ck58 = 3.3 time = 590
* CHECK dout1_22 vdout1_22ck58 = 0 time = 590
* CHECK dout1_23 vdout1_23ck58 = 3.3 time = 590
* CHECK dout1_24 vdout1_24ck58 = 3.3 time = 590
* CHECK dout1_25 vdout1_25ck58 = 0 time = 590
* CHECK dout1_26 vdout1_26ck58 = 3.3 time = 590
* CHECK dout1_27 vdout1_27ck58 = 3.3 time = 590
* CHECK dout1_28 vdout1_28ck58 = 3.3 time = 590
* CHECK dout1_29 vdout1_29ck58 = 0 time = 590
* CHECK dout1_30 vdout1_30ck58 = 3.3 time = 590
* CHECK dout1_31 vdout1_31ck58 = 3.3 time = 590
* CHECK dout0_0 vdout0_0ck59 = 3.3 time = 600
* CHECK dout0_1 vdout0_1ck59 = 0 time = 600
* CHECK dout0_2 vdout0_2ck59 = 3.3 time = 600
* CHECK dout0_3 vdout0_3ck59 = 3.3 time = 600
* CHECK dout0_4 vdout0_4ck59 = 3.3 time = 600
* CHECK dout0_5 vdout0_5ck59 = 3.3 time = 600
* CHECK dout0_6 vdout0_6ck59 = 3.3 time = 600
* CHECK dout0_7 vdout0_7ck59 = 0 time = 600
* CHECK dout0_8 vdout0_8ck59 = 3.3 time = 600
* CHECK dout0_9 vdout0_9ck59 = 3.3 time = 600
* CHECK dout0_10 vdout0_10ck59 = 0 time = 600
* CHECK dout0_11 vdout0_11ck59 = 3.3 time = 600
* CHECK dout0_12 vdout0_12ck59 = 0 time = 600
* CHECK dout0_13 vdout0_13ck59 = 0 time = 600
* CHECK dout0_14 vdout0_14ck59 = 3.3 time = 600
* CHECK dout0_15 vdout0_15ck59 = 3.3 time = 600
* CHECK dout0_16 vdout0_16ck59 = 0 time = 600
* CHECK dout0_17 vdout0_17ck59 = 0 time = 600
* CHECK dout0_18 vdout0_18ck59 = 0 time = 600
* CHECK dout0_19 vdout0_19ck59 = 0 time = 600
* CHECK dout0_20 vdout0_20ck59 = 3.3 time = 600
* CHECK dout0_21 vdout0_21ck59 = 3.3 time = 600
* CHECK dout0_22 vdout0_22ck59 = 0 time = 600
* CHECK dout0_23 vdout0_23ck59 = 3.3 time = 600
* CHECK dout0_24 vdout0_24ck59 = 3.3 time = 600
* CHECK dout0_25 vdout0_25ck59 = 0 time = 600
* CHECK dout0_26 vdout0_26ck59 = 3.3 time = 600
* CHECK dout0_27 vdout0_27ck59 = 3.3 time = 600
* CHECK dout0_28 vdout0_28ck59 = 3.3 time = 600
* CHECK dout0_29 vdout0_29ck59 = 0 time = 600
* CHECK dout0_30 vdout0_30ck59 = 3.3 time = 600
* CHECK dout0_31 vdout0_31ck59 = 3.3 time = 600
* CHECK dout0_0 vdout0_0ck61 = 3.3 time = 620
* CHECK dout0_1 vdout0_1ck61 = 0 time = 620
* CHECK dout0_2 vdout0_2ck61 = 3.3 time = 620
* CHECK dout0_3 vdout0_3ck61 = 3.3 time = 620
* CHECK dout0_4 vdout0_4ck61 = 3.3 time = 620
* CHECK dout0_5 vdout0_5ck61 = 3.3 time = 620
* CHECK dout0_6 vdout0_6ck61 = 3.3 time = 620
* CHECK dout0_7 vdout0_7ck61 = 0 time = 620
* CHECK dout0_8 vdout0_8ck61 = 3.3 time = 620
* CHECK dout0_9 vdout0_9ck61 = 3.3 time = 620
* CHECK dout0_10 vdout0_10ck61 = 0 time = 620
* CHECK dout0_11 vdout0_11ck61 = 3.3 time = 620
* CHECK dout0_12 vdout0_12ck61 = 0 time = 620
* CHECK dout0_13 vdout0_13ck61 = 0 time = 620
* CHECK dout0_14 vdout0_14ck61 = 3.3 time = 620
* CHECK dout0_15 vdout0_15ck61 = 3.3 time = 620
* CHECK dout0_16 vdout0_16ck61 = 0 time = 620
* CHECK dout0_17 vdout0_17ck61 = 0 time = 620
* CHECK dout0_18 vdout0_18ck61 = 0 time = 620
* CHECK dout0_19 vdout0_19ck61 = 0 time = 620
* CHECK dout0_20 vdout0_20ck61 = 3.3 time = 620
* CHECK dout0_21 vdout0_21ck61 = 3.3 time = 620
* CHECK dout0_22 vdout0_22ck61 = 0 time = 620
* CHECK dout0_23 vdout0_23ck61 = 3.3 time = 620
* CHECK dout0_24 vdout0_24ck61 = 3.3 time = 620
* CHECK dout0_25 vdout0_25ck61 = 0 time = 620
* CHECK dout0_26 vdout0_26ck61 = 3.3 time = 620
* CHECK dout0_27 vdout0_27ck61 = 3.3 time = 620
* CHECK dout0_28 vdout0_28ck61 = 3.3 time = 620
* CHECK dout0_29 vdout0_29ck61 = 0 time = 620
* CHECK dout0_30 vdout0_30ck61 = 3.3 time = 620
* CHECK dout0_31 vdout0_31ck61 = 3.3 time = 620
* CHECK dout0_0 vdout0_0ck62 = 0 time = 630
* CHECK dout0_1 vdout0_1ck62 = 3.3 time = 630
* CHECK dout0_2 vdout0_2ck62 = 0 time = 630
* CHECK dout0_3 vdout0_3ck62 = 0 time = 630
* CHECK dout0_4 vdout0_4ck62 = 0 time = 630
* CHECK dout0_5 vdout0_5ck62 = 0 time = 630
* CHECK dout0_6 vdout0_6ck62 = 3.3 time = 630
* CHECK dout0_7 vdout0_7ck62 = 3.3 time = 630
* CHECK dout0_8 vdout0_8ck62 = 3.3 time = 630
* CHECK dout0_9 vdout0_9ck62 = 0 time = 630
* CHECK dout0_10 vdout0_10ck62 = 0 time = 630
* CHECK dout0_11 vdout0_11ck62 = 0 time = 630
* CHECK dout0_12 vdout0_12ck62 = 0 time = 630
* CHECK dout0_13 vdout0_13ck62 = 3.3 time = 630
* CHECK dout0_14 vdout0_14ck62 = 0 time = 630
* CHECK dout0_15 vdout0_15ck62 = 3.3 time = 630
* CHECK dout0_16 vdout0_16ck62 = 0 time = 630
* CHECK dout0_17 vdout0_17ck62 = 3.3 time = 630
* CHECK dout0_18 vdout0_18ck62 = 0 time = 630
* CHECK dout0_19 vdout0_19ck62 = 3.3 time = 630
* CHECK dout0_20 vdout0_20ck62 = 0 time = 630
* CHECK dout0_21 vdout0_21ck62 = 3.3 time = 630
* CHECK dout0_22 vdout0_22ck62 = 3.3 time = 630
* CHECK dout0_23 vdout0_23ck62 = 0 time = 630
* CHECK dout0_24 vdout0_24ck62 = 0 time = 630
* CHECK dout0_25 vdout0_25ck62 = 3.3 time = 630
* CHECK dout0_26 vdout0_26ck62 = 3.3 time = 630
* CHECK dout0_27 vdout0_27ck62 = 0 time = 630
* CHECK dout0_28 vdout0_28ck62 = 3.3 time = 630
* CHECK dout0_29 vdout0_29ck62 = 0 time = 630
* CHECK dout0_30 vdout0_30ck62 = 0 time = 630
* CHECK dout0_31 vdout0_31ck62 = 0 time = 630
* CHECK dout1_0 vdout1_0ck62 = 0 time = 630
* CHECK dout1_1 vdout1_1ck62 = 3.3 time = 630
* CHECK dout1_2 vdout1_2ck62 = 0 time = 630
* CHECK dout1_3 vdout1_3ck62 = 0 time = 630
* CHECK dout1_4 vdout1_4ck62 = 0 time = 630
* CHECK dout1_5 vdout1_5ck62 = 0 time = 630
* CHECK dout1_6 vdout1_6ck62 = 3.3 time = 630
* CHECK dout1_7 vdout1_7ck62 = 3.3 time = 630
* CHECK dout1_8 vdout1_8ck62 = 3.3 time = 630
* CHECK dout1_9 vdout1_9ck62 = 0 time = 630
* CHECK dout1_10 vdout1_10ck62 = 0 time = 630
* CHECK dout1_11 vdout1_11ck62 = 0 time = 630
* CHECK dout1_12 vdout1_12ck62 = 0 time = 630
* CHECK dout1_13 vdout1_13ck62 = 3.3 time = 630
* CHECK dout1_14 vdout1_14ck62 = 0 time = 630
* CHECK dout1_15 vdout1_15ck62 = 3.3 time = 630
* CHECK dout1_16 vdout1_16ck62 = 0 time = 630
* CHECK dout1_17 vdout1_17ck62 = 3.3 time = 630
* CHECK dout1_18 vdout1_18ck62 = 0 time = 630
* CHECK dout1_19 vdout1_19ck62 = 3.3 time = 630
* CHECK dout1_20 vdout1_20ck62 = 0 time = 630
* CHECK dout1_21 vdout1_21ck62 = 3.3 time = 630
* CHECK dout1_22 vdout1_22ck62 = 3.3 time = 630
* CHECK dout1_23 vdout1_23ck62 = 0 time = 630
* CHECK dout1_24 vdout1_24ck62 = 0 time = 630
* CHECK dout1_25 vdout1_25ck62 = 3.3 time = 630
* CHECK dout1_26 vdout1_26ck62 = 3.3 time = 630
* CHECK dout1_27 vdout1_27ck62 = 0 time = 630
* CHECK dout1_28 vdout1_28ck62 = 3.3 time = 630
* CHECK dout1_29 vdout1_29ck62 = 0 time = 630
* CHECK dout1_30 vdout1_30ck62 = 0 time = 630
* CHECK dout1_31 vdout1_31ck62 = 0 time = 630
* CHECK dout0_0 vdout0_0ck63 = 0 time = 640
* CHECK dout0_1 vdout0_1ck63 = 3.3 time = 640
* CHECK dout0_2 vdout0_2ck63 = 0 time = 640
* CHECK dout0_3 vdout0_3ck63 = 0 time = 640
* CHECK dout0_4 vdout0_4ck63 = 0 time = 640
* CHECK dout0_5 vdout0_5ck63 = 0 time = 640
* CHECK dout0_6 vdout0_6ck63 = 3.3 time = 640
* CHECK dout0_7 vdout0_7ck63 = 3.3 time = 640
* CHECK dout0_8 vdout0_8ck63 = 3.3 time = 640
* CHECK dout0_9 vdout0_9ck63 = 0 time = 640
* CHECK dout0_10 vdout0_10ck63 = 0 time = 640
* CHECK dout0_11 vdout0_11ck63 = 0 time = 640
* CHECK dout0_12 vdout0_12ck63 = 0 time = 640
* CHECK dout0_13 vdout0_13ck63 = 3.3 time = 640
* CHECK dout0_14 vdout0_14ck63 = 0 time = 640
* CHECK dout0_15 vdout0_15ck63 = 3.3 time = 640
* CHECK dout0_16 vdout0_16ck63 = 0 time = 640
* CHECK dout0_17 vdout0_17ck63 = 3.3 time = 640
* CHECK dout0_18 vdout0_18ck63 = 0 time = 640
* CHECK dout0_19 vdout0_19ck63 = 3.3 time = 640
* CHECK dout0_20 vdout0_20ck63 = 0 time = 640
* CHECK dout0_21 vdout0_21ck63 = 3.3 time = 640
* CHECK dout0_22 vdout0_22ck63 = 3.3 time = 640
* CHECK dout0_23 vdout0_23ck63 = 0 time = 640
* CHECK dout0_24 vdout0_24ck63 = 0 time = 640
* CHECK dout0_25 vdout0_25ck63 = 3.3 time = 640
* CHECK dout0_26 vdout0_26ck63 = 3.3 time = 640
* CHECK dout0_27 vdout0_27ck63 = 0 time = 640
* CHECK dout0_28 vdout0_28ck63 = 3.3 time = 640
* CHECK dout0_29 vdout0_29ck63 = 0 time = 640
* CHECK dout0_30 vdout0_30ck63 = 0 time = 640
* CHECK dout0_31 vdout0_31ck63 = 0 time = 640
* CHECK dout0_0 vdout0_0ck64 = 3.3 time = 650
* CHECK dout0_1 vdout0_1ck64 = 0 time = 650
* CHECK dout0_2 vdout0_2ck64 = 0 time = 650
* CHECK dout0_3 vdout0_3ck64 = 0 time = 650
* CHECK dout0_4 vdout0_4ck64 = 0 time = 650
* CHECK dout0_5 vdout0_5ck64 = 3.3 time = 650
* CHECK dout0_6 vdout0_6ck64 = 0 time = 650
* CHECK dout0_7 vdout0_7ck64 = 3.3 time = 650
* CHECK dout0_8 vdout0_8ck64 = 0 time = 650
* CHECK dout0_9 vdout0_9ck64 = 0 time = 650
* CHECK dout0_10 vdout0_10ck64 = 0 time = 650
* CHECK dout0_11 vdout0_11ck64 = 0 time = 650
* CHECK dout0_12 vdout0_12ck64 = 0 time = 650
* CHECK dout0_13 vdout0_13ck64 = 0 time = 650
* CHECK dout0_14 vdout0_14ck64 = 3.3 time = 650
* CHECK dout0_15 vdout0_15ck64 = 3.3 time = 650
* CHECK dout0_16 vdout0_16ck64 = 0 time = 650
* CHECK dout0_17 vdout0_17ck64 = 0 time = 650
* CHECK dout0_18 vdout0_18ck64 = 0 time = 650
* CHECK dout0_19 vdout0_19ck64 = 3.3 time = 650
* CHECK dout0_20 vdout0_20ck64 = 0 time = 650
* CHECK dout0_21 vdout0_21ck64 = 3.3 time = 650
* CHECK dout0_22 vdout0_22ck64 = 0 time = 650
* CHECK dout0_23 vdout0_23ck64 = 0 time = 650
* CHECK dout0_24 vdout0_24ck64 = 0 time = 650
* CHECK dout0_25 vdout0_25ck64 = 3.3 time = 650
* CHECK dout0_26 vdout0_26ck64 = 3.3 time = 650
* CHECK dout0_27 vdout0_27ck64 = 3.3 time = 650
* CHECK dout0_28 vdout0_28ck64 = 0 time = 650
* CHECK dout0_29 vdout0_29ck64 = 0 time = 650
* CHECK dout0_30 vdout0_30ck64 = 0 time = 650
* CHECK dout0_31 vdout0_31ck64 = 3.3 time = 650
* CHECK dout1_0 vdout1_0ck64 = 3.3 time = 650
* CHECK dout1_1 vdout1_1ck64 = 0 time = 650
* CHECK dout1_2 vdout1_2ck64 = 3.3 time = 650
* CHECK dout1_3 vdout1_3ck64 = 3.3 time = 650
* CHECK dout1_4 vdout1_4ck64 = 3.3 time = 650
* CHECK dout1_5 vdout1_5ck64 = 3.3 time = 650
* CHECK dout1_6 vdout1_6ck64 = 3.3 time = 650
* CHECK dout1_7 vdout1_7ck64 = 0 time = 650
* CHECK dout1_8 vdout1_8ck64 = 3.3 time = 650
* CHECK dout1_9 vdout1_9ck64 = 3.3 time = 650
* CHECK dout1_10 vdout1_10ck64 = 0 time = 650
* CHECK dout1_11 vdout1_11ck64 = 3.3 time = 650
* CHECK dout1_12 vdout1_12ck64 = 0 time = 650
* CHECK dout1_13 vdout1_13ck64 = 0 time = 650
* CHECK dout1_14 vdout1_14ck64 = 3.3 time = 650
* CHECK dout1_15 vdout1_15ck64 = 3.3 time = 650
* CHECK dout1_16 vdout1_16ck64 = 0 time = 650
* CHECK dout1_17 vdout1_17ck64 = 0 time = 650
* CHECK dout1_18 vdout1_18ck64 = 0 time = 650
* CHECK dout1_19 vdout1_19ck64 = 0 time = 650
* CHECK dout1_20 vdout1_20ck64 = 3.3 time = 650
* CHECK dout1_21 vdout1_21ck64 = 3.3 time = 650
* CHECK dout1_22 vdout1_22ck64 = 0 time = 650
* CHECK dout1_23 vdout1_23ck64 = 3.3 time = 650
* CHECK dout1_24 vdout1_24ck64 = 3.3 time = 650
* CHECK dout1_25 vdout1_25ck64 = 0 time = 650
* CHECK dout1_26 vdout1_26ck64 = 3.3 time = 650
* CHECK dout1_27 vdout1_27ck64 = 3.3 time = 650
* CHECK dout1_28 vdout1_28ck64 = 3.3 time = 650
* CHECK dout1_29 vdout1_29ck64 = 0 time = 650
* CHECK dout1_30 vdout1_30ck64 = 3.3 time = 650
* CHECK dout1_31 vdout1_31ck64 = 3.3 time = 650
* CHECK dout0_0 vdout0_0ck66 = 3.3 time = 670
* CHECK dout0_1 vdout0_1ck66 = 0 time = 670
* CHECK dout0_2 vdout0_2ck66 = 3.3 time = 670
* CHECK dout0_3 vdout0_3ck66 = 3.3 time = 670
* CHECK dout0_4 vdout0_4ck66 = 3.3 time = 670
* CHECK dout0_5 vdout0_5ck66 = 3.3 time = 670
* CHECK dout0_6 vdout0_6ck66 = 3.3 time = 670
* CHECK dout0_7 vdout0_7ck66 = 0 time = 670
* CHECK dout0_8 vdout0_8ck66 = 3.3 time = 670
* CHECK dout0_9 vdout0_9ck66 = 3.3 time = 670
* CHECK dout0_10 vdout0_10ck66 = 0 time = 670
* CHECK dout0_11 vdout0_11ck66 = 3.3 time = 670
* CHECK dout0_12 vdout0_12ck66 = 0 time = 670
* CHECK dout0_13 vdout0_13ck66 = 0 time = 670
* CHECK dout0_14 vdout0_14ck66 = 3.3 time = 670
* CHECK dout0_15 vdout0_15ck66 = 3.3 time = 670
* CHECK dout0_16 vdout0_16ck66 = 0 time = 670
* CHECK dout0_17 vdout0_17ck66 = 0 time = 670
* CHECK dout0_18 vdout0_18ck66 = 0 time = 670
* CHECK dout0_19 vdout0_19ck66 = 0 time = 670
* CHECK dout0_20 vdout0_20ck66 = 3.3 time = 670
* CHECK dout0_21 vdout0_21ck66 = 3.3 time = 670
* CHECK dout0_22 vdout0_22ck66 = 0 time = 670
* CHECK dout0_23 vdout0_23ck66 = 3.3 time = 670
* CHECK dout0_24 vdout0_24ck66 = 3.3 time = 670
* CHECK dout0_25 vdout0_25ck66 = 0 time = 670
* CHECK dout0_26 vdout0_26ck66 = 3.3 time = 670
* CHECK dout0_27 vdout0_27ck66 = 3.3 time = 670
* CHECK dout0_28 vdout0_28ck66 = 3.3 time = 670
* CHECK dout0_29 vdout0_29ck66 = 0 time = 670
* CHECK dout0_30 vdout0_30ck66 = 3.3 time = 670
* CHECK dout0_31 vdout0_31ck66 = 3.3 time = 670
* CHECK dout1_0 vdout1_0ck66 = 3.3 time = 670
* CHECK dout1_1 vdout1_1ck66 = 0 time = 670
* CHECK dout1_2 vdout1_2ck66 = 3.3 time = 670
* CHECK dout1_3 vdout1_3ck66 = 3.3 time = 670
* CHECK dout1_4 vdout1_4ck66 = 3.3 time = 670
* CHECK dout1_5 vdout1_5ck66 = 3.3 time = 670
* CHECK dout1_6 vdout1_6ck66 = 3.3 time = 670
* CHECK dout1_7 vdout1_7ck66 = 0 time = 670
* CHECK dout1_8 vdout1_8ck66 = 3.3 time = 670
* CHECK dout1_9 vdout1_9ck66 = 3.3 time = 670
* CHECK dout1_10 vdout1_10ck66 = 0 time = 670
* CHECK dout1_11 vdout1_11ck66 = 3.3 time = 670
* CHECK dout1_12 vdout1_12ck66 = 0 time = 670
* CHECK dout1_13 vdout1_13ck66 = 0 time = 670
* CHECK dout1_14 vdout1_14ck66 = 3.3 time = 670
* CHECK dout1_15 vdout1_15ck66 = 3.3 time = 670
* CHECK dout1_16 vdout1_16ck66 = 0 time = 670
* CHECK dout1_17 vdout1_17ck66 = 0 time = 670
* CHECK dout1_18 vdout1_18ck66 = 0 time = 670
* CHECK dout1_19 vdout1_19ck66 = 0 time = 670
* CHECK dout1_20 vdout1_20ck66 = 3.3 time = 670
* CHECK dout1_21 vdout1_21ck66 = 3.3 time = 670
* CHECK dout1_22 vdout1_22ck66 = 0 time = 670
* CHECK dout1_23 vdout1_23ck66 = 3.3 time = 670
* CHECK dout1_24 vdout1_24ck66 = 3.3 time = 670
* CHECK dout1_25 vdout1_25ck66 = 0 time = 670
* CHECK dout1_26 vdout1_26ck66 = 3.3 time = 670
* CHECK dout1_27 vdout1_27ck66 = 3.3 time = 670
* CHECK dout1_28 vdout1_28ck66 = 3.3 time = 670
* CHECK dout1_29 vdout1_29ck66 = 0 time = 670
* CHECK dout1_30 vdout1_30ck66 = 3.3 time = 670
* CHECK dout1_31 vdout1_31ck66 = 3.3 time = 670
* CHECK dout0_0 vdout0_0ck68 = 3.3 time = 690
* CHECK dout0_1 vdout0_1ck68 = 0 time = 690
* CHECK dout0_2 vdout0_2ck68 = 3.3 time = 690
* CHECK dout0_3 vdout0_3ck68 = 0 time = 690
* CHECK dout0_4 vdout0_4ck68 = 3.3 time = 690
* CHECK dout0_5 vdout0_5ck68 = 3.3 time = 690
* CHECK dout0_6 vdout0_6ck68 = 3.3 time = 690
* CHECK dout0_7 vdout0_7ck68 = 0 time = 690
* CHECK dout0_8 vdout0_8ck68 = 0 time = 690
* CHECK dout0_9 vdout0_9ck68 = 3.3 time = 690
* CHECK dout0_10 vdout0_10ck68 = 0 time = 690
* CHECK dout0_11 vdout0_11ck68 = 0 time = 690
* CHECK dout0_12 vdout0_12ck68 = 3.3 time = 690
* CHECK dout0_13 vdout0_13ck68 = 0 time = 690
* CHECK dout0_14 vdout0_14ck68 = 0 time = 690
* CHECK dout0_15 vdout0_15ck68 = 3.3 time = 690
* CHECK dout0_16 vdout0_16ck68 = 0 time = 690
* CHECK dout0_17 vdout0_17ck68 = 0 time = 690
* CHECK dout0_18 vdout0_18ck68 = 3.3 time = 690
* CHECK dout0_19 vdout0_19ck68 = 0 time = 690
* CHECK dout0_20 vdout0_20ck68 = 3.3 time = 690
* CHECK dout0_21 vdout0_21ck68 = 0 time = 690
* CHECK dout0_22 vdout0_22ck68 = 3.3 time = 690
* CHECK dout0_23 vdout0_23ck68 = 3.3 time = 690
* CHECK dout0_24 vdout0_24ck68 = 0 time = 690
* CHECK dout0_25 vdout0_25ck68 = 3.3 time = 690
* CHECK dout0_26 vdout0_26ck68 = 0 time = 690
* CHECK dout0_27 vdout0_27ck68 = 0 time = 690
* CHECK dout0_28 vdout0_28ck68 = 3.3 time = 690
* CHECK dout0_29 vdout0_29ck68 = 3.3 time = 690
* CHECK dout0_30 vdout0_30ck68 = 0 time = 690
* CHECK dout0_31 vdout0_31ck68 = 3.3 time = 690
* CHECK dout1_0 vdout1_0ck68 = 3.3 time = 690
* CHECK dout1_1 vdout1_1ck68 = 0 time = 690
* CHECK dout1_2 vdout1_2ck68 = 3.3 time = 690
* CHECK dout1_3 vdout1_3ck68 = 0 time = 690
* CHECK dout1_4 vdout1_4ck68 = 3.3 time = 690
* CHECK dout1_5 vdout1_5ck68 = 3.3 time = 690
* CHECK dout1_6 vdout1_6ck68 = 3.3 time = 690
* CHECK dout1_7 vdout1_7ck68 = 0 time = 690
* CHECK dout1_8 vdout1_8ck68 = 0 time = 690
* CHECK dout1_9 vdout1_9ck68 = 3.3 time = 690
* CHECK dout1_10 vdout1_10ck68 = 0 time = 690
* CHECK dout1_11 vdout1_11ck68 = 0 time = 690
* CHECK dout1_12 vdout1_12ck68 = 3.3 time = 690
* CHECK dout1_13 vdout1_13ck68 = 0 time = 690
* CHECK dout1_14 vdout1_14ck68 = 0 time = 690
* CHECK dout1_15 vdout1_15ck68 = 3.3 time = 690
* CHECK dout1_16 vdout1_16ck68 = 0 time = 690
* CHECK dout1_17 vdout1_17ck68 = 0 time = 690
* CHECK dout1_18 vdout1_18ck68 = 3.3 time = 690
* CHECK dout1_19 vdout1_19ck68 = 0 time = 690
* CHECK dout1_20 vdout1_20ck68 = 3.3 time = 690
* CHECK dout1_21 vdout1_21ck68 = 0 time = 690
* CHECK dout1_22 vdout1_22ck68 = 3.3 time = 690
* CHECK dout1_23 vdout1_23ck68 = 3.3 time = 690
* CHECK dout1_24 vdout1_24ck68 = 0 time = 690
* CHECK dout1_25 vdout1_25ck68 = 3.3 time = 690
* CHECK dout1_26 vdout1_26ck68 = 0 time = 690
* CHECK dout1_27 vdout1_27ck68 = 0 time = 690
* CHECK dout1_28 vdout1_28ck68 = 3.3 time = 690
* CHECK dout1_29 vdout1_29ck68 = 3.3 time = 690
* CHECK dout1_30 vdout1_30ck68 = 0 time = 690
* CHECK dout1_31 vdout1_31ck68 = 3.3 time = 690
* CHECK dout0_0 vdout0_0ck69 = 3.3 time = 700
* CHECK dout0_1 vdout0_1ck69 = 0 time = 700
* CHECK dout0_2 vdout0_2ck69 = 3.3 time = 700
* CHECK dout0_3 vdout0_3ck69 = 3.3 time = 700
* CHECK dout0_4 vdout0_4ck69 = 3.3 time = 700
* CHECK dout0_5 vdout0_5ck69 = 3.3 time = 700
* CHECK dout0_6 vdout0_6ck69 = 3.3 time = 700
* CHECK dout0_7 vdout0_7ck69 = 0 time = 700
* CHECK dout0_8 vdout0_8ck69 = 3.3 time = 700
* CHECK dout0_9 vdout0_9ck69 = 3.3 time = 700
* CHECK dout0_10 vdout0_10ck69 = 0 time = 700
* CHECK dout0_11 vdout0_11ck69 = 3.3 time = 700
* CHECK dout0_12 vdout0_12ck69 = 0 time = 700
* CHECK dout0_13 vdout0_13ck69 = 0 time = 700
* CHECK dout0_14 vdout0_14ck69 = 3.3 time = 700
* CHECK dout0_15 vdout0_15ck69 = 3.3 time = 700
* CHECK dout0_16 vdout0_16ck69 = 0 time = 700
* CHECK dout0_17 vdout0_17ck69 = 0 time = 700
* CHECK dout0_18 vdout0_18ck69 = 0 time = 700
* CHECK dout0_19 vdout0_19ck69 = 0 time = 700
* CHECK dout0_20 vdout0_20ck69 = 3.3 time = 700
* CHECK dout0_21 vdout0_21ck69 = 3.3 time = 700
* CHECK dout0_22 vdout0_22ck69 = 0 time = 700
* CHECK dout0_23 vdout0_23ck69 = 3.3 time = 700
* CHECK dout0_24 vdout0_24ck69 = 3.3 time = 700
* CHECK dout0_25 vdout0_25ck69 = 0 time = 700
* CHECK dout0_26 vdout0_26ck69 = 3.3 time = 700
* CHECK dout0_27 vdout0_27ck69 = 3.3 time = 700
* CHECK dout0_28 vdout0_28ck69 = 3.3 time = 700
* CHECK dout0_29 vdout0_29ck69 = 0 time = 700
* CHECK dout0_30 vdout0_30ck69 = 3.3 time = 700
* CHECK dout0_31 vdout0_31ck69 = 3.3 time = 700
* CHECK dout1_0 vdout1_0ck70 = 0 time = 710
* CHECK dout1_1 vdout1_1ck70 = 0 time = 710
* CHECK dout1_2 vdout1_2ck70 = 3.3 time = 710
* CHECK dout1_3 vdout1_3ck70 = 0 time = 710
* CHECK dout1_4 vdout1_4ck70 = 3.3 time = 710
* CHECK dout1_5 vdout1_5ck70 = 3.3 time = 710
* CHECK dout1_6 vdout1_6ck70 = 0 time = 710
* CHECK dout1_7 vdout1_7ck70 = 0 time = 710
* CHECK dout1_8 vdout1_8ck70 = 3.3 time = 710
* CHECK dout1_9 vdout1_9ck70 = 3.3 time = 710
* CHECK dout1_10 vdout1_10ck70 = 3.3 time = 710
* CHECK dout1_11 vdout1_11ck70 = 0 time = 710
* CHECK dout1_12 vdout1_12ck70 = 3.3 time = 710
* CHECK dout1_13 vdout1_13ck70 = 0 time = 710
* CHECK dout1_14 vdout1_14ck70 = 3.3 time = 710
* CHECK dout1_15 vdout1_15ck70 = 0 time = 710
* CHECK dout1_16 vdout1_16ck70 = 0 time = 710
* CHECK dout1_17 vdout1_17ck70 = 0 time = 710
* CHECK dout1_18 vdout1_18ck70 = 3.3 time = 710
* CHECK dout1_19 vdout1_19ck70 = 0 time = 710
* CHECK dout1_20 vdout1_20ck70 = 3.3 time = 710
* CHECK dout1_21 vdout1_21ck70 = 3.3 time = 710
* CHECK dout1_22 vdout1_22ck70 = 0 time = 710
* CHECK dout1_23 vdout1_23ck70 = 3.3 time = 710
* CHECK dout1_24 vdout1_24ck70 = 3.3 time = 710
* CHECK dout1_25 vdout1_25ck70 = 0 time = 710
* CHECK dout1_26 vdout1_26ck70 = 3.3 time = 710
* CHECK dout1_27 vdout1_27ck70 = 0 time = 710
* CHECK dout1_28 vdout1_28ck70 = 3.3 time = 710
* CHECK dout1_29 vdout1_29ck70 = 0 time = 710
* CHECK dout1_30 vdout1_30ck70 = 0 time = 710
* CHECK dout1_31 vdout1_31ck70 = 3.3 time = 710
* CHECK dout1_0 vdout1_0ck71 = 3.3 time = 720
* CHECK dout1_1 vdout1_1ck71 = 0 time = 720
* CHECK dout1_2 vdout1_2ck71 = 3.3 time = 720
* CHECK dout1_3 vdout1_3ck71 = 3.3 time = 720
* CHECK dout1_4 vdout1_4ck71 = 3.3 time = 720
* CHECK dout1_5 vdout1_5ck71 = 3.3 time = 720
* CHECK dout1_6 vdout1_6ck71 = 3.3 time = 720
* CHECK dout1_7 vdout1_7ck71 = 0 time = 720
* CHECK dout1_8 vdout1_8ck71 = 3.3 time = 720
* CHECK dout1_9 vdout1_9ck71 = 3.3 time = 720
* CHECK dout1_10 vdout1_10ck71 = 0 time = 720
* CHECK dout1_11 vdout1_11ck71 = 3.3 time = 720
* CHECK dout1_12 vdout1_12ck71 = 0 time = 720
* CHECK dout1_13 vdout1_13ck71 = 0 time = 720
* CHECK dout1_14 vdout1_14ck71 = 3.3 time = 720
* CHECK dout1_15 vdout1_15ck71 = 3.3 time = 720
* CHECK dout1_16 vdout1_16ck71 = 0 time = 720
* CHECK dout1_17 vdout1_17ck71 = 0 time = 720
* CHECK dout1_18 vdout1_18ck71 = 0 time = 720
* CHECK dout1_19 vdout1_19ck71 = 0 time = 720
* CHECK dout1_20 vdout1_20ck71 = 3.3 time = 720
* CHECK dout1_21 vdout1_21ck71 = 3.3 time = 720
* CHECK dout1_22 vdout1_22ck71 = 0 time = 720
* CHECK dout1_23 vdout1_23ck71 = 3.3 time = 720
* CHECK dout1_24 vdout1_24ck71 = 3.3 time = 720
* CHECK dout1_25 vdout1_25ck71 = 0 time = 720
* CHECK dout1_26 vdout1_26ck71 = 3.3 time = 720
* CHECK dout1_27 vdout1_27ck71 = 3.3 time = 720
* CHECK dout1_28 vdout1_28ck71 = 3.3 time = 720
* CHECK dout1_29 vdout1_29ck71 = 0 time = 720
* CHECK dout1_30 vdout1_30ck71 = 3.3 time = 720
* CHECK dout1_31 vdout1_31ck71 = 3.3 time = 720
* CHECK dout0_0 vdout0_0ck72 = 0 time = 730
* CHECK dout0_1 vdout0_1ck72 = 0 time = 730
* CHECK dout0_2 vdout0_2ck72 = 3.3 time = 730
* CHECK dout0_3 vdout0_3ck72 = 0 time = 730
* CHECK dout0_4 vdout0_4ck72 = 3.3 time = 730
* CHECK dout0_5 vdout0_5ck72 = 3.3 time = 730
* CHECK dout0_6 vdout0_6ck72 = 0 time = 730
* CHECK dout0_7 vdout0_7ck72 = 0 time = 730
* CHECK dout0_8 vdout0_8ck72 = 3.3 time = 730
* CHECK dout0_9 vdout0_9ck72 = 3.3 time = 730
* CHECK dout0_10 vdout0_10ck72 = 3.3 time = 730
* CHECK dout0_11 vdout0_11ck72 = 0 time = 730
* CHECK dout0_12 vdout0_12ck72 = 3.3 time = 730
* CHECK dout0_13 vdout0_13ck72 = 0 time = 730
* CHECK dout0_14 vdout0_14ck72 = 3.3 time = 730
* CHECK dout0_15 vdout0_15ck72 = 0 time = 730
* CHECK dout0_16 vdout0_16ck72 = 0 time = 730
* CHECK dout0_17 vdout0_17ck72 = 0 time = 730
* CHECK dout0_18 vdout0_18ck72 = 3.3 time = 730
* CHECK dout0_19 vdout0_19ck72 = 0 time = 730
* CHECK dout0_20 vdout0_20ck72 = 3.3 time = 730
* CHECK dout0_21 vdout0_21ck72 = 3.3 time = 730
* CHECK dout0_22 vdout0_22ck72 = 0 time = 730
* CHECK dout0_23 vdout0_23ck72 = 3.3 time = 730
* CHECK dout0_24 vdout0_24ck72 = 3.3 time = 730
* CHECK dout0_25 vdout0_25ck72 = 0 time = 730
* CHECK dout0_26 vdout0_26ck72 = 3.3 time = 730
* CHECK dout0_27 vdout0_27ck72 = 0 time = 730
* CHECK dout0_28 vdout0_28ck72 = 3.3 time = 730
* CHECK dout0_29 vdout0_29ck72 = 0 time = 730
* CHECK dout0_30 vdout0_30ck72 = 0 time = 730
* CHECK dout0_31 vdout0_31ck72 = 3.3 time = 730
* CHECK dout1_0 vdout1_0ck72 = 0 time = 730
* CHECK dout1_1 vdout1_1ck72 = 0 time = 730
* CHECK dout1_2 vdout1_2ck72 = 3.3 time = 730
* CHECK dout1_3 vdout1_3ck72 = 0 time = 730
* CHECK dout1_4 vdout1_4ck72 = 3.3 time = 730
* CHECK dout1_5 vdout1_5ck72 = 3.3 time = 730
* CHECK dout1_6 vdout1_6ck72 = 0 time = 730
* CHECK dout1_7 vdout1_7ck72 = 0 time = 730
* CHECK dout1_8 vdout1_8ck72 = 3.3 time = 730
* CHECK dout1_9 vdout1_9ck72 = 3.3 time = 730
* CHECK dout1_10 vdout1_10ck72 = 3.3 time = 730
* CHECK dout1_11 vdout1_11ck72 = 0 time = 730
* CHECK dout1_12 vdout1_12ck72 = 3.3 time = 730
* CHECK dout1_13 vdout1_13ck72 = 0 time = 730
* CHECK dout1_14 vdout1_14ck72 = 3.3 time = 730
* CHECK dout1_15 vdout1_15ck72 = 0 time = 730
* CHECK dout1_16 vdout1_16ck72 = 0 time = 730
* CHECK dout1_17 vdout1_17ck72 = 0 time = 730
* CHECK dout1_18 vdout1_18ck72 = 3.3 time = 730
* CHECK dout1_19 vdout1_19ck72 = 0 time = 730
* CHECK dout1_20 vdout1_20ck72 = 3.3 time = 730
* CHECK dout1_21 vdout1_21ck72 = 3.3 time = 730
* CHECK dout1_22 vdout1_22ck72 = 0 time = 730
* CHECK dout1_23 vdout1_23ck72 = 3.3 time = 730
* CHECK dout1_24 vdout1_24ck72 = 3.3 time = 730
* CHECK dout1_25 vdout1_25ck72 = 0 time = 730
* CHECK dout1_26 vdout1_26ck72 = 3.3 time = 730
* CHECK dout1_27 vdout1_27ck72 = 0 time = 730
* CHECK dout1_28 vdout1_28ck72 = 3.3 time = 730
* CHECK dout1_29 vdout1_29ck72 = 0 time = 730
* CHECK dout1_30 vdout1_30ck72 = 0 time = 730
* CHECK dout1_31 vdout1_31ck72 = 3.3 time = 730
* CHECK dout1_0 vdout1_0ck73 = 3.3 time = 740
* CHECK dout1_1 vdout1_1ck73 = 0 time = 740
* CHECK dout1_2 vdout1_2ck73 = 3.3 time = 740
* CHECK dout1_3 vdout1_3ck73 = 3.3 time = 740
* CHECK dout1_4 vdout1_4ck73 = 3.3 time = 740
* CHECK dout1_5 vdout1_5ck73 = 3.3 time = 740
* CHECK dout1_6 vdout1_6ck73 = 3.3 time = 740
* CHECK dout1_7 vdout1_7ck73 = 0 time = 740
* CHECK dout1_8 vdout1_8ck73 = 3.3 time = 740
* CHECK dout1_9 vdout1_9ck73 = 3.3 time = 740
* CHECK dout1_10 vdout1_10ck73 = 0 time = 740
* CHECK dout1_11 vdout1_11ck73 = 3.3 time = 740
* CHECK dout1_12 vdout1_12ck73 = 0 time = 740
* CHECK dout1_13 vdout1_13ck73 = 0 time = 740
* CHECK dout1_14 vdout1_14ck73 = 3.3 time = 740
* CHECK dout1_15 vdout1_15ck73 = 3.3 time = 740
* CHECK dout1_16 vdout1_16ck73 = 0 time = 740
* CHECK dout1_17 vdout1_17ck73 = 0 time = 740
* CHECK dout1_18 vdout1_18ck73 = 0 time = 740
* CHECK dout1_19 vdout1_19ck73 = 0 time = 740
* CHECK dout1_20 vdout1_20ck73 = 3.3 time = 740
* CHECK dout1_21 vdout1_21ck73 = 3.3 time = 740
* CHECK dout1_22 vdout1_22ck73 = 0 time = 740
* CHECK dout1_23 vdout1_23ck73 = 3.3 time = 740
* CHECK dout1_24 vdout1_24ck73 = 3.3 time = 740
* CHECK dout1_25 vdout1_25ck73 = 0 time = 740
* CHECK dout1_26 vdout1_26ck73 = 3.3 time = 740
* CHECK dout1_27 vdout1_27ck73 = 3.3 time = 740
* CHECK dout1_28 vdout1_28ck73 = 3.3 time = 740
* CHECK dout1_29 vdout1_29ck73 = 0 time = 740
* CHECK dout1_30 vdout1_30ck73 = 3.3 time = 740
* CHECK dout1_31 vdout1_31ck73 = 3.3 time = 740
* CHECK dout0_0 vdout0_0ck76 = 0 time = 770
* CHECK dout0_1 vdout0_1ck76 = 0 time = 770
* CHECK dout0_2 vdout0_2ck76 = 3.3 time = 770
* CHECK dout0_3 vdout0_3ck76 = 0 time = 770
* CHECK dout0_4 vdout0_4ck76 = 0 time = 770
* CHECK dout0_5 vdout0_5ck76 = 0 time = 770
* CHECK dout0_6 vdout0_6ck76 = 3.3 time = 770
* CHECK dout0_7 vdout0_7ck76 = 0 time = 770
* CHECK dout0_8 vdout0_8ck76 = 3.3 time = 770
* CHECK dout0_9 vdout0_9ck76 = 3.3 time = 770
* CHECK dout0_10 vdout0_10ck76 = 3.3 time = 770
* CHECK dout0_11 vdout0_11ck76 = 0 time = 770
* CHECK dout0_12 vdout0_12ck76 = 3.3 time = 770
* CHECK dout0_13 vdout0_13ck76 = 0 time = 770
* CHECK dout0_14 vdout0_14ck76 = 3.3 time = 770
* CHECK dout0_15 vdout0_15ck76 = 0 time = 770
* CHECK dout0_16 vdout0_16ck76 = 3.3 time = 770
* CHECK dout0_17 vdout0_17ck76 = 3.3 time = 770
* CHECK dout0_18 vdout0_18ck76 = 0 time = 770
* CHECK dout0_19 vdout0_19ck76 = 0 time = 770
* CHECK dout0_20 vdout0_20ck76 = 3.3 time = 770
* CHECK dout0_21 vdout0_21ck76 = 0 time = 770
* CHECK dout0_22 vdout0_22ck76 = 3.3 time = 770
* CHECK dout0_23 vdout0_23ck76 = 0 time = 770
* CHECK dout0_24 vdout0_24ck76 = 0 time = 770
* CHECK dout0_25 vdout0_25ck76 = 3.3 time = 770
* CHECK dout0_26 vdout0_26ck76 = 3.3 time = 770
* CHECK dout0_27 vdout0_27ck76 = 3.3 time = 770
* CHECK dout0_28 vdout0_28ck76 = 3.3 time = 770
* CHECK dout0_29 vdout0_29ck76 = 0 time = 770
* CHECK dout0_30 vdout0_30ck76 = 3.3 time = 770
* CHECK dout0_31 vdout0_31ck76 = 0 time = 770
* CHECK dout0_0 vdout0_0ck77 = 0 time = 780
* CHECK dout0_1 vdout0_1ck77 = 0 time = 780
* CHECK dout0_2 vdout0_2ck77 = 3.3 time = 780
* CHECK dout0_3 vdout0_3ck77 = 3.3 time = 780
* CHECK dout0_4 vdout0_4ck77 = 0 time = 780
* CHECK dout0_5 vdout0_5ck77 = 0 time = 780
* CHECK dout0_6 vdout0_6ck77 = 0 time = 780
* CHECK dout0_7 vdout0_7ck77 = 3.3 time = 780
* CHECK dout0_8 vdout0_8ck77 = 0 time = 780
* CHECK dout0_9 vdout0_9ck77 = 0 time = 780
* CHECK dout0_10 vdout0_10ck77 = 0 time = 780
* CHECK dout0_11 vdout0_11ck77 = 0 time = 780
* CHECK dout0_12 vdout0_12ck77 = 0 time = 780
* CHECK dout0_13 vdout0_13ck77 = 0 time = 780
* CHECK dout0_14 vdout0_14ck77 = 0 time = 780
* CHECK dout0_15 vdout0_15ck77 = 0 time = 780
* CHECK dout0_16 vdout0_16ck77 = 3.3 time = 780
* CHECK dout0_17 vdout0_17ck77 = 0 time = 780
* CHECK dout0_18 vdout0_18ck77 = 3.3 time = 780
* CHECK dout0_19 vdout0_19ck77 = 3.3 time = 780
* CHECK dout0_20 vdout0_20ck77 = 3.3 time = 780
* CHECK dout0_21 vdout0_21ck77 = 3.3 time = 780
* CHECK dout0_22 vdout0_22ck77 = 3.3 time = 780
* CHECK dout0_23 vdout0_23ck77 = 3.3 time = 780
* CHECK dout0_24 vdout0_24ck77 = 0 time = 780
* CHECK dout0_25 vdout0_25ck77 = 3.3 time = 780
* CHECK dout0_26 vdout0_26ck77 = 0 time = 780
* CHECK dout0_27 vdout0_27ck77 = 0 time = 780
* CHECK dout0_28 vdout0_28ck77 = 0 time = 780
* CHECK dout0_29 vdout0_29ck77 = 3.3 time = 780
* CHECK dout0_30 vdout0_30ck77 = 3.3 time = 780
* CHECK dout0_31 vdout0_31ck77 = 3.3 time = 780
* CHECK dout0_0 vdout0_0ck78 = 3.3 time = 790
* CHECK dout0_1 vdout0_1ck78 = 3.3 time = 790
* CHECK dout0_2 vdout0_2ck78 = 0 time = 790
* CHECK dout0_3 vdout0_3ck78 = 3.3 time = 790
* CHECK dout0_4 vdout0_4ck78 = 0 time = 790
* CHECK dout0_5 vdout0_5ck78 = 0 time = 790
* CHECK dout0_6 vdout0_6ck78 = 3.3 time = 790
* CHECK dout0_7 vdout0_7ck78 = 3.3 time = 790
* CHECK dout0_8 vdout0_8ck78 = 0 time = 790
* CHECK dout0_9 vdout0_9ck78 = 0 time = 790
* CHECK dout0_10 vdout0_10ck78 = 3.3 time = 790
* CHECK dout0_11 vdout0_11ck78 = 0 time = 790
* CHECK dout0_12 vdout0_12ck78 = 0 time = 790
* CHECK dout0_13 vdout0_13ck78 = 3.3 time = 790
* CHECK dout0_14 vdout0_14ck78 = 3.3 time = 790
* CHECK dout0_15 vdout0_15ck78 = 0 time = 790
* CHECK dout0_16 vdout0_16ck78 = 3.3 time = 790
* CHECK dout0_17 vdout0_17ck78 = 0 time = 790
* CHECK dout0_18 vdout0_18ck78 = 3.3 time = 790
* CHECK dout0_19 vdout0_19ck78 = 3.3 time = 790
* CHECK dout0_20 vdout0_20ck78 = 3.3 time = 790
* CHECK dout0_21 vdout0_21ck78 = 0 time = 790
* CHECK dout0_22 vdout0_22ck78 = 0 time = 790
* CHECK dout0_23 vdout0_23ck78 = 0 time = 790
* CHECK dout0_24 vdout0_24ck78 = 3.3 time = 790
* CHECK dout0_25 vdout0_25ck78 = 3.3 time = 790
* CHECK dout0_26 vdout0_26ck78 = 3.3 time = 790
* CHECK dout0_27 vdout0_27ck78 = 3.3 time = 790
* CHECK dout0_28 vdout0_28ck78 = 3.3 time = 790
* CHECK dout0_29 vdout0_29ck78 = 0 time = 790
* CHECK dout0_30 vdout0_30ck78 = 0 time = 790
* CHECK dout0_31 vdout0_31ck78 = 0 time = 790
* CHECK dout1_0 vdout1_0ck78 = 0 time = 790
* CHECK dout1_1 vdout1_1ck78 = 0 time = 790
* CHECK dout1_2 vdout1_2ck78 = 3.3 time = 790
* CHECK dout1_3 vdout1_3ck78 = 0 time = 790
* CHECK dout1_4 vdout1_4ck78 = 0 time = 790
* CHECK dout1_5 vdout1_5ck78 = 0 time = 790
* CHECK dout1_6 vdout1_6ck78 = 3.3 time = 790
* CHECK dout1_7 vdout1_7ck78 = 0 time = 790
* CHECK dout1_8 vdout1_8ck78 = 3.3 time = 790
* CHECK dout1_9 vdout1_9ck78 = 3.3 time = 790
* CHECK dout1_10 vdout1_10ck78 = 3.3 time = 790
* CHECK dout1_11 vdout1_11ck78 = 0 time = 790
* CHECK dout1_12 vdout1_12ck78 = 3.3 time = 790
* CHECK dout1_13 vdout1_13ck78 = 0 time = 790
* CHECK dout1_14 vdout1_14ck78 = 3.3 time = 790
* CHECK dout1_15 vdout1_15ck78 = 0 time = 790
* CHECK dout1_16 vdout1_16ck78 = 3.3 time = 790
* CHECK dout1_17 vdout1_17ck78 = 3.3 time = 790
* CHECK dout1_18 vdout1_18ck78 = 0 time = 790
* CHECK dout1_19 vdout1_19ck78 = 0 time = 790
* CHECK dout1_20 vdout1_20ck78 = 3.3 time = 790
* CHECK dout1_21 vdout1_21ck78 = 0 time = 790
* CHECK dout1_22 vdout1_22ck78 = 3.3 time = 790
* CHECK dout1_23 vdout1_23ck78 = 0 time = 790
* CHECK dout1_24 vdout1_24ck78 = 0 time = 790
* CHECK dout1_25 vdout1_25ck78 = 3.3 time = 790
* CHECK dout1_26 vdout1_26ck78 = 3.3 time = 790
* CHECK dout1_27 vdout1_27ck78 = 3.3 time = 790
* CHECK dout1_28 vdout1_28ck78 = 3.3 time = 790
* CHECK dout1_29 vdout1_29ck78 = 0 time = 790
* CHECK dout1_30 vdout1_30ck78 = 3.3 time = 790
* CHECK dout1_31 vdout1_31ck78 = 0 time = 790
* CHECK dout0_0 vdout0_0ck79 = 0 time = 800
* CHECK dout0_1 vdout0_1ck79 = 0 time = 800
* CHECK dout0_2 vdout0_2ck79 = 3.3 time = 800
* CHECK dout0_3 vdout0_3ck79 = 0 time = 800
* CHECK dout0_4 vdout0_4ck79 = 0 time = 800
* CHECK dout0_5 vdout0_5ck79 = 0 time = 800
* CHECK dout0_6 vdout0_6ck79 = 3.3 time = 800
* CHECK dout0_7 vdout0_7ck79 = 0 time = 800
* CHECK dout0_8 vdout0_8ck79 = 3.3 time = 800
* CHECK dout0_9 vdout0_9ck79 = 3.3 time = 800
* CHECK dout0_10 vdout0_10ck79 = 3.3 time = 800
* CHECK dout0_11 vdout0_11ck79 = 0 time = 800
* CHECK dout0_12 vdout0_12ck79 = 3.3 time = 800
* CHECK dout0_13 vdout0_13ck79 = 0 time = 800
* CHECK dout0_14 vdout0_14ck79 = 3.3 time = 800
* CHECK dout0_15 vdout0_15ck79 = 0 time = 800
* CHECK dout0_16 vdout0_16ck79 = 3.3 time = 800
* CHECK dout0_17 vdout0_17ck79 = 3.3 time = 800
* CHECK dout0_18 vdout0_18ck79 = 0 time = 800
* CHECK dout0_19 vdout0_19ck79 = 0 time = 800
* CHECK dout0_20 vdout0_20ck79 = 3.3 time = 800
* CHECK dout0_21 vdout0_21ck79 = 0 time = 800
* CHECK dout0_22 vdout0_22ck79 = 3.3 time = 800
* CHECK dout0_23 vdout0_23ck79 = 0 time = 800
* CHECK dout0_24 vdout0_24ck79 = 0 time = 800
* CHECK dout0_25 vdout0_25ck79 = 3.3 time = 800
* CHECK dout0_26 vdout0_26ck79 = 3.3 time = 800
* CHECK dout0_27 vdout0_27ck79 = 3.3 time = 800
* CHECK dout0_28 vdout0_28ck79 = 3.3 time = 800
* CHECK dout0_29 vdout0_29ck79 = 0 time = 800
* CHECK dout0_30 vdout0_30ck79 = 3.3 time = 800
* CHECK dout0_31 vdout0_31ck79 = 0 time = 800
* CHECK dout1_0 vdout1_0ck79 = 3.3 time = 800
* CHECK dout1_1 vdout1_1ck79 = 3.3 time = 800
* CHECK dout1_2 vdout1_2ck79 = 0 time = 800
* CHECK dout1_3 vdout1_3ck79 = 3.3 time = 800
* CHECK dout1_4 vdout1_4ck79 = 0 time = 800
* CHECK dout1_5 vdout1_5ck79 = 0 time = 800
* CHECK dout1_6 vdout1_6ck79 = 3.3 time = 800
* CHECK dout1_7 vdout1_7ck79 = 3.3 time = 800
* CHECK dout1_8 vdout1_8ck79 = 0 time = 800
* CHECK dout1_9 vdout1_9ck79 = 0 time = 800
* CHECK dout1_10 vdout1_10ck79 = 3.3 time = 800
* CHECK dout1_11 vdout1_11ck79 = 0 time = 800
* CHECK dout1_12 vdout1_12ck79 = 0 time = 800
* CHECK dout1_13 vdout1_13ck79 = 3.3 time = 800
* CHECK dout1_14 vdout1_14ck79 = 3.3 time = 800
* CHECK dout1_15 vdout1_15ck79 = 0 time = 800
* CHECK dout1_16 vdout1_16ck79 = 3.3 time = 800
* CHECK dout1_17 vdout1_17ck79 = 0 time = 800
* CHECK dout1_18 vdout1_18ck79 = 3.3 time = 800
* CHECK dout1_19 vdout1_19ck79 = 3.3 time = 800
* CHECK dout1_20 vdout1_20ck79 = 3.3 time = 800
* CHECK dout1_21 vdout1_21ck79 = 0 time = 800
* CHECK dout1_22 vdout1_22ck79 = 0 time = 800
* CHECK dout1_23 vdout1_23ck79 = 0 time = 800
* CHECK dout1_24 vdout1_24ck79 = 3.3 time = 800
* CHECK dout1_25 vdout1_25ck79 = 3.3 time = 800
* CHECK dout1_26 vdout1_26ck79 = 3.3 time = 800
* CHECK dout1_27 vdout1_27ck79 = 3.3 time = 800
* CHECK dout1_28 vdout1_28ck79 = 3.3 time = 800
* CHECK dout1_29 vdout1_29ck79 = 0 time = 800
* CHECK dout1_30 vdout1_30ck79 = 0 time = 800
* CHECK dout1_31 vdout1_31ck79 = 0 time = 800
* CHECK dout0_0 vdout0_0ck80 = 3.3 time = 810
* CHECK dout0_1 vdout0_1ck80 = 3.3 time = 810
* CHECK dout0_2 vdout0_2ck80 = 0 time = 810
* CHECK dout0_3 vdout0_3ck80 = 3.3 time = 810
* CHECK dout0_4 vdout0_4ck80 = 0 time = 810
* CHECK dout0_5 vdout0_5ck80 = 0 time = 810
* CHECK dout0_6 vdout0_6ck80 = 3.3 time = 810
* CHECK dout0_7 vdout0_7ck80 = 3.3 time = 810
* CHECK dout0_8 vdout0_8ck80 = 0 time = 810
* CHECK dout0_9 vdout0_9ck80 = 0 time = 810
* CHECK dout0_10 vdout0_10ck80 = 3.3 time = 810
* CHECK dout0_11 vdout0_11ck80 = 0 time = 810
* CHECK dout0_12 vdout0_12ck80 = 0 time = 810
* CHECK dout0_13 vdout0_13ck80 = 3.3 time = 810
* CHECK dout0_14 vdout0_14ck80 = 3.3 time = 810
* CHECK dout0_15 vdout0_15ck80 = 0 time = 810
* CHECK dout0_16 vdout0_16ck80 = 3.3 time = 810
* CHECK dout0_17 vdout0_17ck80 = 0 time = 810
* CHECK dout0_18 vdout0_18ck80 = 3.3 time = 810
* CHECK dout0_19 vdout0_19ck80 = 3.3 time = 810
* CHECK dout0_20 vdout0_20ck80 = 3.3 time = 810
* CHECK dout0_21 vdout0_21ck80 = 0 time = 810
* CHECK dout0_22 vdout0_22ck80 = 0 time = 810
* CHECK dout0_23 vdout0_23ck80 = 0 time = 810
* CHECK dout0_24 vdout0_24ck80 = 3.3 time = 810
* CHECK dout0_25 vdout0_25ck80 = 3.3 time = 810
* CHECK dout0_26 vdout0_26ck80 = 3.3 time = 810
* CHECK dout0_27 vdout0_27ck80 = 3.3 time = 810
* CHECK dout0_28 vdout0_28ck80 = 3.3 time = 810
* CHECK dout0_29 vdout0_29ck80 = 0 time = 810
* CHECK dout0_30 vdout0_30ck80 = 0 time = 810
* CHECK dout0_31 vdout0_31ck80 = 0 time = 810
* CHECK dout0_0 vdout0_0ck81 = 0 time = 820
* CHECK dout0_1 vdout0_1ck81 = 3.3 time = 820
* CHECK dout0_2 vdout0_2ck81 = 0 time = 820
* CHECK dout0_3 vdout0_3ck81 = 0 time = 820
* CHECK dout0_4 vdout0_4ck81 = 0 time = 820
* CHECK dout0_5 vdout0_5ck81 = 0 time = 820
* CHECK dout0_6 vdout0_6ck81 = 0 time = 820
* CHECK dout0_7 vdout0_7ck81 = 3.3 time = 820
* CHECK dout0_8 vdout0_8ck81 = 0 time = 820
* CHECK dout0_9 vdout0_9ck81 = 3.3 time = 820
* CHECK dout0_10 vdout0_10ck81 = 0 time = 820
* CHECK dout0_11 vdout0_11ck81 = 0 time = 820
* CHECK dout0_12 vdout0_12ck81 = 0 time = 820
* CHECK dout0_13 vdout0_13ck81 = 0 time = 820
* CHECK dout0_14 vdout0_14ck81 = 0 time = 820
* CHECK dout0_15 vdout0_15ck81 = 0 time = 820
* CHECK dout0_16 vdout0_16ck81 = 3.3 time = 820
* CHECK dout0_17 vdout0_17ck81 = 3.3 time = 820
* CHECK dout0_18 vdout0_18ck81 = 3.3 time = 820
* CHECK dout0_19 vdout0_19ck81 = 3.3 time = 820
* CHECK dout0_20 vdout0_20ck81 = 3.3 time = 820
* CHECK dout0_21 vdout0_21ck81 = 3.3 time = 820
* CHECK dout0_22 vdout0_22ck81 = 0 time = 820
* CHECK dout0_23 vdout0_23ck81 = 0 time = 820
* CHECK dout0_24 vdout0_24ck81 = 3.3 time = 820
* CHECK dout0_25 vdout0_25ck81 = 0 time = 820
* CHECK dout0_26 vdout0_26ck81 = 0 time = 820
* CHECK dout0_27 vdout0_27ck81 = 3.3 time = 820
* CHECK dout0_28 vdout0_28ck81 = 3.3 time = 820
* CHECK dout0_29 vdout0_29ck81 = 3.3 time = 820
* CHECK dout0_30 vdout0_30ck81 = 3.3 time = 820
* CHECK dout0_31 vdout0_31ck81 = 3.3 time = 820
* CHECK dout1_0 vdout1_0ck81 = 0 time = 820
* CHECK dout1_1 vdout1_1ck81 = 3.3 time = 820
* CHECK dout1_2 vdout1_2ck81 = 0 time = 820
* CHECK dout1_3 vdout1_3ck81 = 0 time = 820
* CHECK dout1_4 vdout1_4ck81 = 0 time = 820
* CHECK dout1_5 vdout1_5ck81 = 0 time = 820
* CHECK dout1_6 vdout1_6ck81 = 0 time = 820
* CHECK dout1_7 vdout1_7ck81 = 3.3 time = 820
* CHECK dout1_8 vdout1_8ck81 = 0 time = 820
* CHECK dout1_9 vdout1_9ck81 = 3.3 time = 820
* CHECK dout1_10 vdout1_10ck81 = 0 time = 820
* CHECK dout1_11 vdout1_11ck81 = 0 time = 820
* CHECK dout1_12 vdout1_12ck81 = 0 time = 820
* CHECK dout1_13 vdout1_13ck81 = 0 time = 820
* CHECK dout1_14 vdout1_14ck81 = 0 time = 820
* CHECK dout1_15 vdout1_15ck81 = 0 time = 820
* CHECK dout1_16 vdout1_16ck81 = 3.3 time = 820
* CHECK dout1_17 vdout1_17ck81 = 3.3 time = 820
* CHECK dout1_18 vdout1_18ck81 = 3.3 time = 820
* CHECK dout1_19 vdout1_19ck81 = 3.3 time = 820
* CHECK dout1_20 vdout1_20ck81 = 3.3 time = 820
* CHECK dout1_21 vdout1_21ck81 = 3.3 time = 820
* CHECK dout1_22 vdout1_22ck81 = 0 time = 820
* CHECK dout1_23 vdout1_23ck81 = 0 time = 820
* CHECK dout1_24 vdout1_24ck81 = 3.3 time = 820
* CHECK dout1_25 vdout1_25ck81 = 0 time = 820
* CHECK dout1_26 vdout1_26ck81 = 0 time = 820
* CHECK dout1_27 vdout1_27ck81 = 3.3 time = 820
* CHECK dout1_28 vdout1_28ck81 = 3.3 time = 820
* CHECK dout1_29 vdout1_29ck81 = 3.3 time = 820
* CHECK dout1_30 vdout1_30ck81 = 3.3 time = 820
* CHECK dout1_31 vdout1_31ck81 = 3.3 time = 820
* CHECK dout0_0 vdout0_0ck82 = 0 time = 830
* CHECK dout0_1 vdout0_1ck82 = 3.3 time = 830
* CHECK dout0_2 vdout0_2ck82 = 0 time = 830
* CHECK dout0_3 vdout0_3ck82 = 0 time = 830
* CHECK dout0_4 vdout0_4ck82 = 0 time = 830
* CHECK dout0_5 vdout0_5ck82 = 0 time = 830
* CHECK dout0_6 vdout0_6ck82 = 0 time = 830
* CHECK dout0_7 vdout0_7ck82 = 3.3 time = 830
* CHECK dout0_8 vdout0_8ck82 = 0 time = 830
* CHECK dout0_9 vdout0_9ck82 = 3.3 time = 830
* CHECK dout0_10 vdout0_10ck82 = 0 time = 830
* CHECK dout0_11 vdout0_11ck82 = 0 time = 830
* CHECK dout0_12 vdout0_12ck82 = 0 time = 830
* CHECK dout0_13 vdout0_13ck82 = 0 time = 830
* CHECK dout0_14 vdout0_14ck82 = 0 time = 830
* CHECK dout0_15 vdout0_15ck82 = 0 time = 830
* CHECK dout0_16 vdout0_16ck82 = 3.3 time = 830
* CHECK dout0_17 vdout0_17ck82 = 3.3 time = 830
* CHECK dout0_18 vdout0_18ck82 = 3.3 time = 830
* CHECK dout0_19 vdout0_19ck82 = 3.3 time = 830
* CHECK dout0_20 vdout0_20ck82 = 3.3 time = 830
* CHECK dout0_21 vdout0_21ck82 = 3.3 time = 830
* CHECK dout0_22 vdout0_22ck82 = 0 time = 830
* CHECK dout0_23 vdout0_23ck82 = 0 time = 830
* CHECK dout0_24 vdout0_24ck82 = 3.3 time = 830
* CHECK dout0_25 vdout0_25ck82 = 0 time = 830
* CHECK dout0_26 vdout0_26ck82 = 0 time = 830
* CHECK dout0_27 vdout0_27ck82 = 3.3 time = 830
* CHECK dout0_28 vdout0_28ck82 = 3.3 time = 830
* CHECK dout0_29 vdout0_29ck82 = 3.3 time = 830
* CHECK dout0_30 vdout0_30ck82 = 3.3 time = 830
* CHECK dout0_31 vdout0_31ck82 = 3.3 time = 830
* CHECK dout0_0 vdout0_0ck83 = 3.3 time = 840
* CHECK dout0_1 vdout0_1ck83 = 3.3 time = 840
* CHECK dout0_2 vdout0_2ck83 = 0 time = 840
* CHECK dout0_3 vdout0_3ck83 = 3.3 time = 840
* CHECK dout0_4 vdout0_4ck83 = 0 time = 840
* CHECK dout0_5 vdout0_5ck83 = 0 time = 840
* CHECK dout0_6 vdout0_6ck83 = 3.3 time = 840
* CHECK dout0_7 vdout0_7ck83 = 3.3 time = 840
* CHECK dout0_8 vdout0_8ck83 = 0 time = 840
* CHECK dout0_9 vdout0_9ck83 = 0 time = 840
* CHECK dout0_10 vdout0_10ck83 = 3.3 time = 840
* CHECK dout0_11 vdout0_11ck83 = 0 time = 840
* CHECK dout0_12 vdout0_12ck83 = 0 time = 840
* CHECK dout0_13 vdout0_13ck83 = 3.3 time = 840
* CHECK dout0_14 vdout0_14ck83 = 3.3 time = 840
* CHECK dout0_15 vdout0_15ck83 = 0 time = 840
* CHECK dout0_16 vdout0_16ck83 = 3.3 time = 840
* CHECK dout0_17 vdout0_17ck83 = 0 time = 840
* CHECK dout0_18 vdout0_18ck83 = 3.3 time = 840
* CHECK dout0_19 vdout0_19ck83 = 3.3 time = 840
* CHECK dout0_20 vdout0_20ck83 = 3.3 time = 840
* CHECK dout0_21 vdout0_21ck83 = 0 time = 840
* CHECK dout0_22 vdout0_22ck83 = 0 time = 840
* CHECK dout0_23 vdout0_23ck83 = 0 time = 840
* CHECK dout0_24 vdout0_24ck83 = 3.3 time = 840
* CHECK dout0_25 vdout0_25ck83 = 3.3 time = 840
* CHECK dout0_26 vdout0_26ck83 = 3.3 time = 840
* CHECK dout0_27 vdout0_27ck83 = 3.3 time = 840
* CHECK dout0_28 vdout0_28ck83 = 3.3 time = 840
* CHECK dout0_29 vdout0_29ck83 = 0 time = 840
* CHECK dout0_30 vdout0_30ck83 = 0 time = 840
* CHECK dout0_31 vdout0_31ck83 = 0 time = 840
* CHECK dout1_0 vdout1_0ck83 = 3.3 time = 840
* CHECK dout1_1 vdout1_1ck83 = 3.3 time = 840
* CHECK dout1_2 vdout1_2ck83 = 3.3 time = 840
* CHECK dout1_3 vdout1_3ck83 = 0 time = 840
* CHECK dout1_4 vdout1_4ck83 = 0 time = 840
* CHECK dout1_5 vdout1_5ck83 = 0 time = 840
* CHECK dout1_6 vdout1_6ck83 = 3.3 time = 840
* CHECK dout1_7 vdout1_7ck83 = 0 time = 840
* CHECK dout1_8 vdout1_8ck83 = 3.3 time = 840
* CHECK dout1_9 vdout1_9ck83 = 0 time = 840
* CHECK dout1_10 vdout1_10ck83 = 0 time = 840
* CHECK dout1_11 vdout1_11ck83 = 3.3 time = 840
* CHECK dout1_12 vdout1_12ck83 = 3.3 time = 840
* CHECK dout1_13 vdout1_13ck83 = 0 time = 840
* CHECK dout1_14 vdout1_14ck83 = 3.3 time = 840
* CHECK dout1_15 vdout1_15ck83 = 0 time = 840
* CHECK dout1_16 vdout1_16ck83 = 0 time = 840
* CHECK dout1_17 vdout1_17ck83 = 3.3 time = 840
* CHECK dout1_18 vdout1_18ck83 = 3.3 time = 840
* CHECK dout1_19 vdout1_19ck83 = 3.3 time = 840
* CHECK dout1_20 vdout1_20ck83 = 3.3 time = 840
* CHECK dout1_21 vdout1_21ck83 = 3.3 time = 840
* CHECK dout1_22 vdout1_22ck83 = 0 time = 840
* CHECK dout1_23 vdout1_23ck83 = 0 time = 840
* CHECK dout1_24 vdout1_24ck83 = 3.3 time = 840
* CHECK dout1_25 vdout1_25ck83 = 0 time = 840
* CHECK dout1_26 vdout1_26ck83 = 3.3 time = 840
* CHECK dout1_27 vdout1_27ck83 = 0 time = 840
* CHECK dout1_28 vdout1_28ck83 = 3.3 time = 840
* CHECK dout1_29 vdout1_29ck83 = 3.3 time = 840
* CHECK dout1_30 vdout1_30ck83 = 0 time = 840
* CHECK dout1_31 vdout1_31ck83 = 3.3 time = 840
* CHECK dout1_0 vdout1_0ck86 = 3.3 time = 870
* CHECK dout1_1 vdout1_1ck86 = 3.3 time = 870
* CHECK dout1_2 vdout1_2ck86 = 3.3 time = 870
* CHECK dout1_3 vdout1_3ck86 = 3.3 time = 870
* CHECK dout1_4 vdout1_4ck86 = 0 time = 870
* CHECK dout1_5 vdout1_5ck86 = 3.3 time = 870
* CHECK dout1_6 vdout1_6ck86 = 0 time = 870
* CHECK dout1_7 vdout1_7ck86 = 3.3 time = 870
* CHECK dout1_8 vdout1_8ck86 = 3.3 time = 870
* CHECK dout1_9 vdout1_9ck86 = 3.3 time = 870
* CHECK dout1_10 vdout1_10ck86 = 3.3 time = 870
* CHECK dout1_11 vdout1_11ck86 = 3.3 time = 870
* CHECK dout1_12 vdout1_12ck86 = 3.3 time = 870
* CHECK dout1_13 vdout1_13ck86 = 0 time = 870
* CHECK dout1_14 vdout1_14ck86 = 3.3 time = 870
* CHECK dout1_15 vdout1_15ck86 = 0 time = 870
* CHECK dout1_16 vdout1_16ck86 = 0 time = 870
* CHECK dout1_17 vdout1_17ck86 = 3.3 time = 870
* CHECK dout1_18 vdout1_18ck86 = 0 time = 870
* CHECK dout1_19 vdout1_19ck86 = 3.3 time = 870
* CHECK dout1_20 vdout1_20ck86 = 0 time = 870
* CHECK dout1_21 vdout1_21ck86 = 3.3 time = 870
* CHECK dout1_22 vdout1_22ck86 = 0 time = 870
* CHECK dout1_23 vdout1_23ck86 = 0 time = 870
* CHECK dout1_24 vdout1_24ck86 = 3.3 time = 870
* CHECK dout1_25 vdout1_25ck86 = 3.3 time = 870
* CHECK dout1_26 vdout1_26ck86 = 0 time = 870
* CHECK dout1_27 vdout1_27ck86 = 0 time = 870
* CHECK dout1_28 vdout1_28ck86 = 0 time = 870
* CHECK dout1_29 vdout1_29ck86 = 3.3 time = 870
* CHECK dout1_30 vdout1_30ck86 = 0 time = 870
* CHECK dout1_31 vdout1_31ck86 = 3.3 time = 870
* CHECK dout0_0 vdout0_0ck87 = 3.3 time = 880
* CHECK dout0_1 vdout0_1ck87 = 3.3 time = 880
* CHECK dout0_2 vdout0_2ck87 = 3.3 time = 880
* CHECK dout0_3 vdout0_3ck87 = 3.3 time = 880
* CHECK dout0_4 vdout0_4ck87 = 0 time = 880
* CHECK dout0_5 vdout0_5ck87 = 3.3 time = 880
* CHECK dout0_6 vdout0_6ck87 = 0 time = 880
* CHECK dout0_7 vdout0_7ck87 = 3.3 time = 880
* CHECK dout0_8 vdout0_8ck87 = 3.3 time = 880
* CHECK dout0_9 vdout0_9ck87 = 3.3 time = 880
* CHECK dout0_10 vdout0_10ck87 = 3.3 time = 880
* CHECK dout0_11 vdout0_11ck87 = 3.3 time = 880
* CHECK dout0_12 vdout0_12ck87 = 3.3 time = 880
* CHECK dout0_13 vdout0_13ck87 = 0 time = 880
* CHECK dout0_14 vdout0_14ck87 = 3.3 time = 880
* CHECK dout0_15 vdout0_15ck87 = 0 time = 880
* CHECK dout0_16 vdout0_16ck87 = 0 time = 880
* CHECK dout0_17 vdout0_17ck87 = 3.3 time = 880
* CHECK dout0_18 vdout0_18ck87 = 0 time = 880
* CHECK dout0_19 vdout0_19ck87 = 3.3 time = 880
* CHECK dout0_20 vdout0_20ck87 = 0 time = 880
* CHECK dout0_21 vdout0_21ck87 = 3.3 time = 880
* CHECK dout0_22 vdout0_22ck87 = 0 time = 880
* CHECK dout0_23 vdout0_23ck87 = 0 time = 880
* CHECK dout0_24 vdout0_24ck87 = 3.3 time = 880
* CHECK dout0_25 vdout0_25ck87 = 3.3 time = 880
* CHECK dout0_26 vdout0_26ck87 = 0 time = 880
* CHECK dout0_27 vdout0_27ck87 = 0 time = 880
* CHECK dout0_28 vdout0_28ck87 = 0 time = 880
* CHECK dout0_29 vdout0_29ck87 = 3.3 time = 880
* CHECK dout0_30 vdout0_30ck87 = 0 time = 880
* CHECK dout0_31 vdout0_31ck87 = 3.3 time = 880
* CHECK dout1_0 vdout1_0ck87 = 3.3 time = 880
* CHECK dout1_1 vdout1_1ck87 = 3.3 time = 880
* CHECK dout1_2 vdout1_2ck87 = 3.3 time = 880
* CHECK dout1_3 vdout1_3ck87 = 3.3 time = 880
* CHECK dout1_4 vdout1_4ck87 = 0 time = 880
* CHECK dout1_5 vdout1_5ck87 = 3.3 time = 880
* CHECK dout1_6 vdout1_6ck87 = 0 time = 880
* CHECK dout1_7 vdout1_7ck87 = 3.3 time = 880
* CHECK dout1_8 vdout1_8ck87 = 3.3 time = 880
* CHECK dout1_9 vdout1_9ck87 = 3.3 time = 880
* CHECK dout1_10 vdout1_10ck87 = 3.3 time = 880
* CHECK dout1_11 vdout1_11ck87 = 3.3 time = 880
* CHECK dout1_12 vdout1_12ck87 = 3.3 time = 880
* CHECK dout1_13 vdout1_13ck87 = 0 time = 880
* CHECK dout1_14 vdout1_14ck87 = 3.3 time = 880
* CHECK dout1_15 vdout1_15ck87 = 0 time = 880
* CHECK dout1_16 vdout1_16ck87 = 0 time = 880
* CHECK dout1_17 vdout1_17ck87 = 3.3 time = 880
* CHECK dout1_18 vdout1_18ck87 = 0 time = 880
* CHECK dout1_19 vdout1_19ck87 = 3.3 time = 880
* CHECK dout1_20 vdout1_20ck87 = 0 time = 880
* CHECK dout1_21 vdout1_21ck87 = 3.3 time = 880
* CHECK dout1_22 vdout1_22ck87 = 0 time = 880
* CHECK dout1_23 vdout1_23ck87 = 0 time = 880
* CHECK dout1_24 vdout1_24ck87 = 3.3 time = 880
* CHECK dout1_25 vdout1_25ck87 = 3.3 time = 880
* CHECK dout1_26 vdout1_26ck87 = 0 time = 880
* CHECK dout1_27 vdout1_27ck87 = 0 time = 880
* CHECK dout1_28 vdout1_28ck87 = 0 time = 880
* CHECK dout1_29 vdout1_29ck87 = 3.3 time = 880
* CHECK dout1_30 vdout1_30ck87 = 0 time = 880
* CHECK dout1_31 vdout1_31ck87 = 3.3 time = 880
* CHECK dout1_0 vdout1_0ck90 = 0 time = 910
* CHECK dout1_1 vdout1_1ck90 = 3.3 time = 910
* CHECK dout1_2 vdout1_2ck90 = 3.3 time = 910
* CHECK dout1_3 vdout1_3ck90 = 0 time = 910
* CHECK dout1_4 vdout1_4ck90 = 3.3 time = 910
* CHECK dout1_5 vdout1_5ck90 = 0 time = 910
* CHECK dout1_6 vdout1_6ck90 = 0 time = 910
* CHECK dout1_7 vdout1_7ck90 = 0 time = 910
* CHECK dout1_8 vdout1_8ck90 = 3.3 time = 910
* CHECK dout1_9 vdout1_9ck90 = 3.3 time = 910
* CHECK dout1_10 vdout1_10ck90 = 3.3 time = 910
* CHECK dout1_11 vdout1_11ck90 = 3.3 time = 910
* CHECK dout1_12 vdout1_12ck90 = 0 time = 910
* CHECK dout1_13 vdout1_13ck90 = 0 time = 910
* CHECK dout1_14 vdout1_14ck90 = 3.3 time = 910
* CHECK dout1_15 vdout1_15ck90 = 3.3 time = 910
* CHECK dout1_16 vdout1_16ck90 = 3.3 time = 910
* CHECK dout1_17 vdout1_17ck90 = 0 time = 910
* CHECK dout1_18 vdout1_18ck90 = 3.3 time = 910
* CHECK dout1_19 vdout1_19ck90 = 0 time = 910
* CHECK dout1_20 vdout1_20ck90 = 3.3 time = 910
* CHECK dout1_21 vdout1_21ck90 = 0 time = 910
* CHECK dout1_22 vdout1_22ck90 = 0 time = 910
* CHECK dout1_23 vdout1_23ck90 = 0 time = 910
* CHECK dout1_24 vdout1_24ck90 = 0 time = 910
* CHECK dout1_25 vdout1_25ck90 = 3.3 time = 910
* CHECK dout1_26 vdout1_26ck90 = 0 time = 910
* CHECK dout1_27 vdout1_27ck90 = 3.3 time = 910
* CHECK dout1_28 vdout1_28ck90 = 3.3 time = 910
* CHECK dout1_29 vdout1_29ck90 = 3.3 time = 910
* CHECK dout1_30 vdout1_30ck90 = 0 time = 910
* CHECK dout1_31 vdout1_31ck90 = 0 time = 910
* CHECK dout0_0 vdout0_0ck91 = 0 time = 920
* CHECK dout0_1 vdout0_1ck91 = 3.3 time = 920
* CHECK dout0_2 vdout0_2ck91 = 0 time = 920
* CHECK dout0_3 vdout0_3ck91 = 0 time = 920
* CHECK dout0_4 vdout0_4ck91 = 3.3 time = 920
* CHECK dout0_5 vdout0_5ck91 = 3.3 time = 920
* CHECK dout0_6 vdout0_6ck91 = 3.3 time = 920
* CHECK dout0_7 vdout0_7ck91 = 3.3 time = 920
* CHECK dout0_8 vdout0_8ck91 = 3.3 time = 920
* CHECK dout0_9 vdout0_9ck91 = 3.3 time = 920
* CHECK dout0_10 vdout0_10ck91 = 3.3 time = 920
* CHECK dout0_11 vdout0_11ck91 = 0 time = 920
* CHECK dout0_12 vdout0_12ck91 = 3.3 time = 920
* CHECK dout0_13 vdout0_13ck91 = 0 time = 920
* CHECK dout0_14 vdout0_14ck91 = 3.3 time = 920
* CHECK dout0_15 vdout0_15ck91 = 0 time = 920
* CHECK dout0_16 vdout0_16ck91 = 3.3 time = 920
* CHECK dout0_17 vdout0_17ck91 = 0 time = 920
* CHECK dout0_18 vdout0_18ck91 = 3.3 time = 920
* CHECK dout0_19 vdout0_19ck91 = 0 time = 920
* CHECK dout0_20 vdout0_20ck91 = 0 time = 920
* CHECK dout0_21 vdout0_21ck91 = 3.3 time = 920
* CHECK dout0_22 vdout0_22ck91 = 3.3 time = 920
* CHECK dout0_23 vdout0_23ck91 = 3.3 time = 920
* CHECK dout0_24 vdout0_24ck91 = 0 time = 920
* CHECK dout0_25 vdout0_25ck91 = 0 time = 920
* CHECK dout0_26 vdout0_26ck91 = 3.3 time = 920
* CHECK dout0_27 vdout0_27ck91 = 3.3 time = 920
* CHECK dout0_28 vdout0_28ck91 = 3.3 time = 920
* CHECK dout0_29 vdout0_29ck91 = 0 time = 920
* CHECK dout0_30 vdout0_30ck91 = 0 time = 920
* CHECK dout0_31 vdout0_31ck91 = 3.3 time = 920
* CHECK dout1_0 vdout1_0ck93 = 3.3 time = 940
* CHECK dout1_1 vdout1_1ck93 = 0 time = 940
* CHECK dout1_2 vdout1_2ck93 = 0 time = 940
* CHECK dout1_3 vdout1_3ck93 = 3.3 time = 940
* CHECK dout1_4 vdout1_4ck93 = 3.3 time = 940
* CHECK dout1_5 vdout1_5ck93 = 3.3 time = 940
* CHECK dout1_6 vdout1_6ck93 = 3.3 time = 940
* CHECK dout1_7 vdout1_7ck93 = 0 time = 940
* CHECK dout1_8 vdout1_8ck93 = 0 time = 940
* CHECK dout1_9 vdout1_9ck93 = 3.3 time = 940
* CHECK dout1_10 vdout1_10ck93 = 0 time = 940
* CHECK dout1_11 vdout1_11ck93 = 3.3 time = 940
* CHECK dout1_12 vdout1_12ck93 = 0 time = 940
* CHECK dout1_13 vdout1_13ck93 = 3.3 time = 940
* CHECK dout1_14 vdout1_14ck93 = 0 time = 940
* CHECK dout1_15 vdout1_15ck93 = 0 time = 940
* CHECK dout1_16 vdout1_16ck93 = 0 time = 940
* CHECK dout1_17 vdout1_17ck93 = 3.3 time = 940
* CHECK dout1_18 vdout1_18ck93 = 0 time = 940
* CHECK dout1_19 vdout1_19ck93 = 0 time = 940
* CHECK dout1_20 vdout1_20ck93 = 0 time = 940
* CHECK dout1_21 vdout1_21ck93 = 3.3 time = 940
* CHECK dout1_22 vdout1_22ck93 = 3.3 time = 940
* CHECK dout1_23 vdout1_23ck93 = 3.3 time = 940
* CHECK dout1_24 vdout1_24ck93 = 3.3 time = 940
* CHECK dout1_25 vdout1_25ck93 = 0 time = 940
* CHECK dout1_26 vdout1_26ck93 = 3.3 time = 940
* CHECK dout1_27 vdout1_27ck93 = 0 time = 940
* CHECK dout1_28 vdout1_28ck93 = 0 time = 940
* CHECK dout1_29 vdout1_29ck93 = 0 time = 940
* CHECK dout1_30 vdout1_30ck93 = 0 time = 940
* CHECK dout1_31 vdout1_31ck93 = 0 time = 940
* CHECK dout0_0 vdout0_0ck94 = 3.3 time = 950
* CHECK dout0_1 vdout0_1ck94 = 0 time = 950
* CHECK dout0_2 vdout0_2ck94 = 0 time = 950
* CHECK dout0_3 vdout0_3ck94 = 3.3 time = 950
* CHECK dout0_4 vdout0_4ck94 = 3.3 time = 950
* CHECK dout0_5 vdout0_5ck94 = 3.3 time = 950
* CHECK dout0_6 vdout0_6ck94 = 3.3 time = 950
* CHECK dout0_7 vdout0_7ck94 = 0 time = 950
* CHECK dout0_8 vdout0_8ck94 = 0 time = 950
* CHECK dout0_9 vdout0_9ck94 = 3.3 time = 950
* CHECK dout0_10 vdout0_10ck94 = 0 time = 950
* CHECK dout0_11 vdout0_11ck94 = 3.3 time = 950
* CHECK dout0_12 vdout0_12ck94 = 0 time = 950
* CHECK dout0_13 vdout0_13ck94 = 3.3 time = 950
* CHECK dout0_14 vdout0_14ck94 = 0 time = 950
* CHECK dout0_15 vdout0_15ck94 = 0 time = 950
* CHECK dout0_16 vdout0_16ck94 = 0 time = 950
* CHECK dout0_17 vdout0_17ck94 = 3.3 time = 950
* CHECK dout0_18 vdout0_18ck94 = 0 time = 950
* CHECK dout0_19 vdout0_19ck94 = 0 time = 950
* CHECK dout0_20 vdout0_20ck94 = 0 time = 950
* CHECK dout0_21 vdout0_21ck94 = 3.3 time = 950
* CHECK dout0_22 vdout0_22ck94 = 3.3 time = 950
* CHECK dout0_23 vdout0_23ck94 = 3.3 time = 950
* CHECK dout0_24 vdout0_24ck94 = 3.3 time = 950
* CHECK dout0_25 vdout0_25ck94 = 0 time = 950
* CHECK dout0_26 vdout0_26ck94 = 3.3 time = 950
* CHECK dout0_27 vdout0_27ck94 = 0 time = 950
* CHECK dout0_28 vdout0_28ck94 = 0 time = 950
* CHECK dout0_29 vdout0_29ck94 = 0 time = 950
* CHECK dout0_30 vdout0_30ck94 = 0 time = 950
* CHECK dout0_31 vdout0_31ck94 = 0 time = 950
* CHECK dout0_0 vdout0_0ck96 = 3.3 time = 970
* CHECK dout0_1 vdout0_1ck96 = 0 time = 970
* CHECK dout0_2 vdout0_2ck96 = 3.3 time = 970
* CHECK dout0_3 vdout0_3ck96 = 3.3 time = 970
* CHECK dout0_4 vdout0_4ck96 = 3.3 time = 970
* CHECK dout0_5 vdout0_5ck96 = 3.3 time = 970
* CHECK dout0_6 vdout0_6ck96 = 3.3 time = 970
* CHECK dout0_7 vdout0_7ck96 = 3.3 time = 970
* CHECK dout0_8 vdout0_8ck96 = 3.3 time = 970
* CHECK dout0_9 vdout0_9ck96 = 3.3 time = 970
* CHECK dout0_10 vdout0_10ck96 = 3.3 time = 970
* CHECK dout0_11 vdout0_11ck96 = 3.3 time = 970
* CHECK dout0_12 vdout0_12ck96 = 0 time = 970
* CHECK dout0_13 vdout0_13ck96 = 3.3 time = 970
* CHECK dout0_14 vdout0_14ck96 = 0 time = 970
* CHECK dout0_15 vdout0_15ck96 = 0 time = 970
* CHECK dout0_16 vdout0_16ck96 = 0 time = 970
* CHECK dout0_17 vdout0_17ck96 = 3.3 time = 970
* CHECK dout0_18 vdout0_18ck96 = 3.3 time = 970
* CHECK dout0_19 vdout0_19ck96 = 0 time = 970
* CHECK dout0_20 vdout0_20ck96 = 0 time = 970
* CHECK dout0_21 vdout0_21ck96 = 3.3 time = 970
* CHECK dout0_22 vdout0_22ck96 = 0 time = 970
* CHECK dout0_23 vdout0_23ck96 = 0 time = 970
* CHECK dout0_24 vdout0_24ck96 = 3.3 time = 970
* CHECK dout0_25 vdout0_25ck96 = 3.3 time = 970
* CHECK dout0_26 vdout0_26ck96 = 3.3 time = 970
* CHECK dout0_27 vdout0_27ck96 = 0 time = 970
* CHECK dout0_28 vdout0_28ck96 = 0 time = 970
* CHECK dout0_29 vdout0_29ck96 = 0 time = 970
* CHECK dout0_30 vdout0_30ck96 = 3.3 time = 970
* CHECK dout0_31 vdout0_31ck96 = 3.3 time = 970
* CHECK dout0_0 vdout0_0ck97 = 0 time = 980
* CHECK dout0_1 vdout0_1ck97 = 0 time = 980
* CHECK dout0_2 vdout0_2ck97 = 3.3 time = 980
* CHECK dout0_3 vdout0_3ck97 = 3.3 time = 980
* CHECK dout0_4 vdout0_4ck97 = 0 time = 980
* CHECK dout0_5 vdout0_5ck97 = 0 time = 980
* CHECK dout0_6 vdout0_6ck97 = 3.3 time = 980
* CHECK dout0_7 vdout0_7ck97 = 3.3 time = 980
* CHECK dout0_8 vdout0_8ck97 = 0 time = 980
* CHECK dout0_9 vdout0_9ck97 = 0 time = 980
* CHECK dout0_10 vdout0_10ck97 = 3.3 time = 980
* CHECK dout0_11 vdout0_11ck97 = 3.3 time = 980
* CHECK dout0_12 vdout0_12ck97 = 3.3 time = 980
* CHECK dout0_13 vdout0_13ck97 = 0 time = 980
* CHECK dout0_14 vdout0_14ck97 = 0 time = 980
* CHECK dout0_15 vdout0_15ck97 = 0 time = 980
* CHECK dout0_16 vdout0_16ck97 = 3.3 time = 980
* CHECK dout0_17 vdout0_17ck97 = 3.3 time = 980
* CHECK dout0_18 vdout0_18ck97 = 3.3 time = 980
* CHECK dout0_19 vdout0_19ck97 = 3.3 time = 980
* CHECK dout0_20 vdout0_20ck97 = 3.3 time = 980
* CHECK dout0_21 vdout0_21ck97 = 0 time = 980
* CHECK dout0_22 vdout0_22ck97 = 0 time = 980
* CHECK dout0_23 vdout0_23ck97 = 0 time = 980
* CHECK dout0_24 vdout0_24ck97 = 0 time = 980
* CHECK dout0_25 vdout0_25ck97 = 0 time = 980
* CHECK dout0_26 vdout0_26ck97 = 0 time = 980
* CHECK dout0_27 vdout0_27ck97 = 3.3 time = 980
* CHECK dout0_28 vdout0_28ck97 = 0 time = 980
* CHECK dout0_29 vdout0_29ck97 = 3.3 time = 980
* CHECK dout0_30 vdout0_30ck97 = 0 time = 980
* CHECK dout0_31 vdout0_31ck97 = 3.3 time = 980
* CHECK dout1_0 vdout1_0ck97 = 3.3 time = 980
* CHECK dout1_1 vdout1_1ck97 = 0 time = 980
* CHECK dout1_2 vdout1_2ck97 = 3.3 time = 980
* CHECK dout1_3 vdout1_3ck97 = 3.3 time = 980
* CHECK dout1_4 vdout1_4ck97 = 3.3 time = 980
* CHECK dout1_5 vdout1_5ck97 = 3.3 time = 980
* CHECK dout1_6 vdout1_6ck97 = 3.3 time = 980
* CHECK dout1_7 vdout1_7ck97 = 3.3 time = 980
* CHECK dout1_8 vdout1_8ck97 = 3.3 time = 980
* CHECK dout1_9 vdout1_9ck97 = 3.3 time = 980
* CHECK dout1_10 vdout1_10ck97 = 3.3 time = 980
* CHECK dout1_11 vdout1_11ck97 = 3.3 time = 980
* CHECK dout1_12 vdout1_12ck97 = 0 time = 980
* CHECK dout1_13 vdout1_13ck97 = 3.3 time = 980
* CHECK dout1_14 vdout1_14ck97 = 0 time = 980
* CHECK dout1_15 vdout1_15ck97 = 0 time = 980
* CHECK dout1_16 vdout1_16ck97 = 0 time = 980
* CHECK dout1_17 vdout1_17ck97 = 3.3 time = 980
* CHECK dout1_18 vdout1_18ck97 = 3.3 time = 980
* CHECK dout1_19 vdout1_19ck97 = 0 time = 980
* CHECK dout1_20 vdout1_20ck97 = 0 time = 980
* CHECK dout1_21 vdout1_21ck97 = 3.3 time = 980
* CHECK dout1_22 vdout1_22ck97 = 0 time = 980
* CHECK dout1_23 vdout1_23ck97 = 0 time = 980
* CHECK dout1_24 vdout1_24ck97 = 3.3 time = 980
* CHECK dout1_25 vdout1_25ck97 = 3.3 time = 980
* CHECK dout1_26 vdout1_26ck97 = 3.3 time = 980
* CHECK dout1_27 vdout1_27ck97 = 0 time = 980
* CHECK dout1_28 vdout1_28ck97 = 0 time = 980
* CHECK dout1_29 vdout1_29ck97 = 0 time = 980
* CHECK dout1_30 vdout1_30ck97 = 3.3 time = 980
* CHECK dout1_31 vdout1_31ck97 = 3.3 time = 980
* CHECK dout0_0 vdout0_0ck99 = 0 time = 1000
* CHECK dout0_1 vdout0_1ck99 = 3.3 time = 1000
* CHECK dout0_2 vdout0_2ck99 = 3.3 time = 1000
* CHECK dout0_3 vdout0_3ck99 = 0 time = 1000
* CHECK dout0_4 vdout0_4ck99 = 0 time = 1000
* CHECK dout0_5 vdout0_5ck99 = 3.3 time = 1000
* CHECK dout0_6 vdout0_6ck99 = 0 time = 1000
* CHECK dout0_7 vdout0_7ck99 = 3.3 time = 1000
* CHECK dout0_8 vdout0_8ck99 = 3.3 time = 1000
* CHECK dout0_9 vdout0_9ck99 = 3.3 time = 1000
* CHECK dout0_10 vdout0_10ck99 = 3.3 time = 1000
* CHECK dout0_11 vdout0_11ck99 = 0 time = 1000
* CHECK dout0_12 vdout0_12ck99 = 0 time = 1000
* CHECK dout0_13 vdout0_13ck99 = 3.3 time = 1000
* CHECK dout0_14 vdout0_14ck99 = 3.3 time = 1000
* CHECK dout0_15 vdout0_15ck99 = 3.3 time = 1000
* CHECK dout0_16 vdout0_16ck99 = 3.3 time = 1000
* CHECK dout0_17 vdout0_17ck99 = 0 time = 1000
* CHECK dout0_18 vdout0_18ck99 = 0 time = 1000
* CHECK dout0_19 vdout0_19ck99 = 0 time = 1000
* CHECK dout0_20 vdout0_20ck99 = 0 time = 1000
* CHECK dout0_21 vdout0_21ck99 = 3.3 time = 1000
* CHECK dout0_22 vdout0_22ck99 = 0 time = 1000
* CHECK dout0_23 vdout0_23ck99 = 3.3 time = 1000
* CHECK dout0_24 vdout0_24ck99 = 3.3 time = 1000
* CHECK dout0_25 vdout0_25ck99 = 0 time = 1000
* CHECK dout0_26 vdout0_26ck99 = 0 time = 1000
* CHECK dout0_27 vdout0_27ck99 = 3.3 time = 1000
* CHECK dout0_28 vdout0_28ck99 = 0 time = 1000
* CHECK dout0_29 vdout0_29ck99 = 0 time = 1000
* CHECK dout0_30 vdout0_30ck99 = 0 time = 1000
* CHECK dout0_31 vdout0_31ck99 = 3.3 time = 1000
* CHECK dout1_0 vdout1_0ck99 = 0 time = 1000
* CHECK dout1_1 vdout1_1ck99 = 3.3 time = 1000
* CHECK dout1_2 vdout1_2ck99 = 3.3 time = 1000
* CHECK dout1_3 vdout1_3ck99 = 0 time = 1000
* CHECK dout1_4 vdout1_4ck99 = 0 time = 1000
* CHECK dout1_5 vdout1_5ck99 = 3.3 time = 1000
* CHECK dout1_6 vdout1_6ck99 = 0 time = 1000
* CHECK dout1_7 vdout1_7ck99 = 3.3 time = 1000
* CHECK dout1_8 vdout1_8ck99 = 3.3 time = 1000
* CHECK dout1_9 vdout1_9ck99 = 3.3 time = 1000
* CHECK dout1_10 vdout1_10ck99 = 3.3 time = 1000
* CHECK dout1_11 vdout1_11ck99 = 0 time = 1000
* CHECK dout1_12 vdout1_12ck99 = 0 time = 1000
* CHECK dout1_13 vdout1_13ck99 = 3.3 time = 1000
* CHECK dout1_14 vdout1_14ck99 = 3.3 time = 1000
* CHECK dout1_15 vdout1_15ck99 = 3.3 time = 1000
* CHECK dout1_16 vdout1_16ck99 = 3.3 time = 1000
* CHECK dout1_17 vdout1_17ck99 = 0 time = 1000
* CHECK dout1_18 vdout1_18ck99 = 0 time = 1000
* CHECK dout1_19 vdout1_19ck99 = 0 time = 1000
* CHECK dout1_20 vdout1_20ck99 = 0 time = 1000
* CHECK dout1_21 vdout1_21ck99 = 3.3 time = 1000
* CHECK dout1_22 vdout1_22ck99 = 0 time = 1000
* CHECK dout1_23 vdout1_23ck99 = 3.3 time = 1000
* CHECK dout1_24 vdout1_24ck99 = 3.3 time = 1000
* CHECK dout1_25 vdout1_25ck99 = 0 time = 1000
* CHECK dout1_26 vdout1_26ck99 = 0 time = 1000
* CHECK dout1_27 vdout1_27ck99 = 3.3 time = 1000
* CHECK dout1_28 vdout1_28ck99 = 0 time = 1000
* CHECK dout1_29 vdout1_29ck99 = 0 time = 1000
* CHECK dout1_30 vdout1_30ck99 = 0 time = 1000
* CHECK dout1_31 vdout1_31ck99 = 3.3 time = 1000
* CHECK dout0_0 vdout0_0ck100 = 0 time = 1010
* CHECK dout0_1 vdout0_1ck100 = 3.3 time = 1010
* CHECK dout0_2 vdout0_2ck100 = 3.3 time = 1010
* CHECK dout0_3 vdout0_3ck100 = 0 time = 1010
* CHECK dout0_4 vdout0_4ck100 = 0 time = 1010
* CHECK dout0_5 vdout0_5ck100 = 3.3 time = 1010
* CHECK dout0_6 vdout0_6ck100 = 0 time = 1010
* CHECK dout0_7 vdout0_7ck100 = 3.3 time = 1010
* CHECK dout0_8 vdout0_8ck100 = 3.3 time = 1010
* CHECK dout0_9 vdout0_9ck100 = 3.3 time = 1010
* CHECK dout0_10 vdout0_10ck100 = 3.3 time = 1010
* CHECK dout0_11 vdout0_11ck100 = 0 time = 1010
* CHECK dout0_12 vdout0_12ck100 = 0 time = 1010
* CHECK dout0_13 vdout0_13ck100 = 3.3 time = 1010
* CHECK dout0_14 vdout0_14ck100 = 3.3 time = 1010
* CHECK dout0_15 vdout0_15ck100 = 3.3 time = 1010
* CHECK dout0_16 vdout0_16ck100 = 3.3 time = 1010
* CHECK dout0_17 vdout0_17ck100 = 0 time = 1010
* CHECK dout0_18 vdout0_18ck100 = 0 time = 1010
* CHECK dout0_19 vdout0_19ck100 = 0 time = 1010
* CHECK dout0_20 vdout0_20ck100 = 0 time = 1010
* CHECK dout0_21 vdout0_21ck100 = 3.3 time = 1010
* CHECK dout0_22 vdout0_22ck100 = 0 time = 1010
* CHECK dout0_23 vdout0_23ck100 = 3.3 time = 1010
* CHECK dout0_24 vdout0_24ck100 = 3.3 time = 1010
* CHECK dout0_25 vdout0_25ck100 = 0 time = 1010
* CHECK dout0_26 vdout0_26ck100 = 0 time = 1010
* CHECK dout0_27 vdout0_27ck100 = 3.3 time = 1010
* CHECK dout0_28 vdout0_28ck100 = 0 time = 1010
* CHECK dout0_29 vdout0_29ck100 = 0 time = 1010
* CHECK dout0_30 vdout0_30ck100 = 0 time = 1010
* CHECK dout0_31 vdout0_31ck100 = 3.3 time = 1010
* CHECK dout1_0 vdout1_0ck101 = 3.3 time = 1020
* CHECK dout1_1 vdout1_1ck101 = 0 time = 1020
* CHECK dout1_2 vdout1_2ck101 = 3.3 time = 1020
* CHECK dout1_3 vdout1_3ck101 = 3.3 time = 1020
* CHECK dout1_4 vdout1_4ck101 = 3.3 time = 1020
* CHECK dout1_5 vdout1_5ck101 = 3.3 time = 1020
* CHECK dout1_6 vdout1_6ck101 = 3.3 time = 1020
* CHECK dout1_7 vdout1_7ck101 = 3.3 time = 1020
* CHECK dout1_8 vdout1_8ck101 = 3.3 time = 1020
* CHECK dout1_9 vdout1_9ck101 = 3.3 time = 1020
* CHECK dout1_10 vdout1_10ck101 = 3.3 time = 1020
* CHECK dout1_11 vdout1_11ck101 = 3.3 time = 1020
* CHECK dout1_12 vdout1_12ck101 = 0 time = 1020
* CHECK dout1_13 vdout1_13ck101 = 3.3 time = 1020
* CHECK dout1_14 vdout1_14ck101 = 0 time = 1020
* CHECK dout1_15 vdout1_15ck101 = 0 time = 1020
* CHECK dout1_16 vdout1_16ck101 = 0 time = 1020
* CHECK dout1_17 vdout1_17ck101 = 3.3 time = 1020
* CHECK dout1_18 vdout1_18ck101 = 3.3 time = 1020
* CHECK dout1_19 vdout1_19ck101 = 0 time = 1020
* CHECK dout1_20 vdout1_20ck101 = 0 time = 1020
* CHECK dout1_21 vdout1_21ck101 = 3.3 time = 1020
* CHECK dout1_22 vdout1_22ck101 = 0 time = 1020
* CHECK dout1_23 vdout1_23ck101 = 0 time = 1020
* CHECK dout1_24 vdout1_24ck101 = 3.3 time = 1020
* CHECK dout1_25 vdout1_25ck101 = 3.3 time = 1020
* CHECK dout1_26 vdout1_26ck101 = 3.3 time = 1020
* CHECK dout1_27 vdout1_27ck101 = 0 time = 1020
* CHECK dout1_28 vdout1_28ck101 = 0 time = 1020
* CHECK dout1_29 vdout1_29ck101 = 0 time = 1020
* CHECK dout1_30 vdout1_30ck101 = 3.3 time = 1020
* CHECK dout1_31 vdout1_31ck101 = 3.3 time = 1020
* CHECK dout0_0 vdout0_0ck102 = 3.3 time = 1030
* CHECK dout0_1 vdout0_1ck102 = 0 time = 1030
* CHECK dout0_2 vdout0_2ck102 = 3.3 time = 1030
* CHECK dout0_3 vdout0_3ck102 = 3.3 time = 1030
* CHECK dout0_4 vdout0_4ck102 = 3.3 time = 1030
* CHECK dout0_5 vdout0_5ck102 = 3.3 time = 1030
* CHECK dout0_6 vdout0_6ck102 = 3.3 time = 1030
* CHECK dout0_7 vdout0_7ck102 = 3.3 time = 1030
* CHECK dout0_8 vdout0_8ck102 = 3.3 time = 1030
* CHECK dout0_9 vdout0_9ck102 = 3.3 time = 1030
* CHECK dout0_10 vdout0_10ck102 = 3.3 time = 1030
* CHECK dout0_11 vdout0_11ck102 = 3.3 time = 1030
* CHECK dout0_12 vdout0_12ck102 = 0 time = 1030
* CHECK dout0_13 vdout0_13ck102 = 3.3 time = 1030
* CHECK dout0_14 vdout0_14ck102 = 0 time = 1030
* CHECK dout0_15 vdout0_15ck102 = 0 time = 1030
* CHECK dout0_16 vdout0_16ck102 = 0 time = 1030
* CHECK dout0_17 vdout0_17ck102 = 3.3 time = 1030
* CHECK dout0_18 vdout0_18ck102 = 3.3 time = 1030
* CHECK dout0_19 vdout0_19ck102 = 0 time = 1030
* CHECK dout0_20 vdout0_20ck102 = 0 time = 1030
* CHECK dout0_21 vdout0_21ck102 = 3.3 time = 1030
* CHECK dout0_22 vdout0_22ck102 = 0 time = 1030
* CHECK dout0_23 vdout0_23ck102 = 0 time = 1030
* CHECK dout0_24 vdout0_24ck102 = 3.3 time = 1030
* CHECK dout0_25 vdout0_25ck102 = 3.3 time = 1030
* CHECK dout0_26 vdout0_26ck102 = 3.3 time = 1030
* CHECK dout0_27 vdout0_27ck102 = 0 time = 1030
* CHECK dout0_28 vdout0_28ck102 = 0 time = 1030
* CHECK dout0_29 vdout0_29ck102 = 0 time = 1030
* CHECK dout0_30 vdout0_30ck102 = 3.3 time = 1030
* CHECK dout0_31 vdout0_31ck102 = 3.3 time = 1030
* CHECK dout1_0 vdout1_0ck102 = 3.3 time = 1030
* CHECK dout1_1 vdout1_1ck102 = 3.3 time = 1030
* CHECK dout1_2 vdout1_2ck102 = 3.3 time = 1030
* CHECK dout1_3 vdout1_3ck102 = 0 time = 1030
* CHECK dout1_4 vdout1_4ck102 = 0 time = 1030
* CHECK dout1_5 vdout1_5ck102 = 0 time = 1030
* CHECK dout1_6 vdout1_6ck102 = 0 time = 1030
* CHECK dout1_7 vdout1_7ck102 = 0 time = 1030
* CHECK dout1_8 vdout1_8ck102 = 3.3 time = 1030
* CHECK dout1_9 vdout1_9ck102 = 3.3 time = 1030
* CHECK dout1_10 vdout1_10ck102 = 0 time = 1030
* CHECK dout1_11 vdout1_11ck102 = 3.3 time = 1030
* CHECK dout1_12 vdout1_12ck102 = 0 time = 1030
* CHECK dout1_13 vdout1_13ck102 = 0 time = 1030
* CHECK dout1_14 vdout1_14ck102 = 3.3 time = 1030
* CHECK dout1_15 vdout1_15ck102 = 3.3 time = 1030
* CHECK dout1_16 vdout1_16ck102 = 3.3 time = 1030
* CHECK dout1_17 vdout1_17ck102 = 3.3 time = 1030
* CHECK dout1_18 vdout1_18ck102 = 3.3 time = 1030
* CHECK dout1_19 vdout1_19ck102 = 3.3 time = 1030
* CHECK dout1_20 vdout1_20ck102 = 0 time = 1030
* CHECK dout1_21 vdout1_21ck102 = 3.3 time = 1030
* CHECK dout1_22 vdout1_22ck102 = 0 time = 1030
* CHECK dout1_23 vdout1_23ck102 = 0 time = 1030
* CHECK dout1_24 vdout1_24ck102 = 0 time = 1030
* CHECK dout1_25 vdout1_25ck102 = 0 time = 1030
* CHECK dout1_26 vdout1_26ck102 = 3.3 time = 1030
* CHECK dout1_27 vdout1_27ck102 = 3.3 time = 1030
* CHECK dout1_28 vdout1_28ck102 = 3.3 time = 1030
* CHECK dout1_29 vdout1_29ck102 = 0 time = 1030
* CHECK dout1_30 vdout1_30ck102 = 3.3 time = 1030
* CHECK dout1_31 vdout1_31ck102 = 3.3 time = 1030
* CHECK dout0_0 vdout0_0ck105 = 3.3 time = 1060
* CHECK dout0_1 vdout0_1ck105 = 0 time = 1060
* CHECK dout0_2 vdout0_2ck105 = 3.3 time = 1060
* CHECK dout0_3 vdout0_3ck105 = 3.3 time = 1060
* CHECK dout0_4 vdout0_4ck105 = 3.3 time = 1060
* CHECK dout0_5 vdout0_5ck105 = 3.3 time = 1060
* CHECK dout0_6 vdout0_6ck105 = 3.3 time = 1060
* CHECK dout0_7 vdout0_7ck105 = 3.3 time = 1060
* CHECK dout0_8 vdout0_8ck105 = 3.3 time = 1060
* CHECK dout0_9 vdout0_9ck105 = 3.3 time = 1060
* CHECK dout0_10 vdout0_10ck105 = 3.3 time = 1060
* CHECK dout0_11 vdout0_11ck105 = 3.3 time = 1060
* CHECK dout0_12 vdout0_12ck105 = 0 time = 1060
* CHECK dout0_13 vdout0_13ck105 = 3.3 time = 1060
* CHECK dout0_14 vdout0_14ck105 = 0 time = 1060
* CHECK dout0_15 vdout0_15ck105 = 0 time = 1060
* CHECK dout0_16 vdout0_16ck105 = 0 time = 1060
* CHECK dout0_17 vdout0_17ck105 = 3.3 time = 1060
* CHECK dout0_18 vdout0_18ck105 = 3.3 time = 1060
* CHECK dout0_19 vdout0_19ck105 = 0 time = 1060
* CHECK dout0_20 vdout0_20ck105 = 0 time = 1060
* CHECK dout0_21 vdout0_21ck105 = 3.3 time = 1060
* CHECK dout0_22 vdout0_22ck105 = 0 time = 1060
* CHECK dout0_23 vdout0_23ck105 = 0 time = 1060
* CHECK dout0_24 vdout0_24ck105 = 3.3 time = 1060
* CHECK dout0_25 vdout0_25ck105 = 3.3 time = 1060
* CHECK dout0_26 vdout0_26ck105 = 3.3 time = 1060
* CHECK dout0_27 vdout0_27ck105 = 0 time = 1060
* CHECK dout0_28 vdout0_28ck105 = 0 time = 1060
* CHECK dout0_29 vdout0_29ck105 = 0 time = 1060
* CHECK dout0_30 vdout0_30ck105 = 3.3 time = 1060
* CHECK dout0_31 vdout0_31ck105 = 3.3 time = 1060
* CHECK dout1_0 vdout1_0ck105 = 3.3 time = 1060
* CHECK dout1_1 vdout1_1ck105 = 0 time = 1060
* CHECK dout1_2 vdout1_2ck105 = 3.3 time = 1060
* CHECK dout1_3 vdout1_3ck105 = 3.3 time = 1060
* CHECK dout1_4 vdout1_4ck105 = 3.3 time = 1060
* CHECK dout1_5 vdout1_5ck105 = 3.3 time = 1060
* CHECK dout1_6 vdout1_6ck105 = 3.3 time = 1060
* CHECK dout1_7 vdout1_7ck105 = 3.3 time = 1060
* CHECK dout1_8 vdout1_8ck105 = 3.3 time = 1060
* CHECK dout1_9 vdout1_9ck105 = 3.3 time = 1060
* CHECK dout1_10 vdout1_10ck105 = 3.3 time = 1060
* CHECK dout1_11 vdout1_11ck105 = 3.3 time = 1060
* CHECK dout1_12 vdout1_12ck105 = 0 time = 1060
* CHECK dout1_13 vdout1_13ck105 = 3.3 time = 1060
* CHECK dout1_14 vdout1_14ck105 = 0 time = 1060
* CHECK dout1_15 vdout1_15ck105 = 0 time = 1060
* CHECK dout1_16 vdout1_16ck105 = 0 time = 1060
* CHECK dout1_17 vdout1_17ck105 = 3.3 time = 1060
* CHECK dout1_18 vdout1_18ck105 = 3.3 time = 1060
* CHECK dout1_19 vdout1_19ck105 = 0 time = 1060
* CHECK dout1_20 vdout1_20ck105 = 0 time = 1060
* CHECK dout1_21 vdout1_21ck105 = 3.3 time = 1060
* CHECK dout1_22 vdout1_22ck105 = 0 time = 1060
* CHECK dout1_23 vdout1_23ck105 = 0 time = 1060
* CHECK dout1_24 vdout1_24ck105 = 3.3 time = 1060
* CHECK dout1_25 vdout1_25ck105 = 3.3 time = 1060
* CHECK dout1_26 vdout1_26ck105 = 3.3 time = 1060
* CHECK dout1_27 vdout1_27ck105 = 0 time = 1060
* CHECK dout1_28 vdout1_28ck105 = 0 time = 1060
* CHECK dout1_29 vdout1_29ck105 = 0 time = 1060
* CHECK dout1_30 vdout1_30ck105 = 3.3 time = 1060
* CHECK dout1_31 vdout1_31ck105 = 3.3 time = 1060
* CHECK dout0_0 vdout0_0ck106 = 3.3 time = 1070
* CHECK dout0_1 vdout0_1ck106 = 3.3 time = 1070
* CHECK dout0_2 vdout0_2ck106 = 0 time = 1070
* CHECK dout0_3 vdout0_3ck106 = 3.3 time = 1070
* CHECK dout0_4 vdout0_4ck106 = 3.3 time = 1070
* CHECK dout0_5 vdout0_5ck106 = 0 time = 1070
* CHECK dout0_6 vdout0_6ck106 = 0 time = 1070
* CHECK dout0_7 vdout0_7ck106 = 0 time = 1070
* CHECK dout0_8 vdout0_8ck106 = 3.3 time = 1070
* CHECK dout0_9 vdout0_9ck106 = 3.3 time = 1070
* CHECK dout0_10 vdout0_10ck106 = 3.3 time = 1070
* CHECK dout0_11 vdout0_11ck106 = 3.3 time = 1070
* CHECK dout0_12 vdout0_12ck106 = 0 time = 1070
* CHECK dout0_13 vdout0_13ck106 = 0 time = 1070
* CHECK dout0_14 vdout0_14ck106 = 3.3 time = 1070
* CHECK dout0_15 vdout0_15ck106 = 3.3 time = 1070
* CHECK dout0_16 vdout0_16ck106 = 0 time = 1070
* CHECK dout0_17 vdout0_17ck106 = 3.3 time = 1070
* CHECK dout0_18 vdout0_18ck106 = 3.3 time = 1070
* CHECK dout0_19 vdout0_19ck106 = 3.3 time = 1070
* CHECK dout0_20 vdout0_20ck106 = 3.3 time = 1070
* CHECK dout0_21 vdout0_21ck106 = 3.3 time = 1070
* CHECK dout0_22 vdout0_22ck106 = 3.3 time = 1070
* CHECK dout0_23 vdout0_23ck106 = 3.3 time = 1070
* CHECK dout0_24 vdout0_24ck106 = 3.3 time = 1070
* CHECK dout0_25 vdout0_25ck106 = 3.3 time = 1070
* CHECK dout0_26 vdout0_26ck106 = 3.3 time = 1070
* CHECK dout0_27 vdout0_27ck106 = 3.3 time = 1070
* CHECK dout0_28 vdout0_28ck106 = 3.3 time = 1070
* CHECK dout0_29 vdout0_29ck106 = 3.3 time = 1070
* CHECK dout0_30 vdout0_30ck106 = 3.3 time = 1070
* CHECK dout0_31 vdout0_31ck106 = 0 time = 1070
* CHECK dout0_0 vdout0_0ck107 = 3.3 time = 1080
* CHECK dout0_1 vdout0_1ck107 = 3.3 time = 1080
* CHECK dout0_2 vdout0_2ck107 = 0 time = 1080
* CHECK dout0_3 vdout0_3ck107 = 3.3 time = 1080
* CHECK dout0_4 vdout0_4ck107 = 3.3 time = 1080
* CHECK dout0_5 vdout0_5ck107 = 0 time = 1080
* CHECK dout0_6 vdout0_6ck107 = 0 time = 1080
* CHECK dout0_7 vdout0_7ck107 = 0 time = 1080
* CHECK dout0_8 vdout0_8ck107 = 3.3 time = 1080
* CHECK dout0_9 vdout0_9ck107 = 3.3 time = 1080
* CHECK dout0_10 vdout0_10ck107 = 3.3 time = 1080
* CHECK dout0_11 vdout0_11ck107 = 3.3 time = 1080
* CHECK dout0_12 vdout0_12ck107 = 0 time = 1080
* CHECK dout0_13 vdout0_13ck107 = 0 time = 1080
* CHECK dout0_14 vdout0_14ck107 = 3.3 time = 1080
* CHECK dout0_15 vdout0_15ck107 = 3.3 time = 1080
* CHECK dout0_16 vdout0_16ck107 = 0 time = 1080
* CHECK dout0_17 vdout0_17ck107 = 3.3 time = 1080
* CHECK dout0_18 vdout0_18ck107 = 3.3 time = 1080
* CHECK dout0_19 vdout0_19ck107 = 3.3 time = 1080
* CHECK dout0_20 vdout0_20ck107 = 3.3 time = 1080
* CHECK dout0_21 vdout0_21ck107 = 3.3 time = 1080
* CHECK dout0_22 vdout0_22ck107 = 3.3 time = 1080
* CHECK dout0_23 vdout0_23ck107 = 3.3 time = 1080
* CHECK dout0_24 vdout0_24ck107 = 3.3 time = 1080
* CHECK dout0_25 vdout0_25ck107 = 3.3 time = 1080
* CHECK dout0_26 vdout0_26ck107 = 3.3 time = 1080
* CHECK dout0_27 vdout0_27ck107 = 3.3 time = 1080
* CHECK dout0_28 vdout0_28ck107 = 3.3 time = 1080
* CHECK dout0_29 vdout0_29ck107 = 3.3 time = 1080
* CHECK dout0_30 vdout0_30ck107 = 3.3 time = 1080
* CHECK dout0_31 vdout0_31ck107 = 0 time = 1080
* CHECK dout1_0 vdout1_0ck107 = 3.3 time = 1080
* CHECK dout1_1 vdout1_1ck107 = 3.3 time = 1080
* CHECK dout1_2 vdout1_2ck107 = 0 time = 1080
* CHECK dout1_3 vdout1_3ck107 = 3.3 time = 1080
* CHECK dout1_4 vdout1_4ck107 = 3.3 time = 1080
* CHECK dout1_5 vdout1_5ck107 = 0 time = 1080
* CHECK dout1_6 vdout1_6ck107 = 0 time = 1080
* CHECK dout1_7 vdout1_7ck107 = 0 time = 1080
* CHECK dout1_8 vdout1_8ck107 = 3.3 time = 1080
* CHECK dout1_9 vdout1_9ck107 = 3.3 time = 1080
* CHECK dout1_10 vdout1_10ck107 = 3.3 time = 1080
* CHECK dout1_11 vdout1_11ck107 = 3.3 time = 1080
* CHECK dout1_12 vdout1_12ck107 = 0 time = 1080
* CHECK dout1_13 vdout1_13ck107 = 0 time = 1080
* CHECK dout1_14 vdout1_14ck107 = 3.3 time = 1080
* CHECK dout1_15 vdout1_15ck107 = 3.3 time = 1080
* CHECK dout1_16 vdout1_16ck107 = 0 time = 1080
* CHECK dout1_17 vdout1_17ck107 = 3.3 time = 1080
* CHECK dout1_18 vdout1_18ck107 = 3.3 time = 1080
* CHECK dout1_19 vdout1_19ck107 = 3.3 time = 1080
* CHECK dout1_20 vdout1_20ck107 = 3.3 time = 1080
* CHECK dout1_21 vdout1_21ck107 = 3.3 time = 1080
* CHECK dout1_22 vdout1_22ck107 = 3.3 time = 1080
* CHECK dout1_23 vdout1_23ck107 = 3.3 time = 1080
* CHECK dout1_24 vdout1_24ck107 = 3.3 time = 1080
* CHECK dout1_25 vdout1_25ck107 = 3.3 time = 1080
* CHECK dout1_26 vdout1_26ck107 = 3.3 time = 1080
* CHECK dout1_27 vdout1_27ck107 = 3.3 time = 1080
* CHECK dout1_28 vdout1_28ck107 = 3.3 time = 1080
* CHECK dout1_29 vdout1_29ck107 = 3.3 time = 1080
* CHECK dout1_30 vdout1_30ck107 = 3.3 time = 1080
* CHECK dout1_31 vdout1_31ck107 = 0 time = 1080
* CHECK dout0_0 vdout0_0ck109 = 3.3 time = 1100
* CHECK dout0_1 vdout0_1ck109 = 3.3 time = 1100
* CHECK dout0_2 vdout0_2ck109 = 3.3 time = 1100
* CHECK dout0_3 vdout0_3ck109 = 3.3 time = 1100
* CHECK dout0_4 vdout0_4ck109 = 0 time = 1100
* CHECK dout0_5 vdout0_5ck109 = 3.3 time = 1100
* CHECK dout0_6 vdout0_6ck109 = 0 time = 1100
* CHECK dout0_7 vdout0_7ck109 = 3.3 time = 1100
* CHECK dout0_8 vdout0_8ck109 = 3.3 time = 1100
* CHECK dout0_9 vdout0_9ck109 = 3.3 time = 1100
* CHECK dout0_10 vdout0_10ck109 = 0 time = 1100
* CHECK dout0_11 vdout0_11ck109 = 3.3 time = 1100
* CHECK dout0_12 vdout0_12ck109 = 3.3 time = 1100
* CHECK dout0_13 vdout0_13ck109 = 3.3 time = 1100
* CHECK dout0_14 vdout0_14ck109 = 0 time = 1100
* CHECK dout0_15 vdout0_15ck109 = 3.3 time = 1100
* CHECK dout0_16 vdout0_16ck109 = 3.3 time = 1100
* CHECK dout0_17 vdout0_17ck109 = 3.3 time = 1100
* CHECK dout0_18 vdout0_18ck109 = 3.3 time = 1100
* CHECK dout0_19 vdout0_19ck109 = 0 time = 1100
* CHECK dout0_20 vdout0_20ck109 = 3.3 time = 1100
* CHECK dout0_21 vdout0_21ck109 = 3.3 time = 1100
* CHECK dout0_22 vdout0_22ck109 = 0 time = 1100
* CHECK dout0_23 vdout0_23ck109 = 3.3 time = 1100
* CHECK dout0_24 vdout0_24ck109 = 0 time = 1100
* CHECK dout0_25 vdout0_25ck109 = 3.3 time = 1100
* CHECK dout0_26 vdout0_26ck109 = 3.3 time = 1100
* CHECK dout0_27 vdout0_27ck109 = 3.3 time = 1100
* CHECK dout0_28 vdout0_28ck109 = 0 time = 1100
* CHECK dout0_29 vdout0_29ck109 = 0 time = 1100
* CHECK dout0_30 vdout0_30ck109 = 0 time = 1100
* CHECK dout0_31 vdout0_31ck109 = 3.3 time = 1100
* CHECK dout0_0 vdout0_0ck110 = 3.3 time = 1110
* CHECK dout0_1 vdout0_1ck110 = 0 time = 1110
* CHECK dout0_2 vdout0_2ck110 = 0 time = 1110
* CHECK dout0_3 vdout0_3ck110 = 3.3 time = 1110
* CHECK dout0_4 vdout0_4ck110 = 0 time = 1110
* CHECK dout0_5 vdout0_5ck110 = 0 time = 1110
* CHECK dout0_6 vdout0_6ck110 = 0 time = 1110
* CHECK dout0_7 vdout0_7ck110 = 0 time = 1110
* CHECK dout0_8 vdout0_8ck110 = 0 time = 1110
* CHECK dout0_9 vdout0_9ck110 = 0 time = 1110
* CHECK dout0_10 vdout0_10ck110 = 0 time = 1110
* CHECK dout0_11 vdout0_11ck110 = 3.3 time = 1110
* CHECK dout0_12 vdout0_12ck110 = 3.3 time = 1110
* CHECK dout0_13 vdout0_13ck110 = 0 time = 1110
* CHECK dout0_14 vdout0_14ck110 = 0 time = 1110
* CHECK dout0_15 vdout0_15ck110 = 3.3 time = 1110
* CHECK dout0_16 vdout0_16ck110 = 0 time = 1110
* CHECK dout0_17 vdout0_17ck110 = 0 time = 1110
* CHECK dout0_18 vdout0_18ck110 = 0 time = 1110
* CHECK dout0_19 vdout0_19ck110 = 3.3 time = 1110
* CHECK dout0_20 vdout0_20ck110 = 3.3 time = 1110
* CHECK dout0_21 vdout0_21ck110 = 3.3 time = 1110
* CHECK dout0_22 vdout0_22ck110 = 0 time = 1110
* CHECK dout0_23 vdout0_23ck110 = 3.3 time = 1110
* CHECK dout0_24 vdout0_24ck110 = 0 time = 1110
* CHECK dout0_25 vdout0_25ck110 = 3.3 time = 1110
* CHECK dout0_26 vdout0_26ck110 = 3.3 time = 1110
* CHECK dout0_27 vdout0_27ck110 = 3.3 time = 1110
* CHECK dout0_28 vdout0_28ck110 = 0 time = 1110
* CHECK dout0_29 vdout0_29ck110 = 3.3 time = 1110
* CHECK dout0_30 vdout0_30ck110 = 0 time = 1110
* CHECK dout0_31 vdout0_31ck110 = 3.3 time = 1110
* CHECK dout1_0 vdout1_0ck110 = 3.3 time = 1110
* CHECK dout1_1 vdout1_1ck110 = 0 time = 1110
* CHECK dout1_2 vdout1_2ck110 = 0 time = 1110
* CHECK dout1_3 vdout1_3ck110 = 3.3 time = 1110
* CHECK dout1_4 vdout1_4ck110 = 0 time = 1110
* CHECK dout1_5 vdout1_5ck110 = 0 time = 1110
* CHECK dout1_6 vdout1_6ck110 = 0 time = 1110
* CHECK dout1_7 vdout1_7ck110 = 0 time = 1110
* CHECK dout1_8 vdout1_8ck110 = 0 time = 1110
* CHECK dout1_9 vdout1_9ck110 = 0 time = 1110
* CHECK dout1_10 vdout1_10ck110 = 0 time = 1110
* CHECK dout1_11 vdout1_11ck110 = 3.3 time = 1110
* CHECK dout1_12 vdout1_12ck110 = 3.3 time = 1110
* CHECK dout1_13 vdout1_13ck110 = 0 time = 1110
* CHECK dout1_14 vdout1_14ck110 = 0 time = 1110
* CHECK dout1_15 vdout1_15ck110 = 3.3 time = 1110
* CHECK dout1_16 vdout1_16ck110 = 0 time = 1110
* CHECK dout1_17 vdout1_17ck110 = 0 time = 1110
* CHECK dout1_18 vdout1_18ck110 = 0 time = 1110
* CHECK dout1_19 vdout1_19ck110 = 3.3 time = 1110
* CHECK dout1_20 vdout1_20ck110 = 3.3 time = 1110
* CHECK dout1_21 vdout1_21ck110 = 3.3 time = 1110
* CHECK dout1_22 vdout1_22ck110 = 0 time = 1110
* CHECK dout1_23 vdout1_23ck110 = 3.3 time = 1110
* CHECK dout1_24 vdout1_24ck110 = 0 time = 1110
* CHECK dout1_25 vdout1_25ck110 = 3.3 time = 1110
* CHECK dout1_26 vdout1_26ck110 = 3.3 time = 1110
* CHECK dout1_27 vdout1_27ck110 = 3.3 time = 1110
* CHECK dout1_28 vdout1_28ck110 = 0 time = 1110
* CHECK dout1_29 vdout1_29ck110 = 3.3 time = 1110
* CHECK dout1_30 vdout1_30ck110 = 0 time = 1110
* CHECK dout1_31 vdout1_31ck110 = 3.3 time = 1110
* CHECK dout0_0 vdout0_0ck112 = 0 time = 1130
* CHECK dout0_1 vdout0_1ck112 = 0 time = 1130
* CHECK dout0_2 vdout0_2ck112 = 0 time = 1130
* CHECK dout0_3 vdout0_3ck112 = 3.3 time = 1130
* CHECK dout0_4 vdout0_4ck112 = 3.3 time = 1130
* CHECK dout0_5 vdout0_5ck112 = 3.3 time = 1130
* CHECK dout0_6 vdout0_6ck112 = 0 time = 1130
* CHECK dout0_7 vdout0_7ck112 = 3.3 time = 1130
* CHECK dout0_8 vdout0_8ck112 = 3.3 time = 1130
* CHECK dout0_9 vdout0_9ck112 = 0 time = 1130
* CHECK dout0_10 vdout0_10ck112 = 3.3 time = 1130
* CHECK dout0_11 vdout0_11ck112 = 3.3 time = 1130
* CHECK dout0_12 vdout0_12ck112 = 0 time = 1130
* CHECK dout0_13 vdout0_13ck112 = 0 time = 1130
* CHECK dout0_14 vdout0_14ck112 = 3.3 time = 1130
* CHECK dout0_15 vdout0_15ck112 = 0 time = 1130
* CHECK dout0_16 vdout0_16ck112 = 3.3 time = 1130
* CHECK dout0_17 vdout0_17ck112 = 0 time = 1130
* CHECK dout0_18 vdout0_18ck112 = 0 time = 1130
* CHECK dout0_19 vdout0_19ck112 = 0 time = 1130
* CHECK dout0_20 vdout0_20ck112 = 0 time = 1130
* CHECK dout0_21 vdout0_21ck112 = 0 time = 1130
* CHECK dout0_22 vdout0_22ck112 = 0 time = 1130
* CHECK dout0_23 vdout0_23ck112 = 0 time = 1130
* CHECK dout0_24 vdout0_24ck112 = 3.3 time = 1130
* CHECK dout0_25 vdout0_25ck112 = 3.3 time = 1130
* CHECK dout0_26 vdout0_26ck112 = 0 time = 1130
* CHECK dout0_27 vdout0_27ck112 = 0 time = 1130
* CHECK dout0_28 vdout0_28ck112 = 3.3 time = 1130
* CHECK dout0_29 vdout0_29ck112 = 0 time = 1130
* CHECK dout0_30 vdout0_30ck112 = 0 time = 1130
* CHECK dout0_31 vdout0_31ck112 = 0 time = 1130
* CHECK dout1_0 vdout1_0ck112 = 0 time = 1130
* CHECK dout1_1 vdout1_1ck112 = 0 time = 1130
* CHECK dout1_2 vdout1_2ck112 = 0 time = 1130
* CHECK dout1_3 vdout1_3ck112 = 3.3 time = 1130
* CHECK dout1_4 vdout1_4ck112 = 3.3 time = 1130
* CHECK dout1_5 vdout1_5ck112 = 3.3 time = 1130
* CHECK dout1_6 vdout1_6ck112 = 0 time = 1130
* CHECK dout1_7 vdout1_7ck112 = 3.3 time = 1130
* CHECK dout1_8 vdout1_8ck112 = 3.3 time = 1130
* CHECK dout1_9 vdout1_9ck112 = 0 time = 1130
* CHECK dout1_10 vdout1_10ck112 = 3.3 time = 1130
* CHECK dout1_11 vdout1_11ck112 = 3.3 time = 1130
* CHECK dout1_12 vdout1_12ck112 = 0 time = 1130
* CHECK dout1_13 vdout1_13ck112 = 0 time = 1130
* CHECK dout1_14 vdout1_14ck112 = 3.3 time = 1130
* CHECK dout1_15 vdout1_15ck112 = 0 time = 1130
* CHECK dout1_16 vdout1_16ck112 = 3.3 time = 1130
* CHECK dout1_17 vdout1_17ck112 = 0 time = 1130
* CHECK dout1_18 vdout1_18ck112 = 0 time = 1130
* CHECK dout1_19 vdout1_19ck112 = 0 time = 1130
* CHECK dout1_20 vdout1_20ck112 = 0 time = 1130
* CHECK dout1_21 vdout1_21ck112 = 0 time = 1130
* CHECK dout1_22 vdout1_22ck112 = 0 time = 1130
* CHECK dout1_23 vdout1_23ck112 = 0 time = 1130
* CHECK dout1_24 vdout1_24ck112 = 3.3 time = 1130
* CHECK dout1_25 vdout1_25ck112 = 3.3 time = 1130
* CHECK dout1_26 vdout1_26ck112 = 0 time = 1130
* CHECK dout1_27 vdout1_27ck112 = 0 time = 1130
* CHECK dout1_28 vdout1_28ck112 = 3.3 time = 1130
* CHECK dout1_29 vdout1_29ck112 = 0 time = 1130
* CHECK dout1_30 vdout1_30ck112 = 0 time = 1130
* CHECK dout1_31 vdout1_31ck112 = 0 time = 1130
* CHECK dout0_0 vdout0_0ck113 = 3.3 time = 1140
* CHECK dout0_1 vdout0_1ck113 = 0 time = 1140
* CHECK dout0_2 vdout0_2ck113 = 0 time = 1140
* CHECK dout0_3 vdout0_3ck113 = 3.3 time = 1140
* CHECK dout0_4 vdout0_4ck113 = 0 time = 1140
* CHECK dout0_5 vdout0_5ck113 = 0 time = 1140
* CHECK dout0_6 vdout0_6ck113 = 0 time = 1140
* CHECK dout0_7 vdout0_7ck113 = 0 time = 1140
* CHECK dout0_8 vdout0_8ck113 = 0 time = 1140
* CHECK dout0_9 vdout0_9ck113 = 0 time = 1140
* CHECK dout0_10 vdout0_10ck113 = 0 time = 1140
* CHECK dout0_11 vdout0_11ck113 = 3.3 time = 1140
* CHECK dout0_12 vdout0_12ck113 = 3.3 time = 1140
* CHECK dout0_13 vdout0_13ck113 = 0 time = 1140
* CHECK dout0_14 vdout0_14ck113 = 0 time = 1140
* CHECK dout0_15 vdout0_15ck113 = 3.3 time = 1140
* CHECK dout0_16 vdout0_16ck113 = 0 time = 1140
* CHECK dout0_17 vdout0_17ck113 = 0 time = 1140
* CHECK dout0_18 vdout0_18ck113 = 0 time = 1140
* CHECK dout0_19 vdout0_19ck113 = 3.3 time = 1140
* CHECK dout0_20 vdout0_20ck113 = 3.3 time = 1140
* CHECK dout0_21 vdout0_21ck113 = 3.3 time = 1140
* CHECK dout0_22 vdout0_22ck113 = 0 time = 1140
* CHECK dout0_23 vdout0_23ck113 = 3.3 time = 1140
* CHECK dout0_24 vdout0_24ck113 = 0 time = 1140
* CHECK dout0_25 vdout0_25ck113 = 3.3 time = 1140
* CHECK dout0_26 vdout0_26ck113 = 3.3 time = 1140
* CHECK dout0_27 vdout0_27ck113 = 3.3 time = 1140
* CHECK dout0_28 vdout0_28ck113 = 0 time = 1140
* CHECK dout0_29 vdout0_29ck113 = 3.3 time = 1140
* CHECK dout0_30 vdout0_30ck113 = 0 time = 1140
* CHECK dout0_31 vdout0_31ck113 = 3.3 time = 1140
* CHECK dout1_0 vdout1_0ck113 = 0 time = 1140
* CHECK dout1_1 vdout1_1ck113 = 0 time = 1140
* CHECK dout1_2 vdout1_2ck113 = 0 time = 1140
* CHECK dout1_3 vdout1_3ck113 = 3.3 time = 1140
* CHECK dout1_4 vdout1_4ck113 = 3.3 time = 1140
* CHECK dout1_5 vdout1_5ck113 = 3.3 time = 1140
* CHECK dout1_6 vdout1_6ck113 = 0 time = 1140
* CHECK dout1_7 vdout1_7ck113 = 3.3 time = 1140
* CHECK dout1_8 vdout1_8ck113 = 3.3 time = 1140
* CHECK dout1_9 vdout1_9ck113 = 0 time = 1140
* CHECK dout1_10 vdout1_10ck113 = 3.3 time = 1140
* CHECK dout1_11 vdout1_11ck113 = 3.3 time = 1140
* CHECK dout1_12 vdout1_12ck113 = 0 time = 1140
* CHECK dout1_13 vdout1_13ck113 = 0 time = 1140
* CHECK dout1_14 vdout1_14ck113 = 3.3 time = 1140
* CHECK dout1_15 vdout1_15ck113 = 0 time = 1140
* CHECK dout1_16 vdout1_16ck113 = 3.3 time = 1140
* CHECK dout1_17 vdout1_17ck113 = 0 time = 1140
* CHECK dout1_18 vdout1_18ck113 = 0 time = 1140
* CHECK dout1_19 vdout1_19ck113 = 0 time = 1140
* CHECK dout1_20 vdout1_20ck113 = 0 time = 1140
* CHECK dout1_21 vdout1_21ck113 = 0 time = 1140
* CHECK dout1_22 vdout1_22ck113 = 0 time = 1140
* CHECK dout1_23 vdout1_23ck113 = 0 time = 1140
* CHECK dout1_24 vdout1_24ck113 = 3.3 time = 1140
* CHECK dout1_25 vdout1_25ck113 = 3.3 time = 1140
* CHECK dout1_26 vdout1_26ck113 = 0 time = 1140
* CHECK dout1_27 vdout1_27ck113 = 0 time = 1140
* CHECK dout1_28 vdout1_28ck113 = 3.3 time = 1140
* CHECK dout1_29 vdout1_29ck113 = 0 time = 1140
* CHECK dout1_30 vdout1_30ck113 = 0 time = 1140
* CHECK dout1_31 vdout1_31ck113 = 0 time = 1140
* CHECK dout0_0 vdout0_0ck114 = 3.3 time = 1150
* CHECK dout0_1 vdout0_1ck114 = 0 time = 1150
* CHECK dout0_2 vdout0_2ck114 = 0 time = 1150
* CHECK dout0_3 vdout0_3ck114 = 3.3 time = 1150
* CHECK dout0_4 vdout0_4ck114 = 0 time = 1150
* CHECK dout0_5 vdout0_5ck114 = 0 time = 1150
* CHECK dout0_6 vdout0_6ck114 = 0 time = 1150
* CHECK dout0_7 vdout0_7ck114 = 0 time = 1150
* CHECK dout0_8 vdout0_8ck114 = 0 time = 1150
* CHECK dout0_9 vdout0_9ck114 = 0 time = 1150
* CHECK dout0_10 vdout0_10ck114 = 0 time = 1150
* CHECK dout0_11 vdout0_11ck114 = 3.3 time = 1150
* CHECK dout0_12 vdout0_12ck114 = 3.3 time = 1150
* CHECK dout0_13 vdout0_13ck114 = 0 time = 1150
* CHECK dout0_14 vdout0_14ck114 = 0 time = 1150
* CHECK dout0_15 vdout0_15ck114 = 3.3 time = 1150
* CHECK dout0_16 vdout0_16ck114 = 0 time = 1150
* CHECK dout0_17 vdout0_17ck114 = 0 time = 1150
* CHECK dout0_18 vdout0_18ck114 = 0 time = 1150
* CHECK dout0_19 vdout0_19ck114 = 3.3 time = 1150
* CHECK dout0_20 vdout0_20ck114 = 3.3 time = 1150
* CHECK dout0_21 vdout0_21ck114 = 3.3 time = 1150
* CHECK dout0_22 vdout0_22ck114 = 0 time = 1150
* CHECK dout0_23 vdout0_23ck114 = 3.3 time = 1150
* CHECK dout0_24 vdout0_24ck114 = 0 time = 1150
* CHECK dout0_25 vdout0_25ck114 = 3.3 time = 1150
* CHECK dout0_26 vdout0_26ck114 = 3.3 time = 1150
* CHECK dout0_27 vdout0_27ck114 = 3.3 time = 1150
* CHECK dout0_28 vdout0_28ck114 = 0 time = 1150
* CHECK dout0_29 vdout0_29ck114 = 3.3 time = 1150
* CHECK dout0_30 vdout0_30ck114 = 0 time = 1150
* CHECK dout0_31 vdout0_31ck114 = 3.3 time = 1150
* CHECK dout0_0 vdout0_0ck115 = 3.3 time = 1160
* CHECK dout0_1 vdout0_1ck115 = 0 time = 1160
* CHECK dout0_2 vdout0_2ck115 = 0 time = 1160
* CHECK dout0_3 vdout0_3ck115 = 3.3 time = 1160
* CHECK dout0_4 vdout0_4ck115 = 0 time = 1160
* CHECK dout0_5 vdout0_5ck115 = 0 time = 1160
* CHECK dout0_6 vdout0_6ck115 = 0 time = 1160
* CHECK dout0_7 vdout0_7ck115 = 0 time = 1160
* CHECK dout0_8 vdout0_8ck115 = 0 time = 1160
* CHECK dout0_9 vdout0_9ck115 = 0 time = 1160
* CHECK dout0_10 vdout0_10ck115 = 0 time = 1160
* CHECK dout0_11 vdout0_11ck115 = 3.3 time = 1160
* CHECK dout0_12 vdout0_12ck115 = 3.3 time = 1160
* CHECK dout0_13 vdout0_13ck115 = 0 time = 1160
* CHECK dout0_14 vdout0_14ck115 = 0 time = 1160
* CHECK dout0_15 vdout0_15ck115 = 3.3 time = 1160
* CHECK dout0_16 vdout0_16ck115 = 0 time = 1160
* CHECK dout0_17 vdout0_17ck115 = 0 time = 1160
* CHECK dout0_18 vdout0_18ck115 = 0 time = 1160
* CHECK dout0_19 vdout0_19ck115 = 3.3 time = 1160
* CHECK dout0_20 vdout0_20ck115 = 3.3 time = 1160
* CHECK dout0_21 vdout0_21ck115 = 3.3 time = 1160
* CHECK dout0_22 vdout0_22ck115 = 0 time = 1160
* CHECK dout0_23 vdout0_23ck115 = 3.3 time = 1160
* CHECK dout0_24 vdout0_24ck115 = 0 time = 1160
* CHECK dout0_25 vdout0_25ck115 = 3.3 time = 1160
* CHECK dout0_26 vdout0_26ck115 = 3.3 time = 1160
* CHECK dout0_27 vdout0_27ck115 = 3.3 time = 1160
* CHECK dout0_28 vdout0_28ck115 = 0 time = 1160
* CHECK dout0_29 vdout0_29ck115 = 3.3 time = 1160
* CHECK dout0_30 vdout0_30ck115 = 0 time = 1160
* CHECK dout0_31 vdout0_31ck115 = 3.3 time = 1160
* CHECK dout1_0 vdout1_0ck115 = 0 time = 1160
* CHECK dout1_1 vdout1_1ck115 = 0 time = 1160
* CHECK dout1_2 vdout1_2ck115 = 0 time = 1160
* CHECK dout1_3 vdout1_3ck115 = 3.3 time = 1160
* CHECK dout1_4 vdout1_4ck115 = 3.3 time = 1160
* CHECK dout1_5 vdout1_5ck115 = 3.3 time = 1160
* CHECK dout1_6 vdout1_6ck115 = 0 time = 1160
* CHECK dout1_7 vdout1_7ck115 = 3.3 time = 1160
* CHECK dout1_8 vdout1_8ck115 = 3.3 time = 1160
* CHECK dout1_9 vdout1_9ck115 = 0 time = 1160
* CHECK dout1_10 vdout1_10ck115 = 3.3 time = 1160
* CHECK dout1_11 vdout1_11ck115 = 3.3 time = 1160
* CHECK dout1_12 vdout1_12ck115 = 0 time = 1160
* CHECK dout1_13 vdout1_13ck115 = 0 time = 1160
* CHECK dout1_14 vdout1_14ck115 = 3.3 time = 1160
* CHECK dout1_15 vdout1_15ck115 = 0 time = 1160
* CHECK dout1_16 vdout1_16ck115 = 3.3 time = 1160
* CHECK dout1_17 vdout1_17ck115 = 0 time = 1160
* CHECK dout1_18 vdout1_18ck115 = 0 time = 1160
* CHECK dout1_19 vdout1_19ck115 = 0 time = 1160
* CHECK dout1_20 vdout1_20ck115 = 0 time = 1160
* CHECK dout1_21 vdout1_21ck115 = 0 time = 1160
* CHECK dout1_22 vdout1_22ck115 = 0 time = 1160
* CHECK dout1_23 vdout1_23ck115 = 0 time = 1160
* CHECK dout1_24 vdout1_24ck115 = 3.3 time = 1160
* CHECK dout1_25 vdout1_25ck115 = 3.3 time = 1160
* CHECK dout1_26 vdout1_26ck115 = 0 time = 1160
* CHECK dout1_27 vdout1_27ck115 = 0 time = 1160
* CHECK dout1_28 vdout1_28ck115 = 3.3 time = 1160
* CHECK dout1_29 vdout1_29ck115 = 0 time = 1160
* CHECK dout1_30 vdout1_30ck115 = 0 time = 1160
* CHECK dout1_31 vdout1_31ck115 = 0 time = 1160
* CHECK dout0_0 vdout0_0ck116 = 3.3 time = 1170
* CHECK dout0_1 vdout0_1ck116 = 0 time = 1170
* CHECK dout0_2 vdout0_2ck116 = 0 time = 1170
* CHECK dout0_3 vdout0_3ck116 = 3.3 time = 1170
* CHECK dout0_4 vdout0_4ck116 = 0 time = 1170
* CHECK dout0_5 vdout0_5ck116 = 0 time = 1170
* CHECK dout0_6 vdout0_6ck116 = 0 time = 1170
* CHECK dout0_7 vdout0_7ck116 = 0 time = 1170
* CHECK dout0_8 vdout0_8ck116 = 0 time = 1170
* CHECK dout0_9 vdout0_9ck116 = 0 time = 1170
* CHECK dout0_10 vdout0_10ck116 = 0 time = 1170
* CHECK dout0_11 vdout0_11ck116 = 3.3 time = 1170
* CHECK dout0_12 vdout0_12ck116 = 3.3 time = 1170
* CHECK dout0_13 vdout0_13ck116 = 0 time = 1170
* CHECK dout0_14 vdout0_14ck116 = 0 time = 1170
* CHECK dout0_15 vdout0_15ck116 = 3.3 time = 1170
* CHECK dout0_16 vdout0_16ck116 = 0 time = 1170
* CHECK dout0_17 vdout0_17ck116 = 0 time = 1170
* CHECK dout0_18 vdout0_18ck116 = 0 time = 1170
* CHECK dout0_19 vdout0_19ck116 = 3.3 time = 1170
* CHECK dout0_20 vdout0_20ck116 = 3.3 time = 1170
* CHECK dout0_21 vdout0_21ck116 = 3.3 time = 1170
* CHECK dout0_22 vdout0_22ck116 = 0 time = 1170
* CHECK dout0_23 vdout0_23ck116 = 3.3 time = 1170
* CHECK dout0_24 vdout0_24ck116 = 0 time = 1170
* CHECK dout0_25 vdout0_25ck116 = 3.3 time = 1170
* CHECK dout0_26 vdout0_26ck116 = 3.3 time = 1170
* CHECK dout0_27 vdout0_27ck116 = 3.3 time = 1170
* CHECK dout0_28 vdout0_28ck116 = 0 time = 1170
* CHECK dout0_29 vdout0_29ck116 = 3.3 time = 1170
* CHECK dout0_30 vdout0_30ck116 = 0 time = 1170
* CHECK dout0_31 vdout0_31ck116 = 3.3 time = 1170
* CHECK dout1_0 vdout1_0ck118 = 3.3 time = 1190
* CHECK dout1_1 vdout1_1ck118 = 0 time = 1190
* CHECK dout1_2 vdout1_2ck118 = 0 time = 1190
* CHECK dout1_3 vdout1_3ck118 = 3.3 time = 1190
* CHECK dout1_4 vdout1_4ck118 = 0 time = 1190
* CHECK dout1_5 vdout1_5ck118 = 0 time = 1190
* CHECK dout1_6 vdout1_6ck118 = 0 time = 1190
* CHECK dout1_7 vdout1_7ck118 = 0 time = 1190
* CHECK dout1_8 vdout1_8ck118 = 0 time = 1190
* CHECK dout1_9 vdout1_9ck118 = 0 time = 1190
* CHECK dout1_10 vdout1_10ck118 = 0 time = 1190
* CHECK dout1_11 vdout1_11ck118 = 3.3 time = 1190
* CHECK dout1_12 vdout1_12ck118 = 3.3 time = 1190
* CHECK dout1_13 vdout1_13ck118 = 0 time = 1190
* CHECK dout1_14 vdout1_14ck118 = 0 time = 1190
* CHECK dout1_15 vdout1_15ck118 = 3.3 time = 1190
* CHECK dout1_16 vdout1_16ck118 = 0 time = 1190
* CHECK dout1_17 vdout1_17ck118 = 0 time = 1190
* CHECK dout1_18 vdout1_18ck118 = 0 time = 1190
* CHECK dout1_19 vdout1_19ck118 = 3.3 time = 1190
* CHECK dout1_20 vdout1_20ck118 = 3.3 time = 1190
* CHECK dout1_21 vdout1_21ck118 = 3.3 time = 1190
* CHECK dout1_22 vdout1_22ck118 = 0 time = 1190
* CHECK dout1_23 vdout1_23ck118 = 3.3 time = 1190
* CHECK dout1_24 vdout1_24ck118 = 0 time = 1190
* CHECK dout1_25 vdout1_25ck118 = 3.3 time = 1190
* CHECK dout1_26 vdout1_26ck118 = 3.3 time = 1190
* CHECK dout1_27 vdout1_27ck118 = 3.3 time = 1190
* CHECK dout1_28 vdout1_28ck118 = 0 time = 1190
* CHECK dout1_29 vdout1_29ck118 = 3.3 time = 1190
* CHECK dout1_30 vdout1_30ck118 = 0 time = 1190
* CHECK dout1_31 vdout1_31ck118 = 3.3 time = 1190
* CHECK dout1_0 vdout1_0ck119 = 3.3 time = 1200
* CHECK dout1_1 vdout1_1ck119 = 0 time = 1200
* CHECK dout1_2 vdout1_2ck119 = 0 time = 1200
* CHECK dout1_3 vdout1_3ck119 = 3.3 time = 1200
* CHECK dout1_4 vdout1_4ck119 = 0 time = 1200
* CHECK dout1_5 vdout1_5ck119 = 0 time = 1200
* CHECK dout1_6 vdout1_6ck119 = 0 time = 1200
* CHECK dout1_7 vdout1_7ck119 = 0 time = 1200
* CHECK dout1_8 vdout1_8ck119 = 0 time = 1200
* CHECK dout1_9 vdout1_9ck119 = 0 time = 1200
* CHECK dout1_10 vdout1_10ck119 = 0 time = 1200
* CHECK dout1_11 vdout1_11ck119 = 3.3 time = 1200
* CHECK dout1_12 vdout1_12ck119 = 3.3 time = 1200
* CHECK dout1_13 vdout1_13ck119 = 0 time = 1200
* CHECK dout1_14 vdout1_14ck119 = 0 time = 1200
* CHECK dout1_15 vdout1_15ck119 = 3.3 time = 1200
* CHECK dout1_16 vdout1_16ck119 = 0 time = 1200
* CHECK dout1_17 vdout1_17ck119 = 0 time = 1200
* CHECK dout1_18 vdout1_18ck119 = 0 time = 1200
* CHECK dout1_19 vdout1_19ck119 = 3.3 time = 1200
* CHECK dout1_20 vdout1_20ck119 = 3.3 time = 1200
* CHECK dout1_21 vdout1_21ck119 = 3.3 time = 1200
* CHECK dout1_22 vdout1_22ck119 = 0 time = 1200
* CHECK dout1_23 vdout1_23ck119 = 3.3 time = 1200
* CHECK dout1_24 vdout1_24ck119 = 0 time = 1200
* CHECK dout1_25 vdout1_25ck119 = 3.3 time = 1200
* CHECK dout1_26 vdout1_26ck119 = 3.3 time = 1200
* CHECK dout1_27 vdout1_27ck119 = 3.3 time = 1200
* CHECK dout1_28 vdout1_28ck119 = 0 time = 1200
* CHECK dout1_29 vdout1_29ck119 = 3.3 time = 1200
* CHECK dout1_30 vdout1_30ck119 = 0 time = 1200
* CHECK dout1_31 vdout1_31ck119 = 3.3 time = 1200
* CHECK dout1_0 vdout1_0ck120 = 3.3 time = 1210
* CHECK dout1_1 vdout1_1ck120 = 0 time = 1210
* CHECK dout1_2 vdout1_2ck120 = 3.3 time = 1210
* CHECK dout1_3 vdout1_3ck120 = 3.3 time = 1210
* CHECK dout1_4 vdout1_4ck120 = 0 time = 1210
* CHECK dout1_5 vdout1_5ck120 = 3.3 time = 1210
* CHECK dout1_6 vdout1_6ck120 = 0 time = 1210
* CHECK dout1_7 vdout1_7ck120 = 0 time = 1210
* CHECK dout1_8 vdout1_8ck120 = 0 time = 1210
* CHECK dout1_9 vdout1_9ck120 = 3.3 time = 1210
* CHECK dout1_10 vdout1_10ck120 = 0 time = 1210
* CHECK dout1_11 vdout1_11ck120 = 3.3 time = 1210
* CHECK dout1_12 vdout1_12ck120 = 0 time = 1210
* CHECK dout1_13 vdout1_13ck120 = 3.3 time = 1210
* CHECK dout1_14 vdout1_14ck120 = 0 time = 1210
* CHECK dout1_15 vdout1_15ck120 = 0 time = 1210
* CHECK dout1_16 vdout1_16ck120 = 3.3 time = 1210
* CHECK dout1_17 vdout1_17ck120 = 3.3 time = 1210
* CHECK dout1_18 vdout1_18ck120 = 0 time = 1210
* CHECK dout1_19 vdout1_19ck120 = 0 time = 1210
* CHECK dout1_20 vdout1_20ck120 = 3.3 time = 1210
* CHECK dout1_21 vdout1_21ck120 = 0 time = 1210
* CHECK dout1_22 vdout1_22ck120 = 3.3 time = 1210
* CHECK dout1_23 vdout1_23ck120 = 0 time = 1210
* CHECK dout1_24 vdout1_24ck120 = 0 time = 1210
* CHECK dout1_25 vdout1_25ck120 = 0 time = 1210
* CHECK dout1_26 vdout1_26ck120 = 0 time = 1210
* CHECK dout1_27 vdout1_27ck120 = 0 time = 1210
* CHECK dout1_28 vdout1_28ck120 = 0 time = 1210
* CHECK dout1_29 vdout1_29ck120 = 0 time = 1210
* CHECK dout1_30 vdout1_30ck120 = 0 time = 1210
* CHECK dout1_31 vdout1_31ck120 = 0 time = 1210
* CHECK dout0_0 vdout0_0ck121 = 3.3 time = 1220
* CHECK dout0_1 vdout0_1ck121 = 0 time = 1220
* CHECK dout0_2 vdout0_2ck121 = 0 time = 1220
* CHECK dout0_3 vdout0_3ck121 = 3.3 time = 1220
* CHECK dout0_4 vdout0_4ck121 = 0 time = 1220
* CHECK dout0_5 vdout0_5ck121 = 0 time = 1220
* CHECK dout0_6 vdout0_6ck121 = 0 time = 1220
* CHECK dout0_7 vdout0_7ck121 = 0 time = 1220
* CHECK dout0_8 vdout0_8ck121 = 0 time = 1220
* CHECK dout0_9 vdout0_9ck121 = 0 time = 1220
* CHECK dout0_10 vdout0_10ck121 = 0 time = 1220
* CHECK dout0_11 vdout0_11ck121 = 3.3 time = 1220
* CHECK dout0_12 vdout0_12ck121 = 3.3 time = 1220
* CHECK dout0_13 vdout0_13ck121 = 0 time = 1220
* CHECK dout0_14 vdout0_14ck121 = 0 time = 1220
* CHECK dout0_15 vdout0_15ck121 = 3.3 time = 1220
* CHECK dout0_16 vdout0_16ck121 = 0 time = 1220
* CHECK dout0_17 vdout0_17ck121 = 0 time = 1220
* CHECK dout0_18 vdout0_18ck121 = 0 time = 1220
* CHECK dout0_19 vdout0_19ck121 = 3.3 time = 1220
* CHECK dout0_20 vdout0_20ck121 = 3.3 time = 1220
* CHECK dout0_21 vdout0_21ck121 = 3.3 time = 1220
* CHECK dout0_22 vdout0_22ck121 = 0 time = 1220
* CHECK dout0_23 vdout0_23ck121 = 3.3 time = 1220
* CHECK dout0_24 vdout0_24ck121 = 0 time = 1220
* CHECK dout0_25 vdout0_25ck121 = 3.3 time = 1220
* CHECK dout0_26 vdout0_26ck121 = 3.3 time = 1220
* CHECK dout0_27 vdout0_27ck121 = 3.3 time = 1220
* CHECK dout0_28 vdout0_28ck121 = 0 time = 1220
* CHECK dout0_29 vdout0_29ck121 = 3.3 time = 1220
* CHECK dout0_30 vdout0_30ck121 = 0 time = 1220
* CHECK dout0_31 vdout0_31ck121 = 3.3 time = 1220
* CHECK dout0_0 vdout0_0ck123 = 0 time = 1240
* CHECK dout0_1 vdout0_1ck123 = 3.3 time = 1240
* CHECK dout0_2 vdout0_2ck123 = 0 time = 1240
* CHECK dout0_3 vdout0_3ck123 = 0 time = 1240
* CHECK dout0_4 vdout0_4ck123 = 0 time = 1240
* CHECK dout0_5 vdout0_5ck123 = 3.3 time = 1240
* CHECK dout0_6 vdout0_6ck123 = 0 time = 1240
* CHECK dout0_7 vdout0_7ck123 = 3.3 time = 1240
* CHECK dout0_8 vdout0_8ck123 = 0 time = 1240
* CHECK dout0_9 vdout0_9ck123 = 3.3 time = 1240
* CHECK dout0_10 vdout0_10ck123 = 3.3 time = 1240
* CHECK dout0_11 vdout0_11ck123 = 0 time = 1240
* CHECK dout0_12 vdout0_12ck123 = 0 time = 1240
* CHECK dout0_13 vdout0_13ck123 = 0 time = 1240
* CHECK dout0_14 vdout0_14ck123 = 0 time = 1240
* CHECK dout0_15 vdout0_15ck123 = 3.3 time = 1240
* CHECK dout0_16 vdout0_16ck123 = 0 time = 1240
* CHECK dout0_17 vdout0_17ck123 = 3.3 time = 1240
* CHECK dout0_18 vdout0_18ck123 = 3.3 time = 1240
* CHECK dout0_19 vdout0_19ck123 = 0 time = 1240
* CHECK dout0_20 vdout0_20ck123 = 3.3 time = 1240
* CHECK dout0_21 vdout0_21ck123 = 0 time = 1240
* CHECK dout0_22 vdout0_22ck123 = 3.3 time = 1240
* CHECK dout0_23 vdout0_23ck123 = 3.3 time = 1240
* CHECK dout0_24 vdout0_24ck123 = 0 time = 1240
* CHECK dout0_25 vdout0_25ck123 = 3.3 time = 1240
* CHECK dout0_26 vdout0_26ck123 = 3.3 time = 1240
* CHECK dout0_27 vdout0_27ck123 = 3.3 time = 1240
* CHECK dout0_28 vdout0_28ck123 = 3.3 time = 1240
* CHECK dout0_29 vdout0_29ck123 = 0 time = 1240
* CHECK dout0_30 vdout0_30ck123 = 3.3 time = 1240
* CHECK dout0_31 vdout0_31ck123 = 0 time = 1240
* CHECK dout1_0 vdout1_0ck123 = 3.3 time = 1240
* CHECK dout1_1 vdout1_1ck123 = 0 time = 1240
* CHECK dout1_2 vdout1_2ck123 = 0 time = 1240
* CHECK dout1_3 vdout1_3ck123 = 3.3 time = 1240
* CHECK dout1_4 vdout1_4ck123 = 0 time = 1240
* CHECK dout1_5 vdout1_5ck123 = 0 time = 1240
* CHECK dout1_6 vdout1_6ck123 = 0 time = 1240
* CHECK dout1_7 vdout1_7ck123 = 0 time = 1240
* CHECK dout1_8 vdout1_8ck123 = 0 time = 1240
* CHECK dout1_9 vdout1_9ck123 = 0 time = 1240
* CHECK dout1_10 vdout1_10ck123 = 0 time = 1240
* CHECK dout1_11 vdout1_11ck123 = 3.3 time = 1240
* CHECK dout1_12 vdout1_12ck123 = 3.3 time = 1240
* CHECK dout1_13 vdout1_13ck123 = 0 time = 1240
* CHECK dout1_14 vdout1_14ck123 = 0 time = 1240
* CHECK dout1_15 vdout1_15ck123 = 3.3 time = 1240
* CHECK dout1_16 vdout1_16ck123 = 0 time = 1240
* CHECK dout1_17 vdout1_17ck123 = 0 time = 1240
* CHECK dout1_18 vdout1_18ck123 = 0 time = 1240
* CHECK dout1_19 vdout1_19ck123 = 3.3 time = 1240
* CHECK dout1_20 vdout1_20ck123 = 3.3 time = 1240
* CHECK dout1_21 vdout1_21ck123 = 3.3 time = 1240
* CHECK dout1_22 vdout1_22ck123 = 0 time = 1240
* CHECK dout1_23 vdout1_23ck123 = 3.3 time = 1240
* CHECK dout1_24 vdout1_24ck123 = 0 time = 1240
* CHECK dout1_25 vdout1_25ck123 = 3.3 time = 1240
* CHECK dout1_26 vdout1_26ck123 = 3.3 time = 1240
* CHECK dout1_27 vdout1_27ck123 = 3.3 time = 1240
* CHECK dout1_28 vdout1_28ck123 = 0 time = 1240
* CHECK dout1_29 vdout1_29ck123 = 3.3 time = 1240
* CHECK dout1_30 vdout1_30ck123 = 0 time = 1240
* CHECK dout1_31 vdout1_31ck123 = 3.3 time = 1240
* CHECK dout0_0 vdout0_0ck124 = 0 time = 1250
* CHECK dout0_1 vdout0_1ck124 = 3.3 time = 1250
* CHECK dout0_2 vdout0_2ck124 = 0 time = 1250
* CHECK dout0_3 vdout0_3ck124 = 0 time = 1250
* CHECK dout0_4 vdout0_4ck124 = 0 time = 1250
* CHECK dout0_5 vdout0_5ck124 = 3.3 time = 1250
* CHECK dout0_6 vdout0_6ck124 = 0 time = 1250
* CHECK dout0_7 vdout0_7ck124 = 3.3 time = 1250
* CHECK dout0_8 vdout0_8ck124 = 0 time = 1250
* CHECK dout0_9 vdout0_9ck124 = 3.3 time = 1250
* CHECK dout0_10 vdout0_10ck124 = 3.3 time = 1250
* CHECK dout0_11 vdout0_11ck124 = 0 time = 1250
* CHECK dout0_12 vdout0_12ck124 = 0 time = 1250
* CHECK dout0_13 vdout0_13ck124 = 0 time = 1250
* CHECK dout0_14 vdout0_14ck124 = 0 time = 1250
* CHECK dout0_15 vdout0_15ck124 = 3.3 time = 1250
* CHECK dout0_16 vdout0_16ck124 = 0 time = 1250
* CHECK dout0_17 vdout0_17ck124 = 3.3 time = 1250
* CHECK dout0_18 vdout0_18ck124 = 3.3 time = 1250
* CHECK dout0_19 vdout0_19ck124 = 0 time = 1250
* CHECK dout0_20 vdout0_20ck124 = 3.3 time = 1250
* CHECK dout0_21 vdout0_21ck124 = 0 time = 1250
* CHECK dout0_22 vdout0_22ck124 = 3.3 time = 1250
* CHECK dout0_23 vdout0_23ck124 = 3.3 time = 1250
* CHECK dout0_24 vdout0_24ck124 = 0 time = 1250
* CHECK dout0_25 vdout0_25ck124 = 3.3 time = 1250
* CHECK dout0_26 vdout0_26ck124 = 3.3 time = 1250
* CHECK dout0_27 vdout0_27ck124 = 3.3 time = 1250
* CHECK dout0_28 vdout0_28ck124 = 3.3 time = 1250
* CHECK dout0_29 vdout0_29ck124 = 0 time = 1250
* CHECK dout0_30 vdout0_30ck124 = 3.3 time = 1250
* CHECK dout0_31 vdout0_31ck124 = 0 time = 1250
* CHECK dout1_0 vdout1_0ck126 = 0 time = 1270
* CHECK dout1_1 vdout1_1ck126 = 0 time = 1270
* CHECK dout1_2 vdout1_2ck126 = 0 time = 1270
* CHECK dout1_3 vdout1_3ck126 = 0 time = 1270
* CHECK dout1_4 vdout1_4ck126 = 0 time = 1270
* CHECK dout1_5 vdout1_5ck126 = 0 time = 1270
* CHECK dout1_6 vdout1_6ck126 = 0 time = 1270
* CHECK dout1_7 vdout1_7ck126 = 3.3 time = 1270
* CHECK dout1_8 vdout1_8ck126 = 0 time = 1270
* CHECK dout1_9 vdout1_9ck126 = 0 time = 1270
* CHECK dout1_10 vdout1_10ck126 = 0 time = 1270
* CHECK dout1_11 vdout1_11ck126 = 0 time = 1270
* CHECK dout1_12 vdout1_12ck126 = 3.3 time = 1270
* CHECK dout1_13 vdout1_13ck126 = 0 time = 1270
* CHECK dout1_14 vdout1_14ck126 = 3.3 time = 1270
* CHECK dout1_15 vdout1_15ck126 = 0 time = 1270
* CHECK dout1_16 vdout1_16ck126 = 0 time = 1270
* CHECK dout1_17 vdout1_17ck126 = 0 time = 1270
* CHECK dout1_18 vdout1_18ck126 = 3.3 time = 1270
* CHECK dout1_19 vdout1_19ck126 = 0 time = 1270
* CHECK dout1_20 vdout1_20ck126 = 0 time = 1270
* CHECK dout1_21 vdout1_21ck126 = 0 time = 1270
* CHECK dout1_22 vdout1_22ck126 = 3.3 time = 1270
* CHECK dout1_23 vdout1_23ck126 = 0 time = 1270
* CHECK dout1_24 vdout1_24ck126 = 0 time = 1270
* CHECK dout1_25 vdout1_25ck126 = 3.3 time = 1270
* CHECK dout1_26 vdout1_26ck126 = 0 time = 1270
* CHECK dout1_27 vdout1_27ck126 = 0 time = 1270
* CHECK dout1_28 vdout1_28ck126 = 3.3 time = 1270
* CHECK dout1_29 vdout1_29ck126 = 0 time = 1270
* CHECK dout1_30 vdout1_30ck126 = 3.3 time = 1270
* CHECK dout1_31 vdout1_31ck126 = 3.3 time = 1270
* CHECK dout0_0 vdout0_0ck129 = 3.3 time = 1300
* CHECK dout0_1 vdout0_1ck129 = 0 time = 1300
* CHECK dout0_2 vdout0_2ck129 = 0 time = 1300
* CHECK dout0_3 vdout0_3ck129 = 0 time = 1300
* CHECK dout0_4 vdout0_4ck129 = 0 time = 1300
* CHECK dout0_5 vdout0_5ck129 = 3.3 time = 1300
* CHECK dout0_6 vdout0_6ck129 = 3.3 time = 1300
* CHECK dout0_7 vdout0_7ck129 = 3.3 time = 1300
* CHECK dout0_8 vdout0_8ck129 = 0 time = 1300
* CHECK dout0_9 vdout0_9ck129 = 0 time = 1300
* CHECK dout0_10 vdout0_10ck129 = 3.3 time = 1300
* CHECK dout0_11 vdout0_11ck129 = 0 time = 1300
* CHECK dout0_12 vdout0_12ck129 = 0 time = 1300
* CHECK dout0_13 vdout0_13ck129 = 3.3 time = 1300
* CHECK dout0_14 vdout0_14ck129 = 3.3 time = 1300
* CHECK dout0_15 vdout0_15ck129 = 0 time = 1300
* CHECK dout0_16 vdout0_16ck129 = 3.3 time = 1300
* CHECK dout0_17 vdout0_17ck129 = 0 time = 1300
* CHECK dout0_18 vdout0_18ck129 = 3.3 time = 1300
* CHECK dout0_19 vdout0_19ck129 = 3.3 time = 1300
* CHECK dout0_20 vdout0_20ck129 = 3.3 time = 1300
* CHECK dout0_21 vdout0_21ck129 = 0 time = 1300
* CHECK dout0_22 vdout0_22ck129 = 3.3 time = 1300
* CHECK dout0_23 vdout0_23ck129 = 3.3 time = 1300
* CHECK dout0_24 vdout0_24ck129 = 3.3 time = 1300
* CHECK dout0_25 vdout0_25ck129 = 3.3 time = 1300
* CHECK dout0_26 vdout0_26ck129 = 3.3 time = 1300
* CHECK dout0_27 vdout0_27ck129 = 3.3 time = 1300
* CHECK dout0_28 vdout0_28ck129 = 3.3 time = 1300
* CHECK dout0_29 vdout0_29ck129 = 3.3 time = 1300
* CHECK dout0_30 vdout0_30ck129 = 0 time = 1300
* CHECK dout0_31 vdout0_31ck129 = 3.3 time = 1300
* CHECK dout1_0 vdout1_0ck129 = 0 time = 1300
* CHECK dout1_1 vdout1_1ck129 = 0 time = 1300
* CHECK dout1_2 vdout1_2ck129 = 0 time = 1300
* CHECK dout1_3 vdout1_3ck129 = 0 time = 1300
* CHECK dout1_4 vdout1_4ck129 = 0 time = 1300
* CHECK dout1_5 vdout1_5ck129 = 0 time = 1300
* CHECK dout1_6 vdout1_6ck129 = 0 time = 1300
* CHECK dout1_7 vdout1_7ck129 = 3.3 time = 1300
* CHECK dout1_8 vdout1_8ck129 = 0 time = 1300
* CHECK dout1_9 vdout1_9ck129 = 0 time = 1300
* CHECK dout1_10 vdout1_10ck129 = 0 time = 1300
* CHECK dout1_11 vdout1_11ck129 = 0 time = 1300
* CHECK dout1_12 vdout1_12ck129 = 3.3 time = 1300
* CHECK dout1_13 vdout1_13ck129 = 0 time = 1300
* CHECK dout1_14 vdout1_14ck129 = 3.3 time = 1300
* CHECK dout1_15 vdout1_15ck129 = 0 time = 1300
* CHECK dout1_16 vdout1_16ck129 = 0 time = 1300
* CHECK dout1_17 vdout1_17ck129 = 0 time = 1300
* CHECK dout1_18 vdout1_18ck129 = 3.3 time = 1300
* CHECK dout1_19 vdout1_19ck129 = 0 time = 1300
* CHECK dout1_20 vdout1_20ck129 = 0 time = 1300
* CHECK dout1_21 vdout1_21ck129 = 0 time = 1300
* CHECK dout1_22 vdout1_22ck129 = 3.3 time = 1300
* CHECK dout1_23 vdout1_23ck129 = 0 time = 1300
* CHECK dout1_24 vdout1_24ck129 = 0 time = 1300
* CHECK dout1_25 vdout1_25ck129 = 3.3 time = 1300
* CHECK dout1_26 vdout1_26ck129 = 0 time = 1300
* CHECK dout1_27 vdout1_27ck129 = 0 time = 1300
* CHECK dout1_28 vdout1_28ck129 = 3.3 time = 1300
* CHECK dout1_29 vdout1_29ck129 = 0 time = 1300
* CHECK dout1_30 vdout1_30ck129 = 3.3 time = 1300
* CHECK dout1_31 vdout1_31ck129 = 3.3 time = 1300
* CHECK dout0_0 vdout0_0ck130 = 0 time = 1310
* CHECK dout0_1 vdout0_1ck130 = 0 time = 1310
* CHECK dout0_2 vdout0_2ck130 = 0 time = 1310
* CHECK dout0_3 vdout0_3ck130 = 0 time = 1310
* CHECK dout0_4 vdout0_4ck130 = 0 time = 1310
* CHECK dout0_5 vdout0_5ck130 = 0 time = 1310
* CHECK dout0_6 vdout0_6ck130 = 0 time = 1310
* CHECK dout0_7 vdout0_7ck130 = 3.3 time = 1310
* CHECK dout0_8 vdout0_8ck130 = 0 time = 1310
* CHECK dout0_9 vdout0_9ck130 = 0 time = 1310
* CHECK dout0_10 vdout0_10ck130 = 0 time = 1310
* CHECK dout0_11 vdout0_11ck130 = 0 time = 1310
* CHECK dout0_12 vdout0_12ck130 = 3.3 time = 1310
* CHECK dout0_13 vdout0_13ck130 = 0 time = 1310
* CHECK dout0_14 vdout0_14ck130 = 3.3 time = 1310
* CHECK dout0_15 vdout0_15ck130 = 0 time = 1310
* CHECK dout0_16 vdout0_16ck130 = 0 time = 1310
* CHECK dout0_17 vdout0_17ck130 = 0 time = 1310
* CHECK dout0_18 vdout0_18ck130 = 3.3 time = 1310
* CHECK dout0_19 vdout0_19ck130 = 0 time = 1310
* CHECK dout0_20 vdout0_20ck130 = 0 time = 1310
* CHECK dout0_21 vdout0_21ck130 = 0 time = 1310
* CHECK dout0_22 vdout0_22ck130 = 3.3 time = 1310
* CHECK dout0_23 vdout0_23ck130 = 0 time = 1310
* CHECK dout0_24 vdout0_24ck130 = 0 time = 1310
* CHECK dout0_25 vdout0_25ck130 = 3.3 time = 1310
* CHECK dout0_26 vdout0_26ck130 = 0 time = 1310
* CHECK dout0_27 vdout0_27ck130 = 0 time = 1310
* CHECK dout0_28 vdout0_28ck130 = 3.3 time = 1310
* CHECK dout0_29 vdout0_29ck130 = 0 time = 1310
* CHECK dout0_30 vdout0_30ck130 = 3.3 time = 1310
* CHECK dout0_31 vdout0_31ck130 = 3.3 time = 1310
* CHECK dout0_0 vdout0_0ck131 = 3.3 time = 1320
* CHECK dout0_1 vdout0_1ck131 = 0 time = 1320
* CHECK dout0_2 vdout0_2ck131 = 0 time = 1320
* CHECK dout0_3 vdout0_3ck131 = 0 time = 1320
* CHECK dout0_4 vdout0_4ck131 = 0 time = 1320
* CHECK dout0_5 vdout0_5ck131 = 3.3 time = 1320
* CHECK dout0_6 vdout0_6ck131 = 3.3 time = 1320
* CHECK dout0_7 vdout0_7ck131 = 3.3 time = 1320
* CHECK dout0_8 vdout0_8ck131 = 0 time = 1320
* CHECK dout0_9 vdout0_9ck131 = 0 time = 1320
* CHECK dout0_10 vdout0_10ck131 = 3.3 time = 1320
* CHECK dout0_11 vdout0_11ck131 = 0 time = 1320
* CHECK dout0_12 vdout0_12ck131 = 0 time = 1320
* CHECK dout0_13 vdout0_13ck131 = 3.3 time = 1320
* CHECK dout0_14 vdout0_14ck131 = 3.3 time = 1320
* CHECK dout0_15 vdout0_15ck131 = 0 time = 1320
* CHECK dout0_16 vdout0_16ck131 = 3.3 time = 1320
* CHECK dout0_17 vdout0_17ck131 = 0 time = 1320
* CHECK dout0_18 vdout0_18ck131 = 3.3 time = 1320
* CHECK dout0_19 vdout0_19ck131 = 3.3 time = 1320
* CHECK dout0_20 vdout0_20ck131 = 3.3 time = 1320
* CHECK dout0_21 vdout0_21ck131 = 0 time = 1320
* CHECK dout0_22 vdout0_22ck131 = 3.3 time = 1320
* CHECK dout0_23 vdout0_23ck131 = 3.3 time = 1320
* CHECK dout0_24 vdout0_24ck131 = 3.3 time = 1320
* CHECK dout0_25 vdout0_25ck131 = 3.3 time = 1320
* CHECK dout0_26 vdout0_26ck131 = 3.3 time = 1320
* CHECK dout0_27 vdout0_27ck131 = 3.3 time = 1320
* CHECK dout0_28 vdout0_28ck131 = 3.3 time = 1320
* CHECK dout0_29 vdout0_29ck131 = 3.3 time = 1320
* CHECK dout0_30 vdout0_30ck131 = 0 time = 1320
* CHECK dout0_31 vdout0_31ck131 = 3.3 time = 1320
* CHECK dout1_0 vdout1_0ck131 = 0 time = 1320
* CHECK dout1_1 vdout1_1ck131 = 0 time = 1320
* CHECK dout1_2 vdout1_2ck131 = 0 time = 1320
* CHECK dout1_3 vdout1_3ck131 = 0 time = 1320
* CHECK dout1_4 vdout1_4ck131 = 0 time = 1320
* CHECK dout1_5 vdout1_5ck131 = 0 time = 1320
* CHECK dout1_6 vdout1_6ck131 = 0 time = 1320
* CHECK dout1_7 vdout1_7ck131 = 3.3 time = 1320
* CHECK dout1_8 vdout1_8ck131 = 0 time = 1320
* CHECK dout1_9 vdout1_9ck131 = 0 time = 1320
* CHECK dout1_10 vdout1_10ck131 = 0 time = 1320
* CHECK dout1_11 vdout1_11ck131 = 0 time = 1320
* CHECK dout1_12 vdout1_12ck131 = 3.3 time = 1320
* CHECK dout1_13 vdout1_13ck131 = 0 time = 1320
* CHECK dout1_14 vdout1_14ck131 = 3.3 time = 1320
* CHECK dout1_15 vdout1_15ck131 = 0 time = 1320
* CHECK dout1_16 vdout1_16ck131 = 0 time = 1320
* CHECK dout1_17 vdout1_17ck131 = 0 time = 1320
* CHECK dout1_18 vdout1_18ck131 = 3.3 time = 1320
* CHECK dout1_19 vdout1_19ck131 = 0 time = 1320
* CHECK dout1_20 vdout1_20ck131 = 0 time = 1320
* CHECK dout1_21 vdout1_21ck131 = 0 time = 1320
* CHECK dout1_22 vdout1_22ck131 = 3.3 time = 1320
* CHECK dout1_23 vdout1_23ck131 = 0 time = 1320
* CHECK dout1_24 vdout1_24ck131 = 0 time = 1320
* CHECK dout1_25 vdout1_25ck131 = 3.3 time = 1320
* CHECK dout1_26 vdout1_26ck131 = 0 time = 1320
* CHECK dout1_27 vdout1_27ck131 = 0 time = 1320
* CHECK dout1_28 vdout1_28ck131 = 3.3 time = 1320
* CHECK dout1_29 vdout1_29ck131 = 0 time = 1320
* CHECK dout1_30 vdout1_30ck131 = 3.3 time = 1320
* CHECK dout1_31 vdout1_31ck131 = 3.3 time = 1320
* CHECK dout0_0 vdout0_0ck132 = 3.3 time = 1330
* CHECK dout0_1 vdout0_1ck132 = 0 time = 1330
* CHECK dout0_2 vdout0_2ck132 = 0 time = 1330
* CHECK dout0_3 vdout0_3ck132 = 0 time = 1330
* CHECK dout0_4 vdout0_4ck132 = 0 time = 1330
* CHECK dout0_5 vdout0_5ck132 = 3.3 time = 1330
* CHECK dout0_6 vdout0_6ck132 = 3.3 time = 1330
* CHECK dout0_7 vdout0_7ck132 = 3.3 time = 1330
* CHECK dout0_8 vdout0_8ck132 = 0 time = 1330
* CHECK dout0_9 vdout0_9ck132 = 0 time = 1330
* CHECK dout0_10 vdout0_10ck132 = 3.3 time = 1330
* CHECK dout0_11 vdout0_11ck132 = 0 time = 1330
* CHECK dout0_12 vdout0_12ck132 = 0 time = 1330
* CHECK dout0_13 vdout0_13ck132 = 3.3 time = 1330
* CHECK dout0_14 vdout0_14ck132 = 3.3 time = 1330
* CHECK dout0_15 vdout0_15ck132 = 0 time = 1330
* CHECK dout0_16 vdout0_16ck132 = 3.3 time = 1330
* CHECK dout0_17 vdout0_17ck132 = 0 time = 1330
* CHECK dout0_18 vdout0_18ck132 = 3.3 time = 1330
* CHECK dout0_19 vdout0_19ck132 = 3.3 time = 1330
* CHECK dout0_20 vdout0_20ck132 = 3.3 time = 1330
* CHECK dout0_21 vdout0_21ck132 = 0 time = 1330
* CHECK dout0_22 vdout0_22ck132 = 3.3 time = 1330
* CHECK dout0_23 vdout0_23ck132 = 3.3 time = 1330
* CHECK dout0_24 vdout0_24ck132 = 3.3 time = 1330
* CHECK dout0_25 vdout0_25ck132 = 3.3 time = 1330
* CHECK dout0_26 vdout0_26ck132 = 3.3 time = 1330
* CHECK dout0_27 vdout0_27ck132 = 3.3 time = 1330
* CHECK dout0_28 vdout0_28ck132 = 3.3 time = 1330
* CHECK dout0_29 vdout0_29ck132 = 3.3 time = 1330
* CHECK dout0_30 vdout0_30ck132 = 0 time = 1330
* CHECK dout0_31 vdout0_31ck132 = 3.3 time = 1330
* CHECK dout1_0 vdout1_0ck133 = 0 time = 1340
* CHECK dout1_1 vdout1_1ck133 = 0 time = 1340
* CHECK dout1_2 vdout1_2ck133 = 0 time = 1340
* CHECK dout1_3 vdout1_3ck133 = 0 time = 1340
* CHECK dout1_4 vdout1_4ck133 = 0 time = 1340
* CHECK dout1_5 vdout1_5ck133 = 0 time = 1340
* CHECK dout1_6 vdout1_6ck133 = 0 time = 1340
* CHECK dout1_7 vdout1_7ck133 = 3.3 time = 1340
* CHECK dout1_8 vdout1_8ck133 = 0 time = 1340
* CHECK dout1_9 vdout1_9ck133 = 0 time = 1340
* CHECK dout1_10 vdout1_10ck133 = 0 time = 1340
* CHECK dout1_11 vdout1_11ck133 = 0 time = 1340
* CHECK dout1_12 vdout1_12ck133 = 3.3 time = 1340
* CHECK dout1_13 vdout1_13ck133 = 0 time = 1340
* CHECK dout1_14 vdout1_14ck133 = 3.3 time = 1340
* CHECK dout1_15 vdout1_15ck133 = 0 time = 1340
* CHECK dout1_16 vdout1_16ck133 = 0 time = 1340
* CHECK dout1_17 vdout1_17ck133 = 0 time = 1340
* CHECK dout1_18 vdout1_18ck133 = 3.3 time = 1340
* CHECK dout1_19 vdout1_19ck133 = 0 time = 1340
* CHECK dout1_20 vdout1_20ck133 = 0 time = 1340
* CHECK dout1_21 vdout1_21ck133 = 0 time = 1340
* CHECK dout1_22 vdout1_22ck133 = 3.3 time = 1340
* CHECK dout1_23 vdout1_23ck133 = 0 time = 1340
* CHECK dout1_24 vdout1_24ck133 = 0 time = 1340
* CHECK dout1_25 vdout1_25ck133 = 3.3 time = 1340
* CHECK dout1_26 vdout1_26ck133 = 0 time = 1340
* CHECK dout1_27 vdout1_27ck133 = 0 time = 1340
* CHECK dout1_28 vdout1_28ck133 = 3.3 time = 1340
* CHECK dout1_29 vdout1_29ck133 = 0 time = 1340
* CHECK dout1_30 vdout1_30ck133 = 3.3 time = 1340
* CHECK dout1_31 vdout1_31ck133 = 3.3 time = 1340
* CHECK dout0_0 vdout0_0ck134 = 3.3 time = 1350
* CHECK dout0_1 vdout0_1ck134 = 3.3 time = 1350
* CHECK dout0_2 vdout0_2ck134 = 3.3 time = 1350
* CHECK dout0_3 vdout0_3ck134 = 0 time = 1350
* CHECK dout0_4 vdout0_4ck134 = 0 time = 1350
* CHECK dout0_5 vdout0_5ck134 = 3.3 time = 1350
* CHECK dout0_6 vdout0_6ck134 = 3.3 time = 1350
* CHECK dout0_7 vdout0_7ck134 = 3.3 time = 1350
* CHECK dout0_8 vdout0_8ck134 = 0 time = 1350
* CHECK dout0_9 vdout0_9ck134 = 3.3 time = 1350
* CHECK dout0_10 vdout0_10ck134 = 3.3 time = 1350
* CHECK dout0_11 vdout0_11ck134 = 3.3 time = 1350
* CHECK dout0_12 vdout0_12ck134 = 0 time = 1350
* CHECK dout0_13 vdout0_13ck134 = 3.3 time = 1350
* CHECK dout0_14 vdout0_14ck134 = 3.3 time = 1350
* CHECK dout0_15 vdout0_15ck134 = 3.3 time = 1350
* CHECK dout0_16 vdout0_16ck134 = 3.3 time = 1350
* CHECK dout0_17 vdout0_17ck134 = 0 time = 1350
* CHECK dout0_18 vdout0_18ck134 = 3.3 time = 1350
* CHECK dout0_19 vdout0_19ck134 = 3.3 time = 1350
* CHECK dout0_20 vdout0_20ck134 = 0 time = 1350
* CHECK dout0_21 vdout0_21ck134 = 3.3 time = 1350
* CHECK dout0_22 vdout0_22ck134 = 0 time = 1350
* CHECK dout0_23 vdout0_23ck134 = 3.3 time = 1350
* CHECK dout0_24 vdout0_24ck134 = 0 time = 1350
* CHECK dout0_25 vdout0_25ck134 = 3.3 time = 1350
* CHECK dout0_26 vdout0_26ck134 = 0 time = 1350
* CHECK dout0_27 vdout0_27ck134 = 0 time = 1350
* CHECK dout0_28 vdout0_28ck134 = 3.3 time = 1350
* CHECK dout0_29 vdout0_29ck134 = 3.3 time = 1350
* CHECK dout0_30 vdout0_30ck134 = 3.3 time = 1350
* CHECK dout0_31 vdout0_31ck134 = 0 time = 1350
* CHECK dout0_0 vdout0_0ck135 = 0 time = 1360
* CHECK dout0_1 vdout0_1ck135 = 0 time = 1360
* CHECK dout0_2 vdout0_2ck135 = 0 time = 1360
* CHECK dout0_3 vdout0_3ck135 = 0 time = 1360
* CHECK dout0_4 vdout0_4ck135 = 0 time = 1360
* CHECK dout0_5 vdout0_5ck135 = 0 time = 1360
* CHECK dout0_6 vdout0_6ck135 = 0 time = 1360
* CHECK dout0_7 vdout0_7ck135 = 3.3 time = 1360
* CHECK dout0_8 vdout0_8ck135 = 0 time = 1360
* CHECK dout0_9 vdout0_9ck135 = 0 time = 1360
* CHECK dout0_10 vdout0_10ck135 = 0 time = 1360
* CHECK dout0_11 vdout0_11ck135 = 0 time = 1360
* CHECK dout0_12 vdout0_12ck135 = 3.3 time = 1360
* CHECK dout0_13 vdout0_13ck135 = 0 time = 1360
* CHECK dout0_14 vdout0_14ck135 = 3.3 time = 1360
* CHECK dout0_15 vdout0_15ck135 = 0 time = 1360
* CHECK dout0_16 vdout0_16ck135 = 0 time = 1360
* CHECK dout0_17 vdout0_17ck135 = 0 time = 1360
* CHECK dout0_18 vdout0_18ck135 = 3.3 time = 1360
* CHECK dout0_19 vdout0_19ck135 = 0 time = 1360
* CHECK dout0_20 vdout0_20ck135 = 0 time = 1360
* CHECK dout0_21 vdout0_21ck135 = 0 time = 1360
* CHECK dout0_22 vdout0_22ck135 = 3.3 time = 1360
* CHECK dout0_23 vdout0_23ck135 = 0 time = 1360
* CHECK dout0_24 vdout0_24ck135 = 0 time = 1360
* CHECK dout0_25 vdout0_25ck135 = 3.3 time = 1360
* CHECK dout0_26 vdout0_26ck135 = 0 time = 1360
* CHECK dout0_27 vdout0_27ck135 = 0 time = 1360
* CHECK dout0_28 vdout0_28ck135 = 3.3 time = 1360
* CHECK dout0_29 vdout0_29ck135 = 0 time = 1360
* CHECK dout0_30 vdout0_30ck135 = 3.3 time = 1360
* CHECK dout0_31 vdout0_31ck135 = 3.3 time = 1360
* CHECK dout1_0 vdout1_0ck135 = 0 time = 1360
* CHECK dout1_1 vdout1_1ck135 = 0 time = 1360
* CHECK dout1_2 vdout1_2ck135 = 0 time = 1360
* CHECK dout1_3 vdout1_3ck135 = 0 time = 1360
* CHECK dout1_4 vdout1_4ck135 = 0 time = 1360
* CHECK dout1_5 vdout1_5ck135 = 0 time = 1360
* CHECK dout1_6 vdout1_6ck135 = 0 time = 1360
* CHECK dout1_7 vdout1_7ck135 = 3.3 time = 1360
* CHECK dout1_8 vdout1_8ck135 = 0 time = 1360
* CHECK dout1_9 vdout1_9ck135 = 0 time = 1360
* CHECK dout1_10 vdout1_10ck135 = 0 time = 1360
* CHECK dout1_11 vdout1_11ck135 = 0 time = 1360
* CHECK dout1_12 vdout1_12ck135 = 3.3 time = 1360
* CHECK dout1_13 vdout1_13ck135 = 0 time = 1360
* CHECK dout1_14 vdout1_14ck135 = 3.3 time = 1360
* CHECK dout1_15 vdout1_15ck135 = 0 time = 1360
* CHECK dout1_16 vdout1_16ck135 = 0 time = 1360
* CHECK dout1_17 vdout1_17ck135 = 0 time = 1360
* CHECK dout1_18 vdout1_18ck135 = 3.3 time = 1360
* CHECK dout1_19 vdout1_19ck135 = 0 time = 1360
* CHECK dout1_20 vdout1_20ck135 = 0 time = 1360
* CHECK dout1_21 vdout1_21ck135 = 0 time = 1360
* CHECK dout1_22 vdout1_22ck135 = 3.3 time = 1360
* CHECK dout1_23 vdout1_23ck135 = 0 time = 1360
* CHECK dout1_24 vdout1_24ck135 = 0 time = 1360
* CHECK dout1_25 vdout1_25ck135 = 3.3 time = 1360
* CHECK dout1_26 vdout1_26ck135 = 0 time = 1360
* CHECK dout1_27 vdout1_27ck135 = 0 time = 1360
* CHECK dout1_28 vdout1_28ck135 = 3.3 time = 1360
* CHECK dout1_29 vdout1_29ck135 = 0 time = 1360
* CHECK dout1_30 vdout1_30ck135 = 3.3 time = 1360
* CHECK dout1_31 vdout1_31ck135 = 3.3 time = 1360
* CHECK dout1_0 vdout1_0ck137 = 0 time = 1380
* CHECK dout1_1 vdout1_1ck137 = 0 time = 1380
* CHECK dout1_2 vdout1_2ck137 = 3.3 time = 1380
* CHECK dout1_3 vdout1_3ck137 = 3.3 time = 1380
* CHECK dout1_4 vdout1_4ck137 = 0 time = 1380
* CHECK dout1_5 vdout1_5ck137 = 0 time = 1380
* CHECK dout1_6 vdout1_6ck137 = 0 time = 1380
* CHECK dout1_7 vdout1_7ck137 = 3.3 time = 1380
* CHECK dout1_8 vdout1_8ck137 = 0 time = 1380
* CHECK dout1_9 vdout1_9ck137 = 0 time = 1380
* CHECK dout1_10 vdout1_10ck137 = 3.3 time = 1380
* CHECK dout1_11 vdout1_11ck137 = 0 time = 1380
* CHECK dout1_12 vdout1_12ck137 = 0 time = 1380
* CHECK dout1_13 vdout1_13ck137 = 3.3 time = 1380
* CHECK dout1_14 vdout1_14ck137 = 0 time = 1380
* CHECK dout1_15 vdout1_15ck137 = 0 time = 1380
* CHECK dout1_16 vdout1_16ck137 = 0 time = 1380
* CHECK dout1_17 vdout1_17ck137 = 0 time = 1380
* CHECK dout1_18 vdout1_18ck137 = 0 time = 1380
* CHECK dout1_19 vdout1_19ck137 = 3.3 time = 1380
* CHECK dout1_20 vdout1_20ck137 = 0 time = 1380
* CHECK dout1_21 vdout1_21ck137 = 0 time = 1380
* CHECK dout1_22 vdout1_22ck137 = 0 time = 1380
* CHECK dout1_23 vdout1_23ck137 = 3.3 time = 1380
* CHECK dout1_24 vdout1_24ck137 = 3.3 time = 1380
* CHECK dout1_25 vdout1_25ck137 = 3.3 time = 1380
* CHECK dout1_26 vdout1_26ck137 = 0 time = 1380
* CHECK dout1_27 vdout1_27ck137 = 3.3 time = 1380
* CHECK dout1_28 vdout1_28ck137 = 0 time = 1380
* CHECK dout1_29 vdout1_29ck137 = 0 time = 1380
* CHECK dout1_30 vdout1_30ck137 = 0 time = 1380
* CHECK dout1_31 vdout1_31ck137 = 3.3 time = 1380
* CHECK dout0_0 vdout0_0ck138 = 0 time = 1390
* CHECK dout0_1 vdout0_1ck138 = 0 time = 1390
* CHECK dout0_2 vdout0_2ck138 = 3.3 time = 1390
* CHECK dout0_3 vdout0_3ck138 = 3.3 time = 1390
* CHECK dout0_4 vdout0_4ck138 = 0 time = 1390
* CHECK dout0_5 vdout0_5ck138 = 0 time = 1390
* CHECK dout0_6 vdout0_6ck138 = 0 time = 1390
* CHECK dout0_7 vdout0_7ck138 = 3.3 time = 1390
* CHECK dout0_8 vdout0_8ck138 = 0 time = 1390
* CHECK dout0_9 vdout0_9ck138 = 0 time = 1390
* CHECK dout0_10 vdout0_10ck138 = 3.3 time = 1390
* CHECK dout0_11 vdout0_11ck138 = 0 time = 1390
* CHECK dout0_12 vdout0_12ck138 = 0 time = 1390
* CHECK dout0_13 vdout0_13ck138 = 3.3 time = 1390
* CHECK dout0_14 vdout0_14ck138 = 0 time = 1390
* CHECK dout0_15 vdout0_15ck138 = 0 time = 1390
* CHECK dout0_16 vdout0_16ck138 = 0 time = 1390
* CHECK dout0_17 vdout0_17ck138 = 0 time = 1390
* CHECK dout0_18 vdout0_18ck138 = 0 time = 1390
* CHECK dout0_19 vdout0_19ck138 = 3.3 time = 1390
* CHECK dout0_20 vdout0_20ck138 = 0 time = 1390
* CHECK dout0_21 vdout0_21ck138 = 0 time = 1390
* CHECK dout0_22 vdout0_22ck138 = 0 time = 1390
* CHECK dout0_23 vdout0_23ck138 = 3.3 time = 1390
* CHECK dout0_24 vdout0_24ck138 = 3.3 time = 1390
* CHECK dout0_25 vdout0_25ck138 = 3.3 time = 1390
* CHECK dout0_26 vdout0_26ck138 = 0 time = 1390
* CHECK dout0_27 vdout0_27ck138 = 3.3 time = 1390
* CHECK dout0_28 vdout0_28ck138 = 0 time = 1390
* CHECK dout0_29 vdout0_29ck138 = 0 time = 1390
* CHECK dout0_30 vdout0_30ck138 = 0 time = 1390
* CHECK dout0_31 vdout0_31ck138 = 3.3 time = 1390
* CHECK dout0_0 vdout0_0ck139 = 0 time = 1400
* CHECK dout0_1 vdout0_1ck139 = 3.3 time = 1400
* CHECK dout0_2 vdout0_2ck139 = 3.3 time = 1400
* CHECK dout0_3 vdout0_3ck139 = 0 time = 1400
* CHECK dout0_4 vdout0_4ck139 = 0 time = 1400
* CHECK dout0_5 vdout0_5ck139 = 3.3 time = 1400
* CHECK dout0_6 vdout0_6ck139 = 3.3 time = 1400
* CHECK dout0_7 vdout0_7ck139 = 0 time = 1400
* CHECK dout0_8 vdout0_8ck139 = 0 time = 1400
* CHECK dout0_9 vdout0_9ck139 = 3.3 time = 1400
* CHECK dout0_10 vdout0_10ck139 = 0 time = 1400
* CHECK dout0_11 vdout0_11ck139 = 3.3 time = 1400
* CHECK dout0_12 vdout0_12ck139 = 0 time = 1400
* CHECK dout0_13 vdout0_13ck139 = 3.3 time = 1400
* CHECK dout0_14 vdout0_14ck139 = 3.3 time = 1400
* CHECK dout0_15 vdout0_15ck139 = 3.3 time = 1400
* CHECK dout0_16 vdout0_16ck139 = 0 time = 1400
* CHECK dout0_17 vdout0_17ck139 = 3.3 time = 1400
* CHECK dout0_18 vdout0_18ck139 = 3.3 time = 1400
* CHECK dout0_19 vdout0_19ck139 = 0 time = 1400
* CHECK dout0_20 vdout0_20ck139 = 0 time = 1400
* CHECK dout0_21 vdout0_21ck139 = 0 time = 1400
* CHECK dout0_22 vdout0_22ck139 = 0 time = 1400
* CHECK dout0_23 vdout0_23ck139 = 0 time = 1400
* CHECK dout0_24 vdout0_24ck139 = 0 time = 1400
* CHECK dout0_25 vdout0_25ck139 = 3.3 time = 1400
* CHECK dout0_26 vdout0_26ck139 = 3.3 time = 1400
* CHECK dout0_27 vdout0_27ck139 = 0 time = 1400
* CHECK dout0_28 vdout0_28ck139 = 3.3 time = 1400
* CHECK dout0_29 vdout0_29ck139 = 0 time = 1400
* CHECK dout0_30 vdout0_30ck139 = 3.3 time = 1400
* CHECK dout0_31 vdout0_31ck139 = 3.3 time = 1400
* CHECK dout0_0 vdout0_0ck140 = 0 time = 1410
* CHECK dout0_1 vdout0_1ck140 = 3.3 time = 1410
* CHECK dout0_2 vdout0_2ck140 = 3.3 time = 1410
* CHECK dout0_3 vdout0_3ck140 = 0 time = 1410
* CHECK dout0_4 vdout0_4ck140 = 0 time = 1410
* CHECK dout0_5 vdout0_5ck140 = 3.3 time = 1410
* CHECK dout0_6 vdout0_6ck140 = 3.3 time = 1410
* CHECK dout0_7 vdout0_7ck140 = 0 time = 1410
* CHECK dout0_8 vdout0_8ck140 = 0 time = 1410
* CHECK dout0_9 vdout0_9ck140 = 3.3 time = 1410
* CHECK dout0_10 vdout0_10ck140 = 0 time = 1410
* CHECK dout0_11 vdout0_11ck140 = 3.3 time = 1410
* CHECK dout0_12 vdout0_12ck140 = 0 time = 1410
* CHECK dout0_13 vdout0_13ck140 = 3.3 time = 1410
* CHECK dout0_14 vdout0_14ck140 = 3.3 time = 1410
* CHECK dout0_15 vdout0_15ck140 = 3.3 time = 1410
* CHECK dout0_16 vdout0_16ck140 = 0 time = 1410
* CHECK dout0_17 vdout0_17ck140 = 3.3 time = 1410
* CHECK dout0_18 vdout0_18ck140 = 3.3 time = 1410
* CHECK dout0_19 vdout0_19ck140 = 0 time = 1410
* CHECK dout0_20 vdout0_20ck140 = 0 time = 1410
* CHECK dout0_21 vdout0_21ck140 = 0 time = 1410
* CHECK dout0_22 vdout0_22ck140 = 0 time = 1410
* CHECK dout0_23 vdout0_23ck140 = 0 time = 1410
* CHECK dout0_24 vdout0_24ck140 = 0 time = 1410
* CHECK dout0_25 vdout0_25ck140 = 3.3 time = 1410
* CHECK dout0_26 vdout0_26ck140 = 3.3 time = 1410
* CHECK dout0_27 vdout0_27ck140 = 0 time = 1410
* CHECK dout0_28 vdout0_28ck140 = 3.3 time = 1410
* CHECK dout0_29 vdout0_29ck140 = 0 time = 1410
* CHECK dout0_30 vdout0_30ck140 = 3.3 time = 1410
* CHECK dout0_31 vdout0_31ck140 = 3.3 time = 1410
* CHECK dout1_0 vdout1_0ck140 = 3.3 time = 1410
* CHECK dout1_1 vdout1_1ck140 = 0 time = 1410
* CHECK dout1_2 vdout1_2ck140 = 3.3 time = 1410
* CHECK dout1_3 vdout1_3ck140 = 3.3 time = 1410
* CHECK dout1_4 vdout1_4ck140 = 3.3 time = 1410
* CHECK dout1_5 vdout1_5ck140 = 3.3 time = 1410
* CHECK dout1_6 vdout1_6ck140 = 3.3 time = 1410
* CHECK dout1_7 vdout1_7ck140 = 3.3 time = 1410
* CHECK dout1_8 vdout1_8ck140 = 3.3 time = 1410
* CHECK dout1_9 vdout1_9ck140 = 0 time = 1410
* CHECK dout1_10 vdout1_10ck140 = 3.3 time = 1410
* CHECK dout1_11 vdout1_11ck140 = 3.3 time = 1410
* CHECK dout1_12 vdout1_12ck140 = 0 time = 1410
* CHECK dout1_13 vdout1_13ck140 = 3.3 time = 1410
* CHECK dout1_14 vdout1_14ck140 = 0 time = 1410
* CHECK dout1_15 vdout1_15ck140 = 0 time = 1410
* CHECK dout1_16 vdout1_16ck140 = 0 time = 1410
* CHECK dout1_17 vdout1_17ck140 = 0 time = 1410
* CHECK dout1_18 vdout1_18ck140 = 0 time = 1410
* CHECK dout1_19 vdout1_19ck140 = 0 time = 1410
* CHECK dout1_20 vdout1_20ck140 = 3.3 time = 1410
* CHECK dout1_21 vdout1_21ck140 = 3.3 time = 1410
* CHECK dout1_22 vdout1_22ck140 = 0 time = 1410
* CHECK dout1_23 vdout1_23ck140 = 0 time = 1410
* CHECK dout1_24 vdout1_24ck140 = 0 time = 1410
* CHECK dout1_25 vdout1_25ck140 = 3.3 time = 1410
* CHECK dout1_26 vdout1_26ck140 = 0 time = 1410
* CHECK dout1_27 vdout1_27ck140 = 3.3 time = 1410
* CHECK dout1_28 vdout1_28ck140 = 3.3 time = 1410
* CHECK dout1_29 vdout1_29ck140 = 0 time = 1410
* CHECK dout1_30 vdout1_30ck140 = 0 time = 1410
* CHECK dout1_31 vdout1_31ck140 = 3.3 time = 1410
* CHECK dout1_0 vdout1_0ck141 = 3.3 time = 1420
* CHECK dout1_1 vdout1_1ck141 = 0 time = 1420
* CHECK dout1_2 vdout1_2ck141 = 3.3 time = 1420
* CHECK dout1_3 vdout1_3ck141 = 3.3 time = 1420
* CHECK dout1_4 vdout1_4ck141 = 3.3 time = 1420
* CHECK dout1_5 vdout1_5ck141 = 3.3 time = 1420
* CHECK dout1_6 vdout1_6ck141 = 3.3 time = 1420
* CHECK dout1_7 vdout1_7ck141 = 3.3 time = 1420
* CHECK dout1_8 vdout1_8ck141 = 3.3 time = 1420
* CHECK dout1_9 vdout1_9ck141 = 0 time = 1420
* CHECK dout1_10 vdout1_10ck141 = 3.3 time = 1420
* CHECK dout1_11 vdout1_11ck141 = 3.3 time = 1420
* CHECK dout1_12 vdout1_12ck141 = 0 time = 1420
* CHECK dout1_13 vdout1_13ck141 = 3.3 time = 1420
* CHECK dout1_14 vdout1_14ck141 = 0 time = 1420
* CHECK dout1_15 vdout1_15ck141 = 0 time = 1420
* CHECK dout1_16 vdout1_16ck141 = 0 time = 1420
* CHECK dout1_17 vdout1_17ck141 = 0 time = 1420
* CHECK dout1_18 vdout1_18ck141 = 0 time = 1420
* CHECK dout1_19 vdout1_19ck141 = 0 time = 1420
* CHECK dout1_20 vdout1_20ck141 = 3.3 time = 1420
* CHECK dout1_21 vdout1_21ck141 = 3.3 time = 1420
* CHECK dout1_22 vdout1_22ck141 = 0 time = 1420
* CHECK dout1_23 vdout1_23ck141 = 0 time = 1420
* CHECK dout1_24 vdout1_24ck141 = 0 time = 1420
* CHECK dout1_25 vdout1_25ck141 = 3.3 time = 1420
* CHECK dout1_26 vdout1_26ck141 = 0 time = 1420
* CHECK dout1_27 vdout1_27ck141 = 3.3 time = 1420
* CHECK dout1_28 vdout1_28ck141 = 3.3 time = 1420
* CHECK dout1_29 vdout1_29ck141 = 0 time = 1420
* CHECK dout1_30 vdout1_30ck141 = 0 time = 1420
* CHECK dout1_31 vdout1_31ck141 = 3.3 time = 1420
* CHECK dout0_0 vdout0_0ck142 = 3.3 time = 1430
* CHECK dout0_1 vdout0_1ck142 = 0 time = 1430
* CHECK dout0_2 vdout0_2ck142 = 3.3 time = 1430
* CHECK dout0_3 vdout0_3ck142 = 3.3 time = 1430
* CHECK dout0_4 vdout0_4ck142 = 3.3 time = 1430
* CHECK dout0_5 vdout0_5ck142 = 3.3 time = 1430
* CHECK dout0_6 vdout0_6ck142 = 3.3 time = 1430
* CHECK dout0_7 vdout0_7ck142 = 3.3 time = 1430
* CHECK dout0_8 vdout0_8ck142 = 3.3 time = 1430
* CHECK dout0_9 vdout0_9ck142 = 0 time = 1430
* CHECK dout0_10 vdout0_10ck142 = 3.3 time = 1430
* CHECK dout0_11 vdout0_11ck142 = 3.3 time = 1430
* CHECK dout0_12 vdout0_12ck142 = 0 time = 1430
* CHECK dout0_13 vdout0_13ck142 = 3.3 time = 1430
* CHECK dout0_14 vdout0_14ck142 = 0 time = 1430
* CHECK dout0_15 vdout0_15ck142 = 0 time = 1430
* CHECK dout0_16 vdout0_16ck142 = 0 time = 1430
* CHECK dout0_17 vdout0_17ck142 = 0 time = 1430
* CHECK dout0_18 vdout0_18ck142 = 0 time = 1430
* CHECK dout0_19 vdout0_19ck142 = 0 time = 1430
* CHECK dout0_20 vdout0_20ck142 = 3.3 time = 1430
* CHECK dout0_21 vdout0_21ck142 = 3.3 time = 1430
* CHECK dout0_22 vdout0_22ck142 = 0 time = 1430
* CHECK dout0_23 vdout0_23ck142 = 0 time = 1430
* CHECK dout0_24 vdout0_24ck142 = 0 time = 1430
* CHECK dout0_25 vdout0_25ck142 = 3.3 time = 1430
* CHECK dout0_26 vdout0_26ck142 = 0 time = 1430
* CHECK dout0_27 vdout0_27ck142 = 3.3 time = 1430
* CHECK dout0_28 vdout0_28ck142 = 3.3 time = 1430
* CHECK dout0_29 vdout0_29ck142 = 0 time = 1430
* CHECK dout0_30 vdout0_30ck142 = 0 time = 1430
* CHECK dout0_31 vdout0_31ck142 = 3.3 time = 1430
* CHECK dout1_0 vdout1_0ck142 = 0 time = 1430
* CHECK dout1_1 vdout1_1ck142 = 3.3 time = 1430
* CHECK dout1_2 vdout1_2ck142 = 3.3 time = 1430
* CHECK dout1_3 vdout1_3ck142 = 0 time = 1430
* CHECK dout1_4 vdout1_4ck142 = 0 time = 1430
* CHECK dout1_5 vdout1_5ck142 = 3.3 time = 1430
* CHECK dout1_6 vdout1_6ck142 = 3.3 time = 1430
* CHECK dout1_7 vdout1_7ck142 = 0 time = 1430
* CHECK dout1_8 vdout1_8ck142 = 0 time = 1430
* CHECK dout1_9 vdout1_9ck142 = 3.3 time = 1430
* CHECK dout1_10 vdout1_10ck142 = 0 time = 1430
* CHECK dout1_11 vdout1_11ck142 = 3.3 time = 1430
* CHECK dout1_12 vdout1_12ck142 = 0 time = 1430
* CHECK dout1_13 vdout1_13ck142 = 3.3 time = 1430
* CHECK dout1_14 vdout1_14ck142 = 3.3 time = 1430
* CHECK dout1_15 vdout1_15ck142 = 3.3 time = 1430
* CHECK dout1_16 vdout1_16ck142 = 0 time = 1430
* CHECK dout1_17 vdout1_17ck142 = 3.3 time = 1430
* CHECK dout1_18 vdout1_18ck142 = 3.3 time = 1430
* CHECK dout1_19 vdout1_19ck142 = 0 time = 1430
* CHECK dout1_20 vdout1_20ck142 = 0 time = 1430
* CHECK dout1_21 vdout1_21ck142 = 0 time = 1430
* CHECK dout1_22 vdout1_22ck142 = 0 time = 1430
* CHECK dout1_23 vdout1_23ck142 = 0 time = 1430
* CHECK dout1_24 vdout1_24ck142 = 0 time = 1430
* CHECK dout1_25 vdout1_25ck142 = 3.3 time = 1430
* CHECK dout1_26 vdout1_26ck142 = 3.3 time = 1430
* CHECK dout1_27 vdout1_27ck142 = 0 time = 1430
* CHECK dout1_28 vdout1_28ck142 = 3.3 time = 1430
* CHECK dout1_29 vdout1_29ck142 = 0 time = 1430
* CHECK dout1_30 vdout1_30ck142 = 3.3 time = 1430
* CHECK dout1_31 vdout1_31ck142 = 3.3 time = 1430
* CHECK dout0_0 vdout0_0ck143 = 3.3 time = 1440
* CHECK dout0_1 vdout0_1ck143 = 0 time = 1440
* CHECK dout0_2 vdout0_2ck143 = 3.3 time = 1440
* CHECK dout0_3 vdout0_3ck143 = 3.3 time = 1440
* CHECK dout0_4 vdout0_4ck143 = 3.3 time = 1440
* CHECK dout0_5 vdout0_5ck143 = 3.3 time = 1440
* CHECK dout0_6 vdout0_6ck143 = 3.3 time = 1440
* CHECK dout0_7 vdout0_7ck143 = 3.3 time = 1440
* CHECK dout0_8 vdout0_8ck143 = 3.3 time = 1440
* CHECK dout0_9 vdout0_9ck143 = 0 time = 1440
* CHECK dout0_10 vdout0_10ck143 = 3.3 time = 1440
* CHECK dout0_11 vdout0_11ck143 = 3.3 time = 1440
* CHECK dout0_12 vdout0_12ck143 = 0 time = 1440
* CHECK dout0_13 vdout0_13ck143 = 3.3 time = 1440
* CHECK dout0_14 vdout0_14ck143 = 0 time = 1440
* CHECK dout0_15 vdout0_15ck143 = 0 time = 1440
* CHECK dout0_16 vdout0_16ck143 = 0 time = 1440
* CHECK dout0_17 vdout0_17ck143 = 0 time = 1440
* CHECK dout0_18 vdout0_18ck143 = 0 time = 1440
* CHECK dout0_19 vdout0_19ck143 = 0 time = 1440
* CHECK dout0_20 vdout0_20ck143 = 3.3 time = 1440
* CHECK dout0_21 vdout0_21ck143 = 3.3 time = 1440
* CHECK dout0_22 vdout0_22ck143 = 0 time = 1440
* CHECK dout0_23 vdout0_23ck143 = 0 time = 1440
* CHECK dout0_24 vdout0_24ck143 = 0 time = 1440
* CHECK dout0_25 vdout0_25ck143 = 3.3 time = 1440
* CHECK dout0_26 vdout0_26ck143 = 0 time = 1440
* CHECK dout0_27 vdout0_27ck143 = 3.3 time = 1440
* CHECK dout0_28 vdout0_28ck143 = 3.3 time = 1440
* CHECK dout0_29 vdout0_29ck143 = 0 time = 1440
* CHECK dout0_30 vdout0_30ck143 = 0 time = 1440
* CHECK dout0_31 vdout0_31ck143 = 3.3 time = 1440
* CHECK dout0_0 vdout0_0ck145 = 3.3 time = 1460
* CHECK dout0_1 vdout0_1ck145 = 0 time = 1460
* CHECK dout0_2 vdout0_2ck145 = 3.3 time = 1460
* CHECK dout0_3 vdout0_3ck145 = 3.3 time = 1460
* CHECK dout0_4 vdout0_4ck145 = 3.3 time = 1460
* CHECK dout0_5 vdout0_5ck145 = 0 time = 1460
* CHECK dout0_6 vdout0_6ck145 = 3.3 time = 1460
* CHECK dout0_7 vdout0_7ck145 = 0 time = 1460
* CHECK dout0_8 vdout0_8ck145 = 0 time = 1460
* CHECK dout0_9 vdout0_9ck145 = 3.3 time = 1460
* CHECK dout0_10 vdout0_10ck145 = 0 time = 1460
* CHECK dout0_11 vdout0_11ck145 = 0 time = 1460
* CHECK dout0_12 vdout0_12ck145 = 3.3 time = 1460
* CHECK dout0_13 vdout0_13ck145 = 3.3 time = 1460
* CHECK dout0_14 vdout0_14ck145 = 3.3 time = 1460
* CHECK dout0_15 vdout0_15ck145 = 0 time = 1460
* CHECK dout0_16 vdout0_16ck145 = 0 time = 1460
* CHECK dout0_17 vdout0_17ck145 = 0 time = 1460
* CHECK dout0_18 vdout0_18ck145 = 0 time = 1460
* CHECK dout0_19 vdout0_19ck145 = 0 time = 1460
* CHECK dout0_20 vdout0_20ck145 = 3.3 time = 1460
* CHECK dout0_21 vdout0_21ck145 = 0 time = 1460
* CHECK dout0_22 vdout0_22ck145 = 0 time = 1460
* CHECK dout0_23 vdout0_23ck145 = 3.3 time = 1460
* CHECK dout0_24 vdout0_24ck145 = 0 time = 1460
* CHECK dout0_25 vdout0_25ck145 = 3.3 time = 1460
* CHECK dout0_26 vdout0_26ck145 = 3.3 time = 1460
* CHECK dout0_27 vdout0_27ck145 = 3.3 time = 1460
* CHECK dout0_28 vdout0_28ck145 = 0 time = 1460
* CHECK dout0_29 vdout0_29ck145 = 3.3 time = 1460
* CHECK dout0_30 vdout0_30ck145 = 0 time = 1460
* CHECK dout0_31 vdout0_31ck145 = 0 time = 1460
* CHECK dout1_0 vdout1_0ck145 = 3.3 time = 1460
* CHECK dout1_1 vdout1_1ck145 = 0 time = 1460
* CHECK dout1_2 vdout1_2ck145 = 3.3 time = 1460
* CHECK dout1_3 vdout1_3ck145 = 3.3 time = 1460
* CHECK dout1_4 vdout1_4ck145 = 3.3 time = 1460
* CHECK dout1_5 vdout1_5ck145 = 0 time = 1460
* CHECK dout1_6 vdout1_6ck145 = 3.3 time = 1460
* CHECK dout1_7 vdout1_7ck145 = 0 time = 1460
* CHECK dout1_8 vdout1_8ck145 = 0 time = 1460
* CHECK dout1_9 vdout1_9ck145 = 3.3 time = 1460
* CHECK dout1_10 vdout1_10ck145 = 0 time = 1460
* CHECK dout1_11 vdout1_11ck145 = 0 time = 1460
* CHECK dout1_12 vdout1_12ck145 = 3.3 time = 1460
* CHECK dout1_13 vdout1_13ck145 = 3.3 time = 1460
* CHECK dout1_14 vdout1_14ck145 = 3.3 time = 1460
* CHECK dout1_15 vdout1_15ck145 = 0 time = 1460
* CHECK dout1_16 vdout1_16ck145 = 0 time = 1460
* CHECK dout1_17 vdout1_17ck145 = 0 time = 1460
* CHECK dout1_18 vdout1_18ck145 = 0 time = 1460
* CHECK dout1_19 vdout1_19ck145 = 0 time = 1460
* CHECK dout1_20 vdout1_20ck145 = 3.3 time = 1460
* CHECK dout1_21 vdout1_21ck145 = 0 time = 1460
* CHECK dout1_22 vdout1_22ck145 = 0 time = 1460
* CHECK dout1_23 vdout1_23ck145 = 3.3 time = 1460
* CHECK dout1_24 vdout1_24ck145 = 0 time = 1460
* CHECK dout1_25 vdout1_25ck145 = 3.3 time = 1460
* CHECK dout1_26 vdout1_26ck145 = 3.3 time = 1460
* CHECK dout1_27 vdout1_27ck145 = 3.3 time = 1460
* CHECK dout1_28 vdout1_28ck145 = 0 time = 1460
* CHECK dout1_29 vdout1_29ck145 = 3.3 time = 1460
* CHECK dout1_30 vdout1_30ck145 = 0 time = 1460
* CHECK dout1_31 vdout1_31ck145 = 0 time = 1460
* CHECK dout0_0 vdout0_0ck147 = 3.3 time = 1480
* CHECK dout0_1 vdout0_1ck147 = 3.3 time = 1480
* CHECK dout0_2 vdout0_2ck147 = 3.3 time = 1480
* CHECK dout0_3 vdout0_3ck147 = 0 time = 1480
* CHECK dout0_4 vdout0_4ck147 = 3.3 time = 1480
* CHECK dout0_5 vdout0_5ck147 = 3.3 time = 1480
* CHECK dout0_6 vdout0_6ck147 = 0 time = 1480
* CHECK dout0_7 vdout0_7ck147 = 0 time = 1480
* CHECK dout0_8 vdout0_8ck147 = 3.3 time = 1480
* CHECK dout0_9 vdout0_9ck147 = 0 time = 1480
* CHECK dout0_10 vdout0_10ck147 = 3.3 time = 1480
* CHECK dout0_11 vdout0_11ck147 = 3.3 time = 1480
* CHECK dout0_12 vdout0_12ck147 = 0 time = 1480
* CHECK dout0_13 vdout0_13ck147 = 0 time = 1480
* CHECK dout0_14 vdout0_14ck147 = 3.3 time = 1480
* CHECK dout0_15 vdout0_15ck147 = 0 time = 1480
* CHECK dout0_16 vdout0_16ck147 = 0 time = 1480
* CHECK dout0_17 vdout0_17ck147 = 0 time = 1480
* CHECK dout0_18 vdout0_18ck147 = 3.3 time = 1480
* CHECK dout0_19 vdout0_19ck147 = 3.3 time = 1480
* CHECK dout0_20 vdout0_20ck147 = 0 time = 1480
* CHECK dout0_21 vdout0_21ck147 = 0 time = 1480
* CHECK dout0_22 vdout0_22ck147 = 3.3 time = 1480
* CHECK dout0_23 vdout0_23ck147 = 3.3 time = 1480
* CHECK dout0_24 vdout0_24ck147 = 3.3 time = 1480
* CHECK dout0_25 vdout0_25ck147 = 0 time = 1480
* CHECK dout0_26 vdout0_26ck147 = 3.3 time = 1480
* CHECK dout0_27 vdout0_27ck147 = 0 time = 1480
* CHECK dout0_28 vdout0_28ck147 = 3.3 time = 1480
* CHECK dout0_29 vdout0_29ck147 = 0 time = 1480
* CHECK dout0_30 vdout0_30ck147 = 0 time = 1480
* CHECK dout0_31 vdout0_31ck147 = 3.3 time = 1480
* CHECK dout0_0 vdout0_0ck148 = 3.3 time = 1490
* CHECK dout0_1 vdout0_1ck148 = 0 time = 1490
* CHECK dout0_2 vdout0_2ck148 = 0 time = 1490
* CHECK dout0_3 vdout0_3ck148 = 0 time = 1490
* CHECK dout0_4 vdout0_4ck148 = 0 time = 1490
* CHECK dout0_5 vdout0_5ck148 = 0 time = 1490
* CHECK dout0_6 vdout0_6ck148 = 3.3 time = 1490
* CHECK dout0_7 vdout0_7ck148 = 0 time = 1490
* CHECK dout0_8 vdout0_8ck148 = 0 time = 1490
* CHECK dout0_9 vdout0_9ck148 = 3.3 time = 1490
* CHECK dout0_10 vdout0_10ck148 = 3.3 time = 1490
* CHECK dout0_11 vdout0_11ck148 = 0 time = 1490
* CHECK dout0_12 vdout0_12ck148 = 0 time = 1490
* CHECK dout0_13 vdout0_13ck148 = 3.3 time = 1490
* CHECK dout0_14 vdout0_14ck148 = 3.3 time = 1490
* CHECK dout0_15 vdout0_15ck148 = 0 time = 1490
* CHECK dout0_16 vdout0_16ck148 = 3.3 time = 1490
* CHECK dout0_17 vdout0_17ck148 = 3.3 time = 1490
* CHECK dout0_18 vdout0_18ck148 = 3.3 time = 1490
* CHECK dout0_19 vdout0_19ck148 = 3.3 time = 1490
* CHECK dout0_20 vdout0_20ck148 = 3.3 time = 1490
* CHECK dout0_21 vdout0_21ck148 = 0 time = 1490
* CHECK dout0_22 vdout0_22ck148 = 3.3 time = 1490
* CHECK dout0_23 vdout0_23ck148 = 0 time = 1490
* CHECK dout0_24 vdout0_24ck148 = 0 time = 1490
* CHECK dout0_25 vdout0_25ck148 = 0 time = 1490
* CHECK dout0_26 vdout0_26ck148 = 3.3 time = 1490
* CHECK dout0_27 vdout0_27ck148 = 3.3 time = 1490
* CHECK dout0_28 vdout0_28ck148 = 3.3 time = 1490
* CHECK dout0_29 vdout0_29ck148 = 3.3 time = 1490
* CHECK dout0_30 vdout0_30ck148 = 3.3 time = 1490
* CHECK dout0_31 vdout0_31ck148 = 0 time = 1490
* CHECK dout0_0 vdout0_0ck149 = 3.3 time = 1500
* CHECK dout0_1 vdout0_1ck149 = 0 time = 1500
* CHECK dout0_2 vdout0_2ck149 = 0 time = 1500
* CHECK dout0_3 vdout0_3ck149 = 0 time = 1500
* CHECK dout0_4 vdout0_4ck149 = 0 time = 1500
* CHECK dout0_5 vdout0_5ck149 = 0 time = 1500
* CHECK dout0_6 vdout0_6ck149 = 3.3 time = 1500
* CHECK dout0_7 vdout0_7ck149 = 0 time = 1500
* CHECK dout0_8 vdout0_8ck149 = 0 time = 1500
* CHECK dout0_9 vdout0_9ck149 = 3.3 time = 1500
* CHECK dout0_10 vdout0_10ck149 = 3.3 time = 1500
* CHECK dout0_11 vdout0_11ck149 = 0 time = 1500
* CHECK dout0_12 vdout0_12ck149 = 0 time = 1500
* CHECK dout0_13 vdout0_13ck149 = 3.3 time = 1500
* CHECK dout0_14 vdout0_14ck149 = 3.3 time = 1500
* CHECK dout0_15 vdout0_15ck149 = 0 time = 1500
* CHECK dout0_16 vdout0_16ck149 = 3.3 time = 1500
* CHECK dout0_17 vdout0_17ck149 = 3.3 time = 1500
* CHECK dout0_18 vdout0_18ck149 = 3.3 time = 1500
* CHECK dout0_19 vdout0_19ck149 = 3.3 time = 1500
* CHECK dout0_20 vdout0_20ck149 = 3.3 time = 1500
* CHECK dout0_21 vdout0_21ck149 = 0 time = 1500
* CHECK dout0_22 vdout0_22ck149 = 3.3 time = 1500
* CHECK dout0_23 vdout0_23ck149 = 0 time = 1500
* CHECK dout0_24 vdout0_24ck149 = 0 time = 1500
* CHECK dout0_25 vdout0_25ck149 = 0 time = 1500
* CHECK dout0_26 vdout0_26ck149 = 3.3 time = 1500
* CHECK dout0_27 vdout0_27ck149 = 3.3 time = 1500
* CHECK dout0_28 vdout0_28ck149 = 3.3 time = 1500
* CHECK dout0_29 vdout0_29ck149 = 3.3 time = 1500
* CHECK dout0_30 vdout0_30ck149 = 3.3 time = 1500
* CHECK dout0_31 vdout0_31ck149 = 0 time = 1500
* CHECK dout1_0 vdout1_0ck149 = 3.3 time = 1500
* CHECK dout1_1 vdout1_1ck149 = 0 time = 1500
* CHECK dout1_2 vdout1_2ck149 = 0 time = 1500
* CHECK dout1_3 vdout1_3ck149 = 0 time = 1500
* CHECK dout1_4 vdout1_4ck149 = 0 time = 1500
* CHECK dout1_5 vdout1_5ck149 = 3.3 time = 1500
* CHECK dout1_6 vdout1_6ck149 = 3.3 time = 1500
* CHECK dout1_7 vdout1_7ck149 = 3.3 time = 1500
* CHECK dout1_8 vdout1_8ck149 = 0 time = 1500
* CHECK dout1_9 vdout1_9ck149 = 0 time = 1500
* CHECK dout1_10 vdout1_10ck149 = 3.3 time = 1500
* CHECK dout1_11 vdout1_11ck149 = 3.3 time = 1500
* CHECK dout1_12 vdout1_12ck149 = 3.3 time = 1500
* CHECK dout1_13 vdout1_13ck149 = 0 time = 1500
* CHECK dout1_14 vdout1_14ck149 = 0 time = 1500
* CHECK dout1_15 vdout1_15ck149 = 3.3 time = 1500
* CHECK dout1_16 vdout1_16ck149 = 0 time = 1500
* CHECK dout1_17 vdout1_17ck149 = 0 time = 1500
* CHECK dout1_18 vdout1_18ck149 = 0 time = 1500
* CHECK dout1_19 vdout1_19ck149 = 0 time = 1500
* CHECK dout1_20 vdout1_20ck149 = 0 time = 1500
* CHECK dout1_21 vdout1_21ck149 = 0 time = 1500
* CHECK dout1_22 vdout1_22ck149 = 3.3 time = 1500
* CHECK dout1_23 vdout1_23ck149 = 0 time = 1500
* CHECK dout1_24 vdout1_24ck149 = 3.3 time = 1500
* CHECK dout1_25 vdout1_25ck149 = 0 time = 1500
* CHECK dout1_26 vdout1_26ck149 = 0 time = 1500
* CHECK dout1_27 vdout1_27ck149 = 3.3 time = 1500
* CHECK dout1_28 vdout1_28ck149 = 3.3 time = 1500
* CHECK dout1_29 vdout1_29ck149 = 0 time = 1500
* CHECK dout1_30 vdout1_30ck149 = 0 time = 1500
* CHECK dout1_31 vdout1_31ck149 = 0 time = 1500
* CHECK dout0_0 vdout0_0ck152 = 3.3 time = 1530
* CHECK dout0_1 vdout0_1ck152 = 0 time = 1530
* CHECK dout0_2 vdout0_2ck152 = 0 time = 1530
* CHECK dout0_3 vdout0_3ck152 = 0 time = 1530
* CHECK dout0_4 vdout0_4ck152 = 0 time = 1530
* CHECK dout0_5 vdout0_5ck152 = 3.3 time = 1530
* CHECK dout0_6 vdout0_6ck152 = 3.3 time = 1530
* CHECK dout0_7 vdout0_7ck152 = 3.3 time = 1530
* CHECK dout0_8 vdout0_8ck152 = 0 time = 1530
* CHECK dout0_9 vdout0_9ck152 = 0 time = 1530
* CHECK dout0_10 vdout0_10ck152 = 3.3 time = 1530
* CHECK dout0_11 vdout0_11ck152 = 3.3 time = 1530
* CHECK dout0_12 vdout0_12ck152 = 3.3 time = 1530
* CHECK dout0_13 vdout0_13ck152 = 0 time = 1530
* CHECK dout0_14 vdout0_14ck152 = 0 time = 1530
* CHECK dout0_15 vdout0_15ck152 = 3.3 time = 1530
* CHECK dout0_16 vdout0_16ck152 = 0 time = 1530
* CHECK dout0_17 vdout0_17ck152 = 0 time = 1530
* CHECK dout0_18 vdout0_18ck152 = 0 time = 1530
* CHECK dout0_19 vdout0_19ck152 = 0 time = 1530
* CHECK dout0_20 vdout0_20ck152 = 0 time = 1530
* CHECK dout0_21 vdout0_21ck152 = 0 time = 1530
* CHECK dout0_22 vdout0_22ck152 = 3.3 time = 1530
* CHECK dout0_23 vdout0_23ck152 = 0 time = 1530
* CHECK dout0_24 vdout0_24ck152 = 3.3 time = 1530
* CHECK dout0_25 vdout0_25ck152 = 0 time = 1530
* CHECK dout0_26 vdout0_26ck152 = 0 time = 1530
* CHECK dout0_27 vdout0_27ck152 = 3.3 time = 1530
* CHECK dout0_28 vdout0_28ck152 = 3.3 time = 1530
* CHECK dout0_29 vdout0_29ck152 = 0 time = 1530
* CHECK dout0_30 vdout0_30ck152 = 0 time = 1530
* CHECK dout0_31 vdout0_31ck152 = 0 time = 1530
* CHECK dout1_0 vdout1_0ck153 = 3.3 time = 1540
* CHECK dout1_1 vdout1_1ck153 = 0 time = 1540
* CHECK dout1_2 vdout1_2ck153 = 0 time = 1540
* CHECK dout1_3 vdout1_3ck153 = 0 time = 1540
* CHECK dout1_4 vdout1_4ck153 = 0 time = 1540
* CHECK dout1_5 vdout1_5ck153 = 3.3 time = 1540
* CHECK dout1_6 vdout1_6ck153 = 3.3 time = 1540
* CHECK dout1_7 vdout1_7ck153 = 3.3 time = 1540
* CHECK dout1_8 vdout1_8ck153 = 0 time = 1540
* CHECK dout1_9 vdout1_9ck153 = 0 time = 1540
* CHECK dout1_10 vdout1_10ck153 = 3.3 time = 1540
* CHECK dout1_11 vdout1_11ck153 = 3.3 time = 1540
* CHECK dout1_12 vdout1_12ck153 = 3.3 time = 1540
* CHECK dout1_13 vdout1_13ck153 = 0 time = 1540
* CHECK dout1_14 vdout1_14ck153 = 0 time = 1540
* CHECK dout1_15 vdout1_15ck153 = 3.3 time = 1540
* CHECK dout1_16 vdout1_16ck153 = 0 time = 1540
* CHECK dout1_17 vdout1_17ck153 = 0 time = 1540
* CHECK dout1_18 vdout1_18ck153 = 0 time = 1540
* CHECK dout1_19 vdout1_19ck153 = 0 time = 1540
* CHECK dout1_20 vdout1_20ck153 = 0 time = 1540
* CHECK dout1_21 vdout1_21ck153 = 0 time = 1540
* CHECK dout1_22 vdout1_22ck153 = 3.3 time = 1540
* CHECK dout1_23 vdout1_23ck153 = 0 time = 1540
* CHECK dout1_24 vdout1_24ck153 = 3.3 time = 1540
* CHECK dout1_25 vdout1_25ck153 = 0 time = 1540
* CHECK dout1_26 vdout1_26ck153 = 0 time = 1540
* CHECK dout1_27 vdout1_27ck153 = 3.3 time = 1540
* CHECK dout1_28 vdout1_28ck153 = 3.3 time = 1540
* CHECK dout1_29 vdout1_29ck153 = 0 time = 1540
* CHECK dout1_30 vdout1_30ck153 = 0 time = 1540
* CHECK dout1_31 vdout1_31ck153 = 0 time = 1540
* CHECK dout0_0 vdout0_0ck154 = 3.3 time = 1550
* CHECK dout0_1 vdout0_1ck154 = 0 time = 1550
* CHECK dout0_2 vdout0_2ck154 = 0 time = 1550
* CHECK dout0_3 vdout0_3ck154 = 0 time = 1550
* CHECK dout0_4 vdout0_4ck154 = 0 time = 1550
* CHECK dout0_5 vdout0_5ck154 = 3.3 time = 1550
* CHECK dout0_6 vdout0_6ck154 = 3.3 time = 1550
* CHECK dout0_7 vdout0_7ck154 = 3.3 time = 1550
* CHECK dout0_8 vdout0_8ck154 = 0 time = 1550
* CHECK dout0_9 vdout0_9ck154 = 0 time = 1550
* CHECK dout0_10 vdout0_10ck154 = 3.3 time = 1550
* CHECK dout0_11 vdout0_11ck154 = 3.3 time = 1550
* CHECK dout0_12 vdout0_12ck154 = 3.3 time = 1550
* CHECK dout0_13 vdout0_13ck154 = 0 time = 1550
* CHECK dout0_14 vdout0_14ck154 = 0 time = 1550
* CHECK dout0_15 vdout0_15ck154 = 3.3 time = 1550
* CHECK dout0_16 vdout0_16ck154 = 0 time = 1550
* CHECK dout0_17 vdout0_17ck154 = 0 time = 1550
* CHECK dout0_18 vdout0_18ck154 = 0 time = 1550
* CHECK dout0_19 vdout0_19ck154 = 0 time = 1550
* CHECK dout0_20 vdout0_20ck154 = 0 time = 1550
* CHECK dout0_21 vdout0_21ck154 = 0 time = 1550
* CHECK dout0_22 vdout0_22ck154 = 3.3 time = 1550
* CHECK dout0_23 vdout0_23ck154 = 0 time = 1550
* CHECK dout0_24 vdout0_24ck154 = 3.3 time = 1550
* CHECK dout0_25 vdout0_25ck154 = 0 time = 1550
* CHECK dout0_26 vdout0_26ck154 = 0 time = 1550
* CHECK dout0_27 vdout0_27ck154 = 3.3 time = 1550
* CHECK dout0_28 vdout0_28ck154 = 3.3 time = 1550
* CHECK dout0_29 vdout0_29ck154 = 0 time = 1550
* CHECK dout0_30 vdout0_30ck154 = 0 time = 1550
* CHECK dout0_31 vdout0_31ck154 = 0 time = 1550
* CHECK dout1_0 vdout1_0ck154 = 3.3 time = 1550
* CHECK dout1_1 vdout1_1ck154 = 0 time = 1550
* CHECK dout1_2 vdout1_2ck154 = 0 time = 1550
* CHECK dout1_3 vdout1_3ck154 = 0 time = 1550
* CHECK dout1_4 vdout1_4ck154 = 0 time = 1550
* CHECK dout1_5 vdout1_5ck154 = 3.3 time = 1550
* CHECK dout1_6 vdout1_6ck154 = 3.3 time = 1550
* CHECK dout1_7 vdout1_7ck154 = 3.3 time = 1550
* CHECK dout1_8 vdout1_8ck154 = 0 time = 1550
* CHECK dout1_9 vdout1_9ck154 = 0 time = 1550
* CHECK dout1_10 vdout1_10ck154 = 3.3 time = 1550
* CHECK dout1_11 vdout1_11ck154 = 3.3 time = 1550
* CHECK dout1_12 vdout1_12ck154 = 3.3 time = 1550
* CHECK dout1_13 vdout1_13ck154 = 0 time = 1550
* CHECK dout1_14 vdout1_14ck154 = 0 time = 1550
* CHECK dout1_15 vdout1_15ck154 = 3.3 time = 1550
* CHECK dout1_16 vdout1_16ck154 = 0 time = 1550
* CHECK dout1_17 vdout1_17ck154 = 0 time = 1550
* CHECK dout1_18 vdout1_18ck154 = 0 time = 1550
* CHECK dout1_19 vdout1_19ck154 = 0 time = 1550
* CHECK dout1_20 vdout1_20ck154 = 0 time = 1550
* CHECK dout1_21 vdout1_21ck154 = 0 time = 1550
* CHECK dout1_22 vdout1_22ck154 = 3.3 time = 1550
* CHECK dout1_23 vdout1_23ck154 = 0 time = 1550
* CHECK dout1_24 vdout1_24ck154 = 3.3 time = 1550
* CHECK dout1_25 vdout1_25ck154 = 0 time = 1550
* CHECK dout1_26 vdout1_26ck154 = 0 time = 1550
* CHECK dout1_27 vdout1_27ck154 = 3.3 time = 1550
* CHECK dout1_28 vdout1_28ck154 = 3.3 time = 1550
* CHECK dout1_29 vdout1_29ck154 = 0 time = 1550
* CHECK dout1_30 vdout1_30ck154 = 0 time = 1550
* CHECK dout1_31 vdout1_31ck154 = 0 time = 1550
* CHECK dout0_0 vdout0_0ck155 = 3.3 time = 1560
* CHECK dout0_1 vdout0_1ck155 = 0 time = 1560
* CHECK dout0_2 vdout0_2ck155 = 0 time = 1560
* CHECK dout0_3 vdout0_3ck155 = 0 time = 1560
* CHECK dout0_4 vdout0_4ck155 = 0 time = 1560
* CHECK dout0_5 vdout0_5ck155 = 3.3 time = 1560
* CHECK dout0_6 vdout0_6ck155 = 3.3 time = 1560
* CHECK dout0_7 vdout0_7ck155 = 3.3 time = 1560
* CHECK dout0_8 vdout0_8ck155 = 0 time = 1560
* CHECK dout0_9 vdout0_9ck155 = 0 time = 1560
* CHECK dout0_10 vdout0_10ck155 = 3.3 time = 1560
* CHECK dout0_11 vdout0_11ck155 = 3.3 time = 1560
* CHECK dout0_12 vdout0_12ck155 = 3.3 time = 1560
* CHECK dout0_13 vdout0_13ck155 = 0 time = 1560
* CHECK dout0_14 vdout0_14ck155 = 0 time = 1560
* CHECK dout0_15 vdout0_15ck155 = 3.3 time = 1560
* CHECK dout0_16 vdout0_16ck155 = 0 time = 1560
* CHECK dout0_17 vdout0_17ck155 = 0 time = 1560
* CHECK dout0_18 vdout0_18ck155 = 0 time = 1560
* CHECK dout0_19 vdout0_19ck155 = 0 time = 1560
* CHECK dout0_20 vdout0_20ck155 = 0 time = 1560
* CHECK dout0_21 vdout0_21ck155 = 0 time = 1560
* CHECK dout0_22 vdout0_22ck155 = 3.3 time = 1560
* CHECK dout0_23 vdout0_23ck155 = 0 time = 1560
* CHECK dout0_24 vdout0_24ck155 = 3.3 time = 1560
* CHECK dout0_25 vdout0_25ck155 = 0 time = 1560
* CHECK dout0_26 vdout0_26ck155 = 0 time = 1560
* CHECK dout0_27 vdout0_27ck155 = 3.3 time = 1560
* CHECK dout0_28 vdout0_28ck155 = 3.3 time = 1560
* CHECK dout0_29 vdout0_29ck155 = 0 time = 1560
* CHECK dout0_30 vdout0_30ck155 = 0 time = 1560
* CHECK dout0_31 vdout0_31ck155 = 0 time = 1560
* CHECK dout1_0 vdout1_0ck156 = 3.3 time = 1570
* CHECK dout1_1 vdout1_1ck156 = 0 time = 1570
* CHECK dout1_2 vdout1_2ck156 = 0 time = 1570
* CHECK dout1_3 vdout1_3ck156 = 0 time = 1570
* CHECK dout1_4 vdout1_4ck156 = 0 time = 1570
* CHECK dout1_5 vdout1_5ck156 = 0 time = 1570
* CHECK dout1_6 vdout1_6ck156 = 3.3 time = 1570
* CHECK dout1_7 vdout1_7ck156 = 0 time = 1570
* CHECK dout1_8 vdout1_8ck156 = 0 time = 1570
* CHECK dout1_9 vdout1_9ck156 = 3.3 time = 1570
* CHECK dout1_10 vdout1_10ck156 = 0 time = 1570
* CHECK dout1_11 vdout1_11ck156 = 0 time = 1570
* CHECK dout1_12 vdout1_12ck156 = 3.3 time = 1570
* CHECK dout1_13 vdout1_13ck156 = 0 time = 1570
* CHECK dout1_14 vdout1_14ck156 = 0 time = 1570
* CHECK dout1_15 vdout1_15ck156 = 3.3 time = 1570
* CHECK dout1_16 vdout1_16ck156 = 3.3 time = 1570
* CHECK dout1_17 vdout1_17ck156 = 3.3 time = 1570
* CHECK dout1_18 vdout1_18ck156 = 0 time = 1570
* CHECK dout1_19 vdout1_19ck156 = 3.3 time = 1570
* CHECK dout1_20 vdout1_20ck156 = 3.3 time = 1570
* CHECK dout1_21 vdout1_21ck156 = 0 time = 1570
* CHECK dout1_22 vdout1_22ck156 = 3.3 time = 1570
* CHECK dout1_23 vdout1_23ck156 = 3.3 time = 1570
* CHECK dout1_24 vdout1_24ck156 = 3.3 time = 1570
* CHECK dout1_25 vdout1_25ck156 = 3.3 time = 1570
* CHECK dout1_26 vdout1_26ck156 = 0 time = 1570
* CHECK dout1_27 vdout1_27ck156 = 0 time = 1570
* CHECK dout1_28 vdout1_28ck156 = 0 time = 1570
* CHECK dout1_29 vdout1_29ck156 = 0 time = 1570
* CHECK dout1_30 vdout1_30ck156 = 0 time = 1570
* CHECK dout1_31 vdout1_31ck156 = 3.3 time = 1570
* CHECK dout0_0 vdout0_0ck157 = 3.3 time = 1580
* CHECK dout0_1 vdout0_1ck157 = 0 time = 1580
* CHECK dout0_2 vdout0_2ck157 = 0 time = 1580
* CHECK dout0_3 vdout0_3ck157 = 0 time = 1580
* CHECK dout0_4 vdout0_4ck157 = 0 time = 1580
* CHECK dout0_5 vdout0_5ck157 = 0 time = 1580
* CHECK dout0_6 vdout0_6ck157 = 3.3 time = 1580
* CHECK dout0_7 vdout0_7ck157 = 0 time = 1580
* CHECK dout0_8 vdout0_8ck157 = 0 time = 1580
* CHECK dout0_9 vdout0_9ck157 = 3.3 time = 1580
* CHECK dout0_10 vdout0_10ck157 = 0 time = 1580
* CHECK dout0_11 vdout0_11ck157 = 0 time = 1580
* CHECK dout0_12 vdout0_12ck157 = 3.3 time = 1580
* CHECK dout0_13 vdout0_13ck157 = 0 time = 1580
* CHECK dout0_14 vdout0_14ck157 = 0 time = 1580
* CHECK dout0_15 vdout0_15ck157 = 3.3 time = 1580
* CHECK dout0_16 vdout0_16ck157 = 3.3 time = 1580
* CHECK dout0_17 vdout0_17ck157 = 3.3 time = 1580
* CHECK dout0_18 vdout0_18ck157 = 0 time = 1580
* CHECK dout0_19 vdout0_19ck157 = 3.3 time = 1580
* CHECK dout0_20 vdout0_20ck157 = 3.3 time = 1580
* CHECK dout0_21 vdout0_21ck157 = 0 time = 1580
* CHECK dout0_22 vdout0_22ck157 = 3.3 time = 1580
* CHECK dout0_23 vdout0_23ck157 = 3.3 time = 1580
* CHECK dout0_24 vdout0_24ck157 = 3.3 time = 1580
* CHECK dout0_25 vdout0_25ck157 = 3.3 time = 1580
* CHECK dout0_26 vdout0_26ck157 = 0 time = 1580
* CHECK dout0_27 vdout0_27ck157 = 0 time = 1580
* CHECK dout0_28 vdout0_28ck157 = 0 time = 1580
* CHECK dout0_29 vdout0_29ck157 = 0 time = 1580
* CHECK dout0_30 vdout0_30ck157 = 0 time = 1580
* CHECK dout0_31 vdout0_31ck157 = 3.3 time = 1580
* CHECK dout1_0 vdout1_0ck158 = 3.3 time = 1590
* CHECK dout1_1 vdout1_1ck158 = 0 time = 1590
* CHECK dout1_2 vdout1_2ck158 = 0 time = 1590
* CHECK dout1_3 vdout1_3ck158 = 0 time = 1590
* CHECK dout1_4 vdout1_4ck158 = 0 time = 1590
* CHECK dout1_5 vdout1_5ck158 = 0 time = 1590
* CHECK dout1_6 vdout1_6ck158 = 3.3 time = 1590
* CHECK dout1_7 vdout1_7ck158 = 0 time = 1590
* CHECK dout1_8 vdout1_8ck158 = 0 time = 1590
* CHECK dout1_9 vdout1_9ck158 = 3.3 time = 1590
* CHECK dout1_10 vdout1_10ck158 = 0 time = 1590
* CHECK dout1_11 vdout1_11ck158 = 0 time = 1590
* CHECK dout1_12 vdout1_12ck158 = 3.3 time = 1590
* CHECK dout1_13 vdout1_13ck158 = 0 time = 1590
* CHECK dout1_14 vdout1_14ck158 = 0 time = 1590
* CHECK dout1_15 vdout1_15ck158 = 3.3 time = 1590
* CHECK dout1_16 vdout1_16ck158 = 3.3 time = 1590
* CHECK dout1_17 vdout1_17ck158 = 3.3 time = 1590
* CHECK dout1_18 vdout1_18ck158 = 0 time = 1590
* CHECK dout1_19 vdout1_19ck158 = 3.3 time = 1590
* CHECK dout1_20 vdout1_20ck158 = 3.3 time = 1590
* CHECK dout1_21 vdout1_21ck158 = 0 time = 1590
* CHECK dout1_22 vdout1_22ck158 = 3.3 time = 1590
* CHECK dout1_23 vdout1_23ck158 = 3.3 time = 1590
* CHECK dout1_24 vdout1_24ck158 = 3.3 time = 1590
* CHECK dout1_25 vdout1_25ck158 = 3.3 time = 1590
* CHECK dout1_26 vdout1_26ck158 = 0 time = 1590
* CHECK dout1_27 vdout1_27ck158 = 0 time = 1590
* CHECK dout1_28 vdout1_28ck158 = 0 time = 1590
* CHECK dout1_29 vdout1_29ck158 = 0 time = 1590
* CHECK dout1_30 vdout1_30ck158 = 0 time = 1590
* CHECK dout1_31 vdout1_31ck158 = 3.3 time = 1590
* CHECK dout1_0 vdout1_0ck159 = 0 time = 1600
* CHECK dout1_1 vdout1_1ck159 = 3.3 time = 1600
* CHECK dout1_2 vdout1_2ck159 = 0 time = 1600
* CHECK dout1_3 vdout1_3ck159 = 0 time = 1600
* CHECK dout1_4 vdout1_4ck159 = 3.3 time = 1600
* CHECK dout1_5 vdout1_5ck159 = 3.3 time = 1600
* CHECK dout1_6 vdout1_6ck159 = 3.3 time = 1600
* CHECK dout1_7 vdout1_7ck159 = 3.3 time = 1600
* CHECK dout1_8 vdout1_8ck159 = 3.3 time = 1600
* CHECK dout1_9 vdout1_9ck159 = 3.3 time = 1600
* CHECK dout1_10 vdout1_10ck159 = 0 time = 1600
* CHECK dout1_11 vdout1_11ck159 = 0 time = 1600
* CHECK dout1_12 vdout1_12ck159 = 0 time = 1600
* CHECK dout1_13 vdout1_13ck159 = 0 time = 1600
* CHECK dout1_14 vdout1_14ck159 = 3.3 time = 1600
* CHECK dout1_15 vdout1_15ck159 = 3.3 time = 1600
* CHECK dout1_16 vdout1_16ck159 = 0 time = 1600
* CHECK dout1_17 vdout1_17ck159 = 0 time = 1600
* CHECK dout1_18 vdout1_18ck159 = 0 time = 1600
* CHECK dout1_19 vdout1_19ck159 = 0 time = 1600
* CHECK dout1_20 vdout1_20ck159 = 3.3 time = 1600
* CHECK dout1_21 vdout1_21ck159 = 3.3 time = 1600
* CHECK dout1_22 vdout1_22ck159 = 0 time = 1600
* CHECK dout1_23 vdout1_23ck159 = 0 time = 1600
* CHECK dout1_24 vdout1_24ck159 = 3.3 time = 1600
* CHECK dout1_25 vdout1_25ck159 = 0 time = 1600
* CHECK dout1_26 vdout1_26ck159 = 0 time = 1600
* CHECK dout1_27 vdout1_27ck159 = 0 time = 1600
* CHECK dout1_28 vdout1_28ck159 = 3.3 time = 1600
* CHECK dout1_29 vdout1_29ck159 = 0 time = 1600
* CHECK dout1_30 vdout1_30ck159 = 3.3 time = 1600
* CHECK dout1_31 vdout1_31ck159 = 0 time = 1600
* CHECK dout0_0 vdout0_0ck160 = 3.3 time = 1610
* CHECK dout0_1 vdout0_1ck160 = 0 time = 1610
* CHECK dout0_2 vdout0_2ck160 = 3.3 time = 1610
* CHECK dout0_3 vdout0_3ck160 = 0 time = 1610
* CHECK dout0_4 vdout0_4ck160 = 0 time = 1610
* CHECK dout0_5 vdout0_5ck160 = 3.3 time = 1610
* CHECK dout0_6 vdout0_6ck160 = 0 time = 1610
* CHECK dout0_7 vdout0_7ck160 = 3.3 time = 1610
* CHECK dout0_8 vdout0_8ck160 = 0 time = 1610
* CHECK dout0_9 vdout0_9ck160 = 3.3 time = 1610
* CHECK dout0_10 vdout0_10ck160 = 3.3 time = 1610
* CHECK dout0_11 vdout0_11ck160 = 3.3 time = 1610
* CHECK dout0_12 vdout0_12ck160 = 0 time = 1610
* CHECK dout0_13 vdout0_13ck160 = 3.3 time = 1610
* CHECK dout0_14 vdout0_14ck160 = 3.3 time = 1610
* CHECK dout0_15 vdout0_15ck160 = 0 time = 1610
* CHECK dout0_16 vdout0_16ck160 = 3.3 time = 1610
* CHECK dout0_17 vdout0_17ck160 = 0 time = 1610
* CHECK dout0_18 vdout0_18ck160 = 0 time = 1610
* CHECK dout0_19 vdout0_19ck160 = 3.3 time = 1610
* CHECK dout0_20 vdout0_20ck160 = 3.3 time = 1610
* CHECK dout0_21 vdout0_21ck160 = 3.3 time = 1610
* CHECK dout0_22 vdout0_22ck160 = 0 time = 1610
* CHECK dout0_23 vdout0_23ck160 = 3.3 time = 1610
* CHECK dout0_24 vdout0_24ck160 = 3.3 time = 1610
* CHECK dout0_25 vdout0_25ck160 = 3.3 time = 1610
* CHECK dout0_26 vdout0_26ck160 = 3.3 time = 1610
* CHECK dout0_27 vdout0_27ck160 = 0 time = 1610
* CHECK dout0_28 vdout0_28ck160 = 0 time = 1610
* CHECK dout0_29 vdout0_29ck160 = 3.3 time = 1610
* CHECK dout0_30 vdout0_30ck160 = 0 time = 1610
* CHECK dout0_31 vdout0_31ck160 = 3.3 time = 1610
* CHECK dout1_0 vdout1_0ck160 = 0 time = 1610
* CHECK dout1_1 vdout1_1ck160 = 3.3 time = 1610
* CHECK dout1_2 vdout1_2ck160 = 0 time = 1610
* CHECK dout1_3 vdout1_3ck160 = 0 time = 1610
* CHECK dout1_4 vdout1_4ck160 = 3.3 time = 1610
* CHECK dout1_5 vdout1_5ck160 = 3.3 time = 1610
* CHECK dout1_6 vdout1_6ck160 = 3.3 time = 1610
* CHECK dout1_7 vdout1_7ck160 = 3.3 time = 1610
* CHECK dout1_8 vdout1_8ck160 = 3.3 time = 1610
* CHECK dout1_9 vdout1_9ck160 = 3.3 time = 1610
* CHECK dout1_10 vdout1_10ck160 = 0 time = 1610
* CHECK dout1_11 vdout1_11ck160 = 0 time = 1610
* CHECK dout1_12 vdout1_12ck160 = 0 time = 1610
* CHECK dout1_13 vdout1_13ck160 = 0 time = 1610
* CHECK dout1_14 vdout1_14ck160 = 3.3 time = 1610
* CHECK dout1_15 vdout1_15ck160 = 3.3 time = 1610
* CHECK dout1_16 vdout1_16ck160 = 0 time = 1610
* CHECK dout1_17 vdout1_17ck160 = 0 time = 1610
* CHECK dout1_18 vdout1_18ck160 = 0 time = 1610
* CHECK dout1_19 vdout1_19ck160 = 0 time = 1610
* CHECK dout1_20 vdout1_20ck160 = 3.3 time = 1610
* CHECK dout1_21 vdout1_21ck160 = 3.3 time = 1610
* CHECK dout1_22 vdout1_22ck160 = 0 time = 1610
* CHECK dout1_23 vdout1_23ck160 = 0 time = 1610
* CHECK dout1_24 vdout1_24ck160 = 3.3 time = 1610
* CHECK dout1_25 vdout1_25ck160 = 0 time = 1610
* CHECK dout1_26 vdout1_26ck160 = 0 time = 1610
* CHECK dout1_27 vdout1_27ck160 = 0 time = 1610
* CHECK dout1_28 vdout1_28ck160 = 3.3 time = 1610
* CHECK dout1_29 vdout1_29ck160 = 0 time = 1610
* CHECK dout1_30 vdout1_30ck160 = 3.3 time = 1610
* CHECK dout1_31 vdout1_31ck160 = 0 time = 1610
* CHECK dout0_0 vdout0_0ck161 = 3.3 time = 1620
* CHECK dout0_1 vdout0_1ck161 = 0 time = 1620
* CHECK dout0_2 vdout0_2ck161 = 3.3 time = 1620
* CHECK dout0_3 vdout0_3ck161 = 0 time = 1620
* CHECK dout0_4 vdout0_4ck161 = 0 time = 1620
* CHECK dout0_5 vdout0_5ck161 = 3.3 time = 1620
* CHECK dout0_6 vdout0_6ck161 = 0 time = 1620
* CHECK dout0_7 vdout0_7ck161 = 3.3 time = 1620
* CHECK dout0_8 vdout0_8ck161 = 0 time = 1620
* CHECK dout0_9 vdout0_9ck161 = 3.3 time = 1620
* CHECK dout0_10 vdout0_10ck161 = 3.3 time = 1620
* CHECK dout0_11 vdout0_11ck161 = 3.3 time = 1620
* CHECK dout0_12 vdout0_12ck161 = 0 time = 1620
* CHECK dout0_13 vdout0_13ck161 = 3.3 time = 1620
* CHECK dout0_14 vdout0_14ck161 = 3.3 time = 1620
* CHECK dout0_15 vdout0_15ck161 = 0 time = 1620
* CHECK dout0_16 vdout0_16ck161 = 3.3 time = 1620
* CHECK dout0_17 vdout0_17ck161 = 0 time = 1620
* CHECK dout0_18 vdout0_18ck161 = 0 time = 1620
* CHECK dout0_19 vdout0_19ck161 = 3.3 time = 1620
* CHECK dout0_20 vdout0_20ck161 = 3.3 time = 1620
* CHECK dout0_21 vdout0_21ck161 = 3.3 time = 1620
* CHECK dout0_22 vdout0_22ck161 = 0 time = 1620
* CHECK dout0_23 vdout0_23ck161 = 3.3 time = 1620
* CHECK dout0_24 vdout0_24ck161 = 3.3 time = 1620
* CHECK dout0_25 vdout0_25ck161 = 3.3 time = 1620
* CHECK dout0_26 vdout0_26ck161 = 3.3 time = 1620
* CHECK dout0_27 vdout0_27ck161 = 0 time = 1620
* CHECK dout0_28 vdout0_28ck161 = 0 time = 1620
* CHECK dout0_29 vdout0_29ck161 = 3.3 time = 1620
* CHECK dout0_30 vdout0_30ck161 = 0 time = 1620
* CHECK dout0_31 vdout0_31ck161 = 3.3 time = 1620
* CHECK dout0_0 vdout0_0ck164 = 0 time = 1650
* CHECK dout0_1 vdout0_1ck164 = 3.3 time = 1650
* CHECK dout0_2 vdout0_2ck164 = 0 time = 1650
* CHECK dout0_3 vdout0_3ck164 = 0 time = 1650
* CHECK dout0_4 vdout0_4ck164 = 3.3 time = 1650
* CHECK dout0_5 vdout0_5ck164 = 3.3 time = 1650
* CHECK dout0_6 vdout0_6ck164 = 3.3 time = 1650
* CHECK dout0_7 vdout0_7ck164 = 3.3 time = 1650
* CHECK dout0_8 vdout0_8ck164 = 3.3 time = 1650
* CHECK dout0_9 vdout0_9ck164 = 3.3 time = 1650
* CHECK dout0_10 vdout0_10ck164 = 0 time = 1650
* CHECK dout0_11 vdout0_11ck164 = 0 time = 1650
* CHECK dout0_12 vdout0_12ck164 = 0 time = 1650
* CHECK dout0_13 vdout0_13ck164 = 0 time = 1650
* CHECK dout0_14 vdout0_14ck164 = 3.3 time = 1650
* CHECK dout0_15 vdout0_15ck164 = 3.3 time = 1650
* CHECK dout0_16 vdout0_16ck164 = 0 time = 1650
* CHECK dout0_17 vdout0_17ck164 = 0 time = 1650
* CHECK dout0_18 vdout0_18ck164 = 0 time = 1650
* CHECK dout0_19 vdout0_19ck164 = 0 time = 1650
* CHECK dout0_20 vdout0_20ck164 = 3.3 time = 1650
* CHECK dout0_21 vdout0_21ck164 = 3.3 time = 1650
* CHECK dout0_22 vdout0_22ck164 = 0 time = 1650
* CHECK dout0_23 vdout0_23ck164 = 0 time = 1650
* CHECK dout0_24 vdout0_24ck164 = 3.3 time = 1650
* CHECK dout0_25 vdout0_25ck164 = 0 time = 1650
* CHECK dout0_26 vdout0_26ck164 = 0 time = 1650
* CHECK dout0_27 vdout0_27ck164 = 0 time = 1650
* CHECK dout0_28 vdout0_28ck164 = 3.3 time = 1650
* CHECK dout0_29 vdout0_29ck164 = 0 time = 1650
* CHECK dout0_30 vdout0_30ck164 = 3.3 time = 1650
* CHECK dout0_31 vdout0_31ck164 = 0 time = 1650
* CHECK dout1_0 vdout1_0ck164 = 0 time = 1650
* CHECK dout1_1 vdout1_1ck164 = 0 time = 1650
* CHECK dout1_2 vdout1_2ck164 = 3.3 time = 1650
* CHECK dout1_3 vdout1_3ck164 = 0 time = 1650
* CHECK dout1_4 vdout1_4ck164 = 0 time = 1650
* CHECK dout1_5 vdout1_5ck164 = 3.3 time = 1650
* CHECK dout1_6 vdout1_6ck164 = 3.3 time = 1650
* CHECK dout1_7 vdout1_7ck164 = 0 time = 1650
* CHECK dout1_8 vdout1_8ck164 = 0 time = 1650
* CHECK dout1_9 vdout1_9ck164 = 0 time = 1650
* CHECK dout1_10 vdout1_10ck164 = 3.3 time = 1650
* CHECK dout1_11 vdout1_11ck164 = 3.3 time = 1650
* CHECK dout1_12 vdout1_12ck164 = 0 time = 1650
* CHECK dout1_13 vdout1_13ck164 = 0 time = 1650
* CHECK dout1_14 vdout1_14ck164 = 3.3 time = 1650
* CHECK dout1_15 vdout1_15ck164 = 0 time = 1650
* CHECK dout1_16 vdout1_16ck164 = 3.3 time = 1650
* CHECK dout1_17 vdout1_17ck164 = 0 time = 1650
* CHECK dout1_18 vdout1_18ck164 = 0 time = 1650
* CHECK dout1_19 vdout1_19ck164 = 0 time = 1650
* CHECK dout1_20 vdout1_20ck164 = 0 time = 1650
* CHECK dout1_21 vdout1_21ck164 = 0 time = 1650
* CHECK dout1_22 vdout1_22ck164 = 0 time = 1650
* CHECK dout1_23 vdout1_23ck164 = 0 time = 1650
* CHECK dout1_24 vdout1_24ck164 = 0 time = 1650
* CHECK dout1_25 vdout1_25ck164 = 3.3 time = 1650
* CHECK dout1_26 vdout1_26ck164 = 3.3 time = 1650
* CHECK dout1_27 vdout1_27ck164 = 0 time = 1650
* CHECK dout1_28 vdout1_28ck164 = 0 time = 1650
* CHECK dout1_29 vdout1_29ck164 = 0 time = 1650
* CHECK dout1_30 vdout1_30ck164 = 0 time = 1650
* CHECK dout1_31 vdout1_31ck164 = 0 time = 1650
* CHECK dout0_0 vdout0_0ck165 = 0 time = 1660
* CHECK dout0_1 vdout0_1ck165 = 3.3 time = 1660
* CHECK dout0_2 vdout0_2ck165 = 0 time = 1660
* CHECK dout0_3 vdout0_3ck165 = 0 time = 1660
* CHECK dout0_4 vdout0_4ck165 = 3.3 time = 1660
* CHECK dout0_5 vdout0_5ck165 = 3.3 time = 1660
* CHECK dout0_6 vdout0_6ck165 = 3.3 time = 1660
* CHECK dout0_7 vdout0_7ck165 = 3.3 time = 1660
* CHECK dout0_8 vdout0_8ck165 = 3.3 time = 1660
* CHECK dout0_9 vdout0_9ck165 = 3.3 time = 1660
* CHECK dout0_10 vdout0_10ck165 = 0 time = 1660
* CHECK dout0_11 vdout0_11ck165 = 0 time = 1660
* CHECK dout0_12 vdout0_12ck165 = 0 time = 1660
* CHECK dout0_13 vdout0_13ck165 = 0 time = 1660
* CHECK dout0_14 vdout0_14ck165 = 3.3 time = 1660
* CHECK dout0_15 vdout0_15ck165 = 3.3 time = 1660
* CHECK dout0_16 vdout0_16ck165 = 0 time = 1660
* CHECK dout0_17 vdout0_17ck165 = 0 time = 1660
* CHECK dout0_18 vdout0_18ck165 = 0 time = 1660
* CHECK dout0_19 vdout0_19ck165 = 0 time = 1660
* CHECK dout0_20 vdout0_20ck165 = 3.3 time = 1660
* CHECK dout0_21 vdout0_21ck165 = 3.3 time = 1660
* CHECK dout0_22 vdout0_22ck165 = 0 time = 1660
* CHECK dout0_23 vdout0_23ck165 = 0 time = 1660
* CHECK dout0_24 vdout0_24ck165 = 3.3 time = 1660
* CHECK dout0_25 vdout0_25ck165 = 0 time = 1660
* CHECK dout0_26 vdout0_26ck165 = 0 time = 1660
* CHECK dout0_27 vdout0_27ck165 = 0 time = 1660
* CHECK dout0_28 vdout0_28ck165 = 3.3 time = 1660
* CHECK dout0_29 vdout0_29ck165 = 0 time = 1660
* CHECK dout0_30 vdout0_30ck165 = 3.3 time = 1660
* CHECK dout0_31 vdout0_31ck165 = 0 time = 1660
* CHECK dout1_0 vdout1_0ck165 = 0 time = 1660
* CHECK dout1_1 vdout1_1ck165 = 0 time = 1660
* CHECK dout1_2 vdout1_2ck165 = 3.3 time = 1660
* CHECK dout1_3 vdout1_3ck165 = 0 time = 1660
* CHECK dout1_4 vdout1_4ck165 = 0 time = 1660
* CHECK dout1_5 vdout1_5ck165 = 3.3 time = 1660
* CHECK dout1_6 vdout1_6ck165 = 3.3 time = 1660
* CHECK dout1_7 vdout1_7ck165 = 0 time = 1660
* CHECK dout1_8 vdout1_8ck165 = 0 time = 1660
* CHECK dout1_9 vdout1_9ck165 = 0 time = 1660
* CHECK dout1_10 vdout1_10ck165 = 3.3 time = 1660
* CHECK dout1_11 vdout1_11ck165 = 3.3 time = 1660
* CHECK dout1_12 vdout1_12ck165 = 0 time = 1660
* CHECK dout1_13 vdout1_13ck165 = 0 time = 1660
* CHECK dout1_14 vdout1_14ck165 = 3.3 time = 1660
* CHECK dout1_15 vdout1_15ck165 = 0 time = 1660
* CHECK dout1_16 vdout1_16ck165 = 3.3 time = 1660
* CHECK dout1_17 vdout1_17ck165 = 0 time = 1660
* CHECK dout1_18 vdout1_18ck165 = 0 time = 1660
* CHECK dout1_19 vdout1_19ck165 = 0 time = 1660
* CHECK dout1_20 vdout1_20ck165 = 0 time = 1660
* CHECK dout1_21 vdout1_21ck165 = 0 time = 1660
* CHECK dout1_22 vdout1_22ck165 = 0 time = 1660
* CHECK dout1_23 vdout1_23ck165 = 0 time = 1660
* CHECK dout1_24 vdout1_24ck165 = 0 time = 1660
* CHECK dout1_25 vdout1_25ck165 = 3.3 time = 1660
* CHECK dout1_26 vdout1_26ck165 = 3.3 time = 1660
* CHECK dout1_27 vdout1_27ck165 = 0 time = 1660
* CHECK dout1_28 vdout1_28ck165 = 0 time = 1660
* CHECK dout1_29 vdout1_29ck165 = 0 time = 1660
* CHECK dout1_30 vdout1_30ck165 = 0 time = 1660
* CHECK dout1_31 vdout1_31ck165 = 0 time = 1660
* CHECK dout0_0 vdout0_0ck167 = 3.3 time = 1680
* CHECK dout0_1 vdout0_1ck167 = 3.3 time = 1680
* CHECK dout0_2 vdout0_2ck167 = 0 time = 1680
* CHECK dout0_3 vdout0_3ck167 = 3.3 time = 1680
* CHECK dout0_4 vdout0_4ck167 = 3.3 time = 1680
* CHECK dout0_5 vdout0_5ck167 = 3.3 time = 1680
* CHECK dout0_6 vdout0_6ck167 = 0 time = 1680
* CHECK dout0_7 vdout0_7ck167 = 0 time = 1680
* CHECK dout0_8 vdout0_8ck167 = 0 time = 1680
* CHECK dout0_9 vdout0_9ck167 = 3.3 time = 1680
* CHECK dout0_10 vdout0_10ck167 = 3.3 time = 1680
* CHECK dout0_11 vdout0_11ck167 = 0 time = 1680
* CHECK dout0_12 vdout0_12ck167 = 0 time = 1680
* CHECK dout0_13 vdout0_13ck167 = 3.3 time = 1680
* CHECK dout0_14 vdout0_14ck167 = 3.3 time = 1680
* CHECK dout0_15 vdout0_15ck167 = 0 time = 1680
* CHECK dout0_16 vdout0_16ck167 = 3.3 time = 1680
* CHECK dout0_17 vdout0_17ck167 = 0 time = 1680
* CHECK dout0_18 vdout0_18ck167 = 0 time = 1680
* CHECK dout0_19 vdout0_19ck167 = 0 time = 1680
* CHECK dout0_20 vdout0_20ck167 = 3.3 time = 1680
* CHECK dout0_21 vdout0_21ck167 = 0 time = 1680
* CHECK dout0_22 vdout0_22ck167 = 0 time = 1680
* CHECK dout0_23 vdout0_23ck167 = 3.3 time = 1680
* CHECK dout0_24 vdout0_24ck167 = 3.3 time = 1680
* CHECK dout0_25 vdout0_25ck167 = 3.3 time = 1680
* CHECK dout0_26 vdout0_26ck167 = 0 time = 1680
* CHECK dout0_27 vdout0_27ck167 = 0 time = 1680
* CHECK dout0_28 vdout0_28ck167 = 3.3 time = 1680
* CHECK dout0_29 vdout0_29ck167 = 3.3 time = 1680
* CHECK dout0_30 vdout0_30ck167 = 0 time = 1680
* CHECK dout0_31 vdout0_31ck167 = 3.3 time = 1680
* CHECK dout1_0 vdout1_0ck169 = 0 time = 1700
* CHECK dout1_1 vdout1_1ck169 = 0 time = 1700
* CHECK dout1_2 vdout1_2ck169 = 0 time = 1700
* CHECK dout1_3 vdout1_3ck169 = 0 time = 1700
* CHECK dout1_4 vdout1_4ck169 = 3.3 time = 1700
* CHECK dout1_5 vdout1_5ck169 = 3.3 time = 1700
* CHECK dout1_6 vdout1_6ck169 = 3.3 time = 1700
* CHECK dout1_7 vdout1_7ck169 = 3.3 time = 1700
* CHECK dout1_8 vdout1_8ck169 = 0 time = 1700
* CHECK dout1_9 vdout1_9ck169 = 0 time = 1700
* CHECK dout1_10 vdout1_10ck169 = 0 time = 1700
* CHECK dout1_11 vdout1_11ck169 = 0 time = 1700
* CHECK dout1_12 vdout1_12ck169 = 3.3 time = 1700
* CHECK dout1_13 vdout1_13ck169 = 0 time = 1700
* CHECK dout1_14 vdout1_14ck169 = 3.3 time = 1700
* CHECK dout1_15 vdout1_15ck169 = 3.3 time = 1700
* CHECK dout1_16 vdout1_16ck169 = 3.3 time = 1700
* CHECK dout1_17 vdout1_17ck169 = 3.3 time = 1700
* CHECK dout1_18 vdout1_18ck169 = 0 time = 1700
* CHECK dout1_19 vdout1_19ck169 = 0 time = 1700
* CHECK dout1_20 vdout1_20ck169 = 3.3 time = 1700
* CHECK dout1_21 vdout1_21ck169 = 3.3 time = 1700
* CHECK dout1_22 vdout1_22ck169 = 0 time = 1700
* CHECK dout1_23 vdout1_23ck169 = 0 time = 1700
* CHECK dout1_24 vdout1_24ck169 = 3.3 time = 1700
* CHECK dout1_25 vdout1_25ck169 = 3.3 time = 1700
* CHECK dout1_26 vdout1_26ck169 = 0 time = 1700
* CHECK dout1_27 vdout1_27ck169 = 3.3 time = 1700
* CHECK dout1_28 vdout1_28ck169 = 0 time = 1700
* CHECK dout1_29 vdout1_29ck169 = 3.3 time = 1700
* CHECK dout1_30 vdout1_30ck169 = 3.3 time = 1700
* CHECK dout1_31 vdout1_31ck169 = 0 time = 1700
* CHECK dout1_0 vdout1_0ck170 = 0 time = 1710
* CHECK dout1_1 vdout1_1ck170 = 0 time = 1710
* CHECK dout1_2 vdout1_2ck170 = 0 time = 1710
* CHECK dout1_3 vdout1_3ck170 = 0 time = 1710
* CHECK dout1_4 vdout1_4ck170 = 3.3 time = 1710
* CHECK dout1_5 vdout1_5ck170 = 3.3 time = 1710
* CHECK dout1_6 vdout1_6ck170 = 3.3 time = 1710
* CHECK dout1_7 vdout1_7ck170 = 3.3 time = 1710
* CHECK dout1_8 vdout1_8ck170 = 0 time = 1710
* CHECK dout1_9 vdout1_9ck170 = 0 time = 1710
* CHECK dout1_10 vdout1_10ck170 = 0 time = 1710
* CHECK dout1_11 vdout1_11ck170 = 0 time = 1710
* CHECK dout1_12 vdout1_12ck170 = 3.3 time = 1710
* CHECK dout1_13 vdout1_13ck170 = 0 time = 1710
* CHECK dout1_14 vdout1_14ck170 = 3.3 time = 1710
* CHECK dout1_15 vdout1_15ck170 = 3.3 time = 1710
* CHECK dout1_16 vdout1_16ck170 = 3.3 time = 1710
* CHECK dout1_17 vdout1_17ck170 = 3.3 time = 1710
* CHECK dout1_18 vdout1_18ck170 = 0 time = 1710
* CHECK dout1_19 vdout1_19ck170 = 0 time = 1710
* CHECK dout1_20 vdout1_20ck170 = 3.3 time = 1710
* CHECK dout1_21 vdout1_21ck170 = 3.3 time = 1710
* CHECK dout1_22 vdout1_22ck170 = 0 time = 1710
* CHECK dout1_23 vdout1_23ck170 = 0 time = 1710
* CHECK dout1_24 vdout1_24ck170 = 3.3 time = 1710
* CHECK dout1_25 vdout1_25ck170 = 3.3 time = 1710
* CHECK dout1_26 vdout1_26ck170 = 0 time = 1710
* CHECK dout1_27 vdout1_27ck170 = 3.3 time = 1710
* CHECK dout1_28 vdout1_28ck170 = 0 time = 1710
* CHECK dout1_29 vdout1_29ck170 = 3.3 time = 1710
* CHECK dout1_30 vdout1_30ck170 = 3.3 time = 1710
* CHECK dout1_31 vdout1_31ck170 = 0 time = 1710
* CHECK dout0_0 vdout0_0ck173 = 0 time = 1740
* CHECK dout0_1 vdout0_1ck173 = 3.3 time = 1740
* CHECK dout0_2 vdout0_2ck173 = 3.3 time = 1740
* CHECK dout0_3 vdout0_3ck173 = 3.3 time = 1740
* CHECK dout0_4 vdout0_4ck173 = 3.3 time = 1740
* CHECK dout0_5 vdout0_5ck173 = 0 time = 1740
* CHECK dout0_6 vdout0_6ck173 = 0 time = 1740
* CHECK dout0_7 vdout0_7ck173 = 0 time = 1740
* CHECK dout0_8 vdout0_8ck173 = 3.3 time = 1740
* CHECK dout0_9 vdout0_9ck173 = 3.3 time = 1740
* CHECK dout0_10 vdout0_10ck173 = 3.3 time = 1740
* CHECK dout0_11 vdout0_11ck173 = 3.3 time = 1740
* CHECK dout0_12 vdout0_12ck173 = 0 time = 1740
* CHECK dout0_13 vdout0_13ck173 = 3.3 time = 1740
* CHECK dout0_14 vdout0_14ck173 = 0 time = 1740
* CHECK dout0_15 vdout0_15ck173 = 3.3 time = 1740
* CHECK dout0_16 vdout0_16ck173 = 3.3 time = 1740
* CHECK dout0_17 vdout0_17ck173 = 0 time = 1740
* CHECK dout0_18 vdout0_18ck173 = 0 time = 1740
* CHECK dout0_19 vdout0_19ck173 = 3.3 time = 1740
* CHECK dout0_20 vdout0_20ck173 = 3.3 time = 1740
* CHECK dout0_21 vdout0_21ck173 = 3.3 time = 1740
* CHECK dout0_22 vdout0_22ck173 = 3.3 time = 1740
* CHECK dout0_23 vdout0_23ck173 = 0 time = 1740
* CHECK dout0_24 vdout0_24ck173 = 0 time = 1740
* CHECK dout0_25 vdout0_25ck173 = 3.3 time = 1740
* CHECK dout0_26 vdout0_26ck173 = 0 time = 1740
* CHECK dout0_27 vdout0_27ck173 = 0 time = 1740
* CHECK dout0_28 vdout0_28ck173 = 3.3 time = 1740
* CHECK dout0_29 vdout0_29ck173 = 0 time = 1740
* CHECK dout0_30 vdout0_30ck173 = 0 time = 1740
* CHECK dout0_31 vdout0_31ck173 = 0 time = 1740
* CHECK dout1_0 vdout1_0ck173 = 0 time = 1740
* CHECK dout1_1 vdout1_1ck173 = 3.3 time = 1740
* CHECK dout1_2 vdout1_2ck173 = 3.3 time = 1740
* CHECK dout1_3 vdout1_3ck173 = 3.3 time = 1740
* CHECK dout1_4 vdout1_4ck173 = 3.3 time = 1740
* CHECK dout1_5 vdout1_5ck173 = 0 time = 1740
* CHECK dout1_6 vdout1_6ck173 = 0 time = 1740
* CHECK dout1_7 vdout1_7ck173 = 0 time = 1740
* CHECK dout1_8 vdout1_8ck173 = 3.3 time = 1740
* CHECK dout1_9 vdout1_9ck173 = 3.3 time = 1740
* CHECK dout1_10 vdout1_10ck173 = 3.3 time = 1740
* CHECK dout1_11 vdout1_11ck173 = 3.3 time = 1740
* CHECK dout1_12 vdout1_12ck173 = 0 time = 1740
* CHECK dout1_13 vdout1_13ck173 = 3.3 time = 1740
* CHECK dout1_14 vdout1_14ck173 = 0 time = 1740
* CHECK dout1_15 vdout1_15ck173 = 3.3 time = 1740
* CHECK dout1_16 vdout1_16ck173 = 3.3 time = 1740
* CHECK dout1_17 vdout1_17ck173 = 0 time = 1740
* CHECK dout1_18 vdout1_18ck173 = 0 time = 1740
* CHECK dout1_19 vdout1_19ck173 = 3.3 time = 1740
* CHECK dout1_20 vdout1_20ck173 = 3.3 time = 1740
* CHECK dout1_21 vdout1_21ck173 = 3.3 time = 1740
* CHECK dout1_22 vdout1_22ck173 = 3.3 time = 1740
* CHECK dout1_23 vdout1_23ck173 = 0 time = 1740
* CHECK dout1_24 vdout1_24ck173 = 0 time = 1740
* CHECK dout1_25 vdout1_25ck173 = 3.3 time = 1740
* CHECK dout1_26 vdout1_26ck173 = 0 time = 1740
* CHECK dout1_27 vdout1_27ck173 = 0 time = 1740
* CHECK dout1_28 vdout1_28ck173 = 3.3 time = 1740
* CHECK dout1_29 vdout1_29ck173 = 0 time = 1740
* CHECK dout1_30 vdout1_30ck173 = 0 time = 1740
* CHECK dout1_31 vdout1_31ck173 = 0 time = 1740
* CHECK dout0_0 vdout0_0ck174 = 0 time = 1750
* CHECK dout0_1 vdout0_1ck174 = 0 time = 1750
* CHECK dout0_2 vdout0_2ck174 = 0 time = 1750
* CHECK dout0_3 vdout0_3ck174 = 0 time = 1750
* CHECK dout0_4 vdout0_4ck174 = 3.3 time = 1750
* CHECK dout0_5 vdout0_5ck174 = 3.3 time = 1750
* CHECK dout0_6 vdout0_6ck174 = 3.3 time = 1750
* CHECK dout0_7 vdout0_7ck174 = 3.3 time = 1750
* CHECK dout0_8 vdout0_8ck174 = 0 time = 1750
* CHECK dout0_9 vdout0_9ck174 = 0 time = 1750
* CHECK dout0_10 vdout0_10ck174 = 0 time = 1750
* CHECK dout0_11 vdout0_11ck174 = 0 time = 1750
* CHECK dout0_12 vdout0_12ck174 = 3.3 time = 1750
* CHECK dout0_13 vdout0_13ck174 = 0 time = 1750
* CHECK dout0_14 vdout0_14ck174 = 3.3 time = 1750
* CHECK dout0_15 vdout0_15ck174 = 3.3 time = 1750
* CHECK dout0_16 vdout0_16ck174 = 3.3 time = 1750
* CHECK dout0_17 vdout0_17ck174 = 3.3 time = 1750
* CHECK dout0_18 vdout0_18ck174 = 0 time = 1750
* CHECK dout0_19 vdout0_19ck174 = 0 time = 1750
* CHECK dout0_20 vdout0_20ck174 = 3.3 time = 1750
* CHECK dout0_21 vdout0_21ck174 = 3.3 time = 1750
* CHECK dout0_22 vdout0_22ck174 = 0 time = 1750
* CHECK dout0_23 vdout0_23ck174 = 0 time = 1750
* CHECK dout0_24 vdout0_24ck174 = 3.3 time = 1750
* CHECK dout0_25 vdout0_25ck174 = 3.3 time = 1750
* CHECK dout0_26 vdout0_26ck174 = 0 time = 1750
* CHECK dout0_27 vdout0_27ck174 = 3.3 time = 1750
* CHECK dout0_28 vdout0_28ck174 = 0 time = 1750
* CHECK dout0_29 vdout0_29ck174 = 3.3 time = 1750
* CHECK dout0_30 vdout0_30ck174 = 3.3 time = 1750
* CHECK dout0_31 vdout0_31ck174 = 0 time = 1750
* CHECK dout1_0 vdout1_0ck174 = 0 time = 1750
* CHECK dout1_1 vdout1_1ck174 = 0 time = 1750
* CHECK dout1_2 vdout1_2ck174 = 0 time = 1750
* CHECK dout1_3 vdout1_3ck174 = 0 time = 1750
* CHECK dout1_4 vdout1_4ck174 = 3.3 time = 1750
* CHECK dout1_5 vdout1_5ck174 = 3.3 time = 1750
* CHECK dout1_6 vdout1_6ck174 = 3.3 time = 1750
* CHECK dout1_7 vdout1_7ck174 = 3.3 time = 1750
* CHECK dout1_8 vdout1_8ck174 = 0 time = 1750
* CHECK dout1_9 vdout1_9ck174 = 0 time = 1750
* CHECK dout1_10 vdout1_10ck174 = 0 time = 1750
* CHECK dout1_11 vdout1_11ck174 = 0 time = 1750
* CHECK dout1_12 vdout1_12ck174 = 3.3 time = 1750
* CHECK dout1_13 vdout1_13ck174 = 0 time = 1750
* CHECK dout1_14 vdout1_14ck174 = 3.3 time = 1750
* CHECK dout1_15 vdout1_15ck174 = 3.3 time = 1750
* CHECK dout1_16 vdout1_16ck174 = 3.3 time = 1750
* CHECK dout1_17 vdout1_17ck174 = 3.3 time = 1750
* CHECK dout1_18 vdout1_18ck174 = 0 time = 1750
* CHECK dout1_19 vdout1_19ck174 = 0 time = 1750
* CHECK dout1_20 vdout1_20ck174 = 3.3 time = 1750
* CHECK dout1_21 vdout1_21ck174 = 3.3 time = 1750
* CHECK dout1_22 vdout1_22ck174 = 0 time = 1750
* CHECK dout1_23 vdout1_23ck174 = 0 time = 1750
* CHECK dout1_24 vdout1_24ck174 = 3.3 time = 1750
* CHECK dout1_25 vdout1_25ck174 = 3.3 time = 1750
* CHECK dout1_26 vdout1_26ck174 = 0 time = 1750
* CHECK dout1_27 vdout1_27ck174 = 3.3 time = 1750
* CHECK dout1_28 vdout1_28ck174 = 0 time = 1750
* CHECK dout1_29 vdout1_29ck174 = 3.3 time = 1750
* CHECK dout1_30 vdout1_30ck174 = 3.3 time = 1750
* CHECK dout1_31 vdout1_31ck174 = 0 time = 1750
* CHECK dout1_0 vdout1_0ck175 = 0 time = 1760
* CHECK dout1_1 vdout1_1ck175 = 3.3 time = 1760
* CHECK dout1_2 vdout1_2ck175 = 3.3 time = 1760
* CHECK dout1_3 vdout1_3ck175 = 3.3 time = 1760
* CHECK dout1_4 vdout1_4ck175 = 3.3 time = 1760
* CHECK dout1_5 vdout1_5ck175 = 0 time = 1760
* CHECK dout1_6 vdout1_6ck175 = 0 time = 1760
* CHECK dout1_7 vdout1_7ck175 = 0 time = 1760
* CHECK dout1_8 vdout1_8ck175 = 3.3 time = 1760
* CHECK dout1_9 vdout1_9ck175 = 3.3 time = 1760
* CHECK dout1_10 vdout1_10ck175 = 3.3 time = 1760
* CHECK dout1_11 vdout1_11ck175 = 3.3 time = 1760
* CHECK dout1_12 vdout1_12ck175 = 0 time = 1760
* CHECK dout1_13 vdout1_13ck175 = 3.3 time = 1760
* CHECK dout1_14 vdout1_14ck175 = 0 time = 1760
* CHECK dout1_15 vdout1_15ck175 = 3.3 time = 1760
* CHECK dout1_16 vdout1_16ck175 = 3.3 time = 1760
* CHECK dout1_17 vdout1_17ck175 = 0 time = 1760
* CHECK dout1_18 vdout1_18ck175 = 0 time = 1760
* CHECK dout1_19 vdout1_19ck175 = 3.3 time = 1760
* CHECK dout1_20 vdout1_20ck175 = 3.3 time = 1760
* CHECK dout1_21 vdout1_21ck175 = 3.3 time = 1760
* CHECK dout1_22 vdout1_22ck175 = 3.3 time = 1760
* CHECK dout1_23 vdout1_23ck175 = 0 time = 1760
* CHECK dout1_24 vdout1_24ck175 = 0 time = 1760
* CHECK dout1_25 vdout1_25ck175 = 3.3 time = 1760
* CHECK dout1_26 vdout1_26ck175 = 0 time = 1760
* CHECK dout1_27 vdout1_27ck175 = 0 time = 1760
* CHECK dout1_28 vdout1_28ck175 = 3.3 time = 1760
* CHECK dout1_29 vdout1_29ck175 = 0 time = 1760
* CHECK dout1_30 vdout1_30ck175 = 0 time = 1760
* CHECK dout1_31 vdout1_31ck175 = 0 time = 1760
* CHECK dout0_0 vdout0_0ck176 = 0 time = 1770
* CHECK dout0_1 vdout0_1ck176 = 0 time = 1770
* CHECK dout0_2 vdout0_2ck176 = 0 time = 1770
* CHECK dout0_3 vdout0_3ck176 = 0 time = 1770
* CHECK dout0_4 vdout0_4ck176 = 3.3 time = 1770
* CHECK dout0_5 vdout0_5ck176 = 3.3 time = 1770
* CHECK dout0_6 vdout0_6ck176 = 3.3 time = 1770
* CHECK dout0_7 vdout0_7ck176 = 3.3 time = 1770
* CHECK dout0_8 vdout0_8ck176 = 0 time = 1770
* CHECK dout0_9 vdout0_9ck176 = 0 time = 1770
* CHECK dout0_10 vdout0_10ck176 = 0 time = 1770
* CHECK dout0_11 vdout0_11ck176 = 0 time = 1770
* CHECK dout0_12 vdout0_12ck176 = 3.3 time = 1770
* CHECK dout0_13 vdout0_13ck176 = 0 time = 1770
* CHECK dout0_14 vdout0_14ck176 = 3.3 time = 1770
* CHECK dout0_15 vdout0_15ck176 = 3.3 time = 1770
* CHECK dout0_16 vdout0_16ck176 = 3.3 time = 1770
* CHECK dout0_17 vdout0_17ck176 = 3.3 time = 1770
* CHECK dout0_18 vdout0_18ck176 = 0 time = 1770
* CHECK dout0_19 vdout0_19ck176 = 0 time = 1770
* CHECK dout0_20 vdout0_20ck176 = 3.3 time = 1770
* CHECK dout0_21 vdout0_21ck176 = 3.3 time = 1770
* CHECK dout0_22 vdout0_22ck176 = 0 time = 1770
* CHECK dout0_23 vdout0_23ck176 = 0 time = 1770
* CHECK dout0_24 vdout0_24ck176 = 3.3 time = 1770
* CHECK dout0_25 vdout0_25ck176 = 3.3 time = 1770
* CHECK dout0_26 vdout0_26ck176 = 0 time = 1770
* CHECK dout0_27 vdout0_27ck176 = 3.3 time = 1770
* CHECK dout0_28 vdout0_28ck176 = 0 time = 1770
* CHECK dout0_29 vdout0_29ck176 = 3.3 time = 1770
* CHECK dout0_30 vdout0_30ck176 = 3.3 time = 1770
* CHECK dout0_31 vdout0_31ck176 = 0 time = 1770
* CHECK dout1_0 vdout1_0ck176 = 0 time = 1770
* CHECK dout1_1 vdout1_1ck176 = 0 time = 1770
* CHECK dout1_2 vdout1_2ck176 = 0 time = 1770
* CHECK dout1_3 vdout1_3ck176 = 0 time = 1770
* CHECK dout1_4 vdout1_4ck176 = 3.3 time = 1770
* CHECK dout1_5 vdout1_5ck176 = 3.3 time = 1770
* CHECK dout1_6 vdout1_6ck176 = 3.3 time = 1770
* CHECK dout1_7 vdout1_7ck176 = 3.3 time = 1770
* CHECK dout1_8 vdout1_8ck176 = 0 time = 1770
* CHECK dout1_9 vdout1_9ck176 = 0 time = 1770
* CHECK dout1_10 vdout1_10ck176 = 0 time = 1770
* CHECK dout1_11 vdout1_11ck176 = 0 time = 1770
* CHECK dout1_12 vdout1_12ck176 = 3.3 time = 1770
* CHECK dout1_13 vdout1_13ck176 = 0 time = 1770
* CHECK dout1_14 vdout1_14ck176 = 3.3 time = 1770
* CHECK dout1_15 vdout1_15ck176 = 3.3 time = 1770
* CHECK dout1_16 vdout1_16ck176 = 3.3 time = 1770
* CHECK dout1_17 vdout1_17ck176 = 3.3 time = 1770
* CHECK dout1_18 vdout1_18ck176 = 0 time = 1770
* CHECK dout1_19 vdout1_19ck176 = 0 time = 1770
* CHECK dout1_20 vdout1_20ck176 = 3.3 time = 1770
* CHECK dout1_21 vdout1_21ck176 = 3.3 time = 1770
* CHECK dout1_22 vdout1_22ck176 = 0 time = 1770
* CHECK dout1_23 vdout1_23ck176 = 0 time = 1770
* CHECK dout1_24 vdout1_24ck176 = 3.3 time = 1770
* CHECK dout1_25 vdout1_25ck176 = 3.3 time = 1770
* CHECK dout1_26 vdout1_26ck176 = 0 time = 1770
* CHECK dout1_27 vdout1_27ck176 = 3.3 time = 1770
* CHECK dout1_28 vdout1_28ck176 = 0 time = 1770
* CHECK dout1_29 vdout1_29ck176 = 3.3 time = 1770
* CHECK dout1_30 vdout1_30ck176 = 3.3 time = 1770
* CHECK dout1_31 vdout1_31ck176 = 0 time = 1770
* CHECK dout1_0 vdout1_0ck178 = 3.3 time = 1790
* CHECK dout1_1 vdout1_1ck178 = 0 time = 1790
* CHECK dout1_2 vdout1_2ck178 = 3.3 time = 1790
* CHECK dout1_3 vdout1_3ck178 = 3.3 time = 1790
* CHECK dout1_4 vdout1_4ck178 = 3.3 time = 1790
* CHECK dout1_5 vdout1_5ck178 = 0 time = 1790
* CHECK dout1_6 vdout1_6ck178 = 0 time = 1790
* CHECK dout1_7 vdout1_7ck178 = 3.3 time = 1790
* CHECK dout1_8 vdout1_8ck178 = 0 time = 1790
* CHECK dout1_9 vdout1_9ck178 = 3.3 time = 1790
* CHECK dout1_10 vdout1_10ck178 = 0 time = 1790
* CHECK dout1_11 vdout1_11ck178 = 0 time = 1790
* CHECK dout1_12 vdout1_12ck178 = 3.3 time = 1790
* CHECK dout1_13 vdout1_13ck178 = 3.3 time = 1790
* CHECK dout1_14 vdout1_14ck178 = 3.3 time = 1790
* CHECK dout1_15 vdout1_15ck178 = 3.3 time = 1790
* CHECK dout1_16 vdout1_16ck178 = 3.3 time = 1790
* CHECK dout1_17 vdout1_17ck178 = 0 time = 1790
* CHECK dout1_18 vdout1_18ck178 = 0 time = 1790
* CHECK dout1_19 vdout1_19ck178 = 0 time = 1790
* CHECK dout1_20 vdout1_20ck178 = 0 time = 1790
* CHECK dout1_21 vdout1_21ck178 = 3.3 time = 1790
* CHECK dout1_22 vdout1_22ck178 = 0 time = 1790
* CHECK dout1_23 vdout1_23ck178 = 0 time = 1790
* CHECK dout1_24 vdout1_24ck178 = 0 time = 1790
* CHECK dout1_25 vdout1_25ck178 = 3.3 time = 1790
* CHECK dout1_26 vdout1_26ck178 = 3.3 time = 1790
* CHECK dout1_27 vdout1_27ck178 = 3.3 time = 1790
* CHECK dout1_28 vdout1_28ck178 = 0 time = 1790
* CHECK dout1_29 vdout1_29ck178 = 3.3 time = 1790
* CHECK dout1_30 vdout1_30ck178 = 0 time = 1790
* CHECK dout1_31 vdout1_31ck178 = 3.3 time = 1790
* CHECK dout0_0 vdout0_0ck179 = 3.3 time = 1800
* CHECK dout0_1 vdout0_1ck179 = 0 time = 1800
* CHECK dout0_2 vdout0_2ck179 = 3.3 time = 1800
* CHECK dout0_3 vdout0_3ck179 = 3.3 time = 1800
* CHECK dout0_4 vdout0_4ck179 = 3.3 time = 1800
* CHECK dout0_5 vdout0_5ck179 = 0 time = 1800
* CHECK dout0_6 vdout0_6ck179 = 0 time = 1800
* CHECK dout0_7 vdout0_7ck179 = 3.3 time = 1800
* CHECK dout0_8 vdout0_8ck179 = 0 time = 1800
* CHECK dout0_9 vdout0_9ck179 = 3.3 time = 1800
* CHECK dout0_10 vdout0_10ck179 = 0 time = 1800
* CHECK dout0_11 vdout0_11ck179 = 0 time = 1800
* CHECK dout0_12 vdout0_12ck179 = 3.3 time = 1800
* CHECK dout0_13 vdout0_13ck179 = 3.3 time = 1800
* CHECK dout0_14 vdout0_14ck179 = 3.3 time = 1800
* CHECK dout0_15 vdout0_15ck179 = 3.3 time = 1800
* CHECK dout0_16 vdout0_16ck179 = 3.3 time = 1800
* CHECK dout0_17 vdout0_17ck179 = 0 time = 1800
* CHECK dout0_18 vdout0_18ck179 = 0 time = 1800
* CHECK dout0_19 vdout0_19ck179 = 0 time = 1800
* CHECK dout0_20 vdout0_20ck179 = 0 time = 1800
* CHECK dout0_21 vdout0_21ck179 = 3.3 time = 1800
* CHECK dout0_22 vdout0_22ck179 = 0 time = 1800
* CHECK dout0_23 vdout0_23ck179 = 0 time = 1800
* CHECK dout0_24 vdout0_24ck179 = 0 time = 1800
* CHECK dout0_25 vdout0_25ck179 = 3.3 time = 1800
* CHECK dout0_26 vdout0_26ck179 = 3.3 time = 1800
* CHECK dout0_27 vdout0_27ck179 = 3.3 time = 1800
* CHECK dout0_28 vdout0_28ck179 = 0 time = 1800
* CHECK dout0_29 vdout0_29ck179 = 3.3 time = 1800
* CHECK dout0_30 vdout0_30ck179 = 0 time = 1800
* CHECK dout0_31 vdout0_31ck179 = 3.3 time = 1800
* CHECK dout0_0 vdout0_0ck180 = 0 time = 1810
* CHECK dout0_1 vdout0_1ck180 = 3.3 time = 1810
* CHECK dout0_2 vdout0_2ck180 = 0 time = 1810
* CHECK dout0_3 vdout0_3ck180 = 0 time = 1810
* CHECK dout0_4 vdout0_4ck180 = 0 time = 1810
* CHECK dout0_5 vdout0_5ck180 = 3.3 time = 1810
* CHECK dout0_6 vdout0_6ck180 = 0 time = 1810
* CHECK dout0_7 vdout0_7ck180 = 3.3 time = 1810
* CHECK dout0_8 vdout0_8ck180 = 0 time = 1810
* CHECK dout0_9 vdout0_9ck180 = 3.3 time = 1810
* CHECK dout0_10 vdout0_10ck180 = 0 time = 1810
* CHECK dout0_11 vdout0_11ck180 = 0 time = 1810
* CHECK dout0_12 vdout0_12ck180 = 3.3 time = 1810
* CHECK dout0_13 vdout0_13ck180 = 0 time = 1810
* CHECK dout0_14 vdout0_14ck180 = 0 time = 1810
* CHECK dout0_15 vdout0_15ck180 = 0 time = 1810
* CHECK dout0_16 vdout0_16ck180 = 3.3 time = 1810
* CHECK dout0_17 vdout0_17ck180 = 3.3 time = 1810
* CHECK dout0_18 vdout0_18ck180 = 3.3 time = 1810
* CHECK dout0_19 vdout0_19ck180 = 0 time = 1810
* CHECK dout0_20 vdout0_20ck180 = 0 time = 1810
* CHECK dout0_21 vdout0_21ck180 = 3.3 time = 1810
* CHECK dout0_22 vdout0_22ck180 = 0 time = 1810
* CHECK dout0_23 vdout0_23ck180 = 0 time = 1810
* CHECK dout0_24 vdout0_24ck180 = 0 time = 1810
* CHECK dout0_25 vdout0_25ck180 = 3.3 time = 1810
* CHECK dout0_26 vdout0_26ck180 = 0 time = 1810
* CHECK dout0_27 vdout0_27ck180 = 0 time = 1810
* CHECK dout0_28 vdout0_28ck180 = 0 time = 1810
* CHECK dout0_29 vdout0_29ck180 = 0 time = 1810
* CHECK dout0_30 vdout0_30ck180 = 3.3 time = 1810
* CHECK dout0_31 vdout0_31ck180 = 3.3 time = 1810
* CHECK dout1_0 vdout1_0ck180 = 3.3 time = 1810
* CHECK dout1_1 vdout1_1ck180 = 0 time = 1810
* CHECK dout1_2 vdout1_2ck180 = 0 time = 1810
* CHECK dout1_3 vdout1_3ck180 = 0 time = 1810
* CHECK dout1_4 vdout1_4ck180 = 3.3 time = 1810
* CHECK dout1_5 vdout1_5ck180 = 3.3 time = 1810
* CHECK dout1_6 vdout1_6ck180 = 3.3 time = 1810
* CHECK dout1_7 vdout1_7ck180 = 3.3 time = 1810
* CHECK dout1_8 vdout1_8ck180 = 3.3 time = 1810
* CHECK dout1_9 vdout1_9ck180 = 0 time = 1810
* CHECK dout1_10 vdout1_10ck180 = 0 time = 1810
* CHECK dout1_11 vdout1_11ck180 = 0 time = 1810
* CHECK dout1_12 vdout1_12ck180 = 3.3 time = 1810
* CHECK dout1_13 vdout1_13ck180 = 3.3 time = 1810
* CHECK dout1_14 vdout1_14ck180 = 0 time = 1810
* CHECK dout1_15 vdout1_15ck180 = 0 time = 1810
* CHECK dout1_16 vdout1_16ck180 = 3.3 time = 1810
* CHECK dout1_17 vdout1_17ck180 = 3.3 time = 1810
* CHECK dout1_18 vdout1_18ck180 = 0 time = 1810
* CHECK dout1_19 vdout1_19ck180 = 0 time = 1810
* CHECK dout1_20 vdout1_20ck180 = 3.3 time = 1810
* CHECK dout1_21 vdout1_21ck180 = 0 time = 1810
* CHECK dout1_22 vdout1_22ck180 = 0 time = 1810
* CHECK dout1_23 vdout1_23ck180 = 0 time = 1810
* CHECK dout1_24 vdout1_24ck180 = 0 time = 1810
* CHECK dout1_25 vdout1_25ck180 = 3.3 time = 1810
* CHECK dout1_26 vdout1_26ck180 = 3.3 time = 1810
* CHECK dout1_27 vdout1_27ck180 = 0 time = 1810
* CHECK dout1_28 vdout1_28ck180 = 3.3 time = 1810
* CHECK dout1_29 vdout1_29ck180 = 0 time = 1810
* CHECK dout1_30 vdout1_30ck180 = 3.3 time = 1810
* CHECK dout1_31 vdout1_31ck180 = 3.3 time = 1810
* CHECK dout0_0 vdout0_0ck181 = 0 time = 1820
* CHECK dout0_1 vdout0_1ck181 = 3.3 time = 1820
* CHECK dout0_2 vdout0_2ck181 = 0 time = 1820
* CHECK dout0_3 vdout0_3ck181 = 0 time = 1820
* CHECK dout0_4 vdout0_4ck181 = 0 time = 1820
* CHECK dout0_5 vdout0_5ck181 = 3.3 time = 1820
* CHECK dout0_6 vdout0_6ck181 = 0 time = 1820
* CHECK dout0_7 vdout0_7ck181 = 3.3 time = 1820
* CHECK dout0_8 vdout0_8ck181 = 0 time = 1820
* CHECK dout0_9 vdout0_9ck181 = 3.3 time = 1820
* CHECK dout0_10 vdout0_10ck181 = 0 time = 1820
* CHECK dout0_11 vdout0_11ck181 = 0 time = 1820
* CHECK dout0_12 vdout0_12ck181 = 3.3 time = 1820
* CHECK dout0_13 vdout0_13ck181 = 0 time = 1820
* CHECK dout0_14 vdout0_14ck181 = 0 time = 1820
* CHECK dout0_15 vdout0_15ck181 = 0 time = 1820
* CHECK dout0_16 vdout0_16ck181 = 3.3 time = 1820
* CHECK dout0_17 vdout0_17ck181 = 3.3 time = 1820
* CHECK dout0_18 vdout0_18ck181 = 3.3 time = 1820
* CHECK dout0_19 vdout0_19ck181 = 0 time = 1820
* CHECK dout0_20 vdout0_20ck181 = 0 time = 1820
* CHECK dout0_21 vdout0_21ck181 = 3.3 time = 1820
* CHECK dout0_22 vdout0_22ck181 = 0 time = 1820
* CHECK dout0_23 vdout0_23ck181 = 0 time = 1820
* CHECK dout0_24 vdout0_24ck181 = 0 time = 1820
* CHECK dout0_25 vdout0_25ck181 = 3.3 time = 1820
* CHECK dout0_26 vdout0_26ck181 = 0 time = 1820
* CHECK dout0_27 vdout0_27ck181 = 0 time = 1820
* CHECK dout0_28 vdout0_28ck181 = 0 time = 1820
* CHECK dout0_29 vdout0_29ck181 = 0 time = 1820
* CHECK dout0_30 vdout0_30ck181 = 3.3 time = 1820
* CHECK dout0_31 vdout0_31ck181 = 3.3 time = 1820
* CHECK dout1_0 vdout1_0ck181 = 0 time = 1820
* CHECK dout1_1 vdout1_1ck181 = 3.3 time = 1820
* CHECK dout1_2 vdout1_2ck181 = 0 time = 1820
* CHECK dout1_3 vdout1_3ck181 = 0 time = 1820
* CHECK dout1_4 vdout1_4ck181 = 0 time = 1820
* CHECK dout1_5 vdout1_5ck181 = 3.3 time = 1820
* CHECK dout1_6 vdout1_6ck181 = 0 time = 1820
* CHECK dout1_7 vdout1_7ck181 = 3.3 time = 1820
* CHECK dout1_8 vdout1_8ck181 = 0 time = 1820
* CHECK dout1_9 vdout1_9ck181 = 3.3 time = 1820
* CHECK dout1_10 vdout1_10ck181 = 0 time = 1820
* CHECK dout1_11 vdout1_11ck181 = 0 time = 1820
* CHECK dout1_12 vdout1_12ck181 = 3.3 time = 1820
* CHECK dout1_13 vdout1_13ck181 = 0 time = 1820
* CHECK dout1_14 vdout1_14ck181 = 0 time = 1820
* CHECK dout1_15 vdout1_15ck181 = 0 time = 1820
* CHECK dout1_16 vdout1_16ck181 = 3.3 time = 1820
* CHECK dout1_17 vdout1_17ck181 = 3.3 time = 1820
* CHECK dout1_18 vdout1_18ck181 = 3.3 time = 1820
* CHECK dout1_19 vdout1_19ck181 = 0 time = 1820
* CHECK dout1_20 vdout1_20ck181 = 0 time = 1820
* CHECK dout1_21 vdout1_21ck181 = 3.3 time = 1820
* CHECK dout1_22 vdout1_22ck181 = 0 time = 1820
* CHECK dout1_23 vdout1_23ck181 = 0 time = 1820
* CHECK dout1_24 vdout1_24ck181 = 0 time = 1820
* CHECK dout1_25 vdout1_25ck181 = 3.3 time = 1820
* CHECK dout1_26 vdout1_26ck181 = 0 time = 1820
* CHECK dout1_27 vdout1_27ck181 = 0 time = 1820
* CHECK dout1_28 vdout1_28ck181 = 0 time = 1820
* CHECK dout1_29 vdout1_29ck181 = 0 time = 1820
* CHECK dout1_30 vdout1_30ck181 = 3.3 time = 1820
* CHECK dout1_31 vdout1_31ck181 = 3.3 time = 1820
* CHECK dout0_0 vdout0_0ck182 = 0 time = 1830
* CHECK dout0_1 vdout0_1ck182 = 3.3 time = 1830
* CHECK dout0_2 vdout0_2ck182 = 0 time = 1830
* CHECK dout0_3 vdout0_3ck182 = 0 time = 1830
* CHECK dout0_4 vdout0_4ck182 = 0 time = 1830
* CHECK dout0_5 vdout0_5ck182 = 3.3 time = 1830
* CHECK dout0_6 vdout0_6ck182 = 0 time = 1830
* CHECK dout0_7 vdout0_7ck182 = 3.3 time = 1830
* CHECK dout0_8 vdout0_8ck182 = 0 time = 1830
* CHECK dout0_9 vdout0_9ck182 = 3.3 time = 1830
* CHECK dout0_10 vdout0_10ck182 = 0 time = 1830
* CHECK dout0_11 vdout0_11ck182 = 0 time = 1830
* CHECK dout0_12 vdout0_12ck182 = 3.3 time = 1830
* CHECK dout0_13 vdout0_13ck182 = 0 time = 1830
* CHECK dout0_14 vdout0_14ck182 = 0 time = 1830
* CHECK dout0_15 vdout0_15ck182 = 0 time = 1830
* CHECK dout0_16 vdout0_16ck182 = 3.3 time = 1830
* CHECK dout0_17 vdout0_17ck182 = 3.3 time = 1830
* CHECK dout0_18 vdout0_18ck182 = 3.3 time = 1830
* CHECK dout0_19 vdout0_19ck182 = 0 time = 1830
* CHECK dout0_20 vdout0_20ck182 = 0 time = 1830
* CHECK dout0_21 vdout0_21ck182 = 3.3 time = 1830
* CHECK dout0_22 vdout0_22ck182 = 0 time = 1830
* CHECK dout0_23 vdout0_23ck182 = 0 time = 1830
* CHECK dout0_24 vdout0_24ck182 = 0 time = 1830
* CHECK dout0_25 vdout0_25ck182 = 3.3 time = 1830
* CHECK dout0_26 vdout0_26ck182 = 0 time = 1830
* CHECK dout0_27 vdout0_27ck182 = 0 time = 1830
* CHECK dout0_28 vdout0_28ck182 = 0 time = 1830
* CHECK dout0_29 vdout0_29ck182 = 0 time = 1830
* CHECK dout0_30 vdout0_30ck182 = 3.3 time = 1830
* CHECK dout0_31 vdout0_31ck182 = 3.3 time = 1830
* CHECK dout1_0 vdout1_0ck182 = 3.3 time = 1830
* CHECK dout1_1 vdout1_1ck182 = 0 time = 1830
* CHECK dout1_2 vdout1_2ck182 = 0 time = 1830
* CHECK dout1_3 vdout1_3ck182 = 0 time = 1830
* CHECK dout1_4 vdout1_4ck182 = 3.3 time = 1830
* CHECK dout1_5 vdout1_5ck182 = 3.3 time = 1830
* CHECK dout1_6 vdout1_6ck182 = 3.3 time = 1830
* CHECK dout1_7 vdout1_7ck182 = 3.3 time = 1830
* CHECK dout1_8 vdout1_8ck182 = 3.3 time = 1830
* CHECK dout1_9 vdout1_9ck182 = 0 time = 1830
* CHECK dout1_10 vdout1_10ck182 = 0 time = 1830
* CHECK dout1_11 vdout1_11ck182 = 0 time = 1830
* CHECK dout1_12 vdout1_12ck182 = 3.3 time = 1830
* CHECK dout1_13 vdout1_13ck182 = 3.3 time = 1830
* CHECK dout1_14 vdout1_14ck182 = 0 time = 1830
* CHECK dout1_15 vdout1_15ck182 = 0 time = 1830
* CHECK dout1_16 vdout1_16ck182 = 3.3 time = 1830
* CHECK dout1_17 vdout1_17ck182 = 3.3 time = 1830
* CHECK dout1_18 vdout1_18ck182 = 0 time = 1830
* CHECK dout1_19 vdout1_19ck182 = 0 time = 1830
* CHECK dout1_20 vdout1_20ck182 = 3.3 time = 1830
* CHECK dout1_21 vdout1_21ck182 = 0 time = 1830
* CHECK dout1_22 vdout1_22ck182 = 0 time = 1830
* CHECK dout1_23 vdout1_23ck182 = 0 time = 1830
* CHECK dout1_24 vdout1_24ck182 = 0 time = 1830
* CHECK dout1_25 vdout1_25ck182 = 3.3 time = 1830
* CHECK dout1_26 vdout1_26ck182 = 3.3 time = 1830
* CHECK dout1_27 vdout1_27ck182 = 0 time = 1830
* CHECK dout1_28 vdout1_28ck182 = 3.3 time = 1830
* CHECK dout1_29 vdout1_29ck182 = 0 time = 1830
* CHECK dout1_30 vdout1_30ck182 = 3.3 time = 1830
* CHECK dout1_31 vdout1_31ck182 = 3.3 time = 1830
* CHECK dout1_0 vdout1_0ck183 = 3.3 time = 1840
* CHECK dout1_1 vdout1_1ck183 = 0 time = 1840
* CHECK dout1_2 vdout1_2ck183 = 0 time = 1840
* CHECK dout1_3 vdout1_3ck183 = 0 time = 1840
* CHECK dout1_4 vdout1_4ck183 = 3.3 time = 1840
* CHECK dout1_5 vdout1_5ck183 = 3.3 time = 1840
* CHECK dout1_6 vdout1_6ck183 = 3.3 time = 1840
* CHECK dout1_7 vdout1_7ck183 = 3.3 time = 1840
* CHECK dout1_8 vdout1_8ck183 = 3.3 time = 1840
* CHECK dout1_9 vdout1_9ck183 = 0 time = 1840
* CHECK dout1_10 vdout1_10ck183 = 0 time = 1840
* CHECK dout1_11 vdout1_11ck183 = 0 time = 1840
* CHECK dout1_12 vdout1_12ck183 = 3.3 time = 1840
* CHECK dout1_13 vdout1_13ck183 = 3.3 time = 1840
* CHECK dout1_14 vdout1_14ck183 = 0 time = 1840
* CHECK dout1_15 vdout1_15ck183 = 0 time = 1840
* CHECK dout1_16 vdout1_16ck183 = 3.3 time = 1840
* CHECK dout1_17 vdout1_17ck183 = 3.3 time = 1840
* CHECK dout1_18 vdout1_18ck183 = 0 time = 1840
* CHECK dout1_19 vdout1_19ck183 = 0 time = 1840
* CHECK dout1_20 vdout1_20ck183 = 3.3 time = 1840
* CHECK dout1_21 vdout1_21ck183 = 0 time = 1840
* CHECK dout1_22 vdout1_22ck183 = 0 time = 1840
* CHECK dout1_23 vdout1_23ck183 = 0 time = 1840
* CHECK dout1_24 vdout1_24ck183 = 0 time = 1840
* CHECK dout1_25 vdout1_25ck183 = 3.3 time = 1840
* CHECK dout1_26 vdout1_26ck183 = 3.3 time = 1840
* CHECK dout1_27 vdout1_27ck183 = 0 time = 1840
* CHECK dout1_28 vdout1_28ck183 = 3.3 time = 1840
* CHECK dout1_29 vdout1_29ck183 = 0 time = 1840
* CHECK dout1_30 vdout1_30ck183 = 3.3 time = 1840
* CHECK dout1_31 vdout1_31ck183 = 3.3 time = 1840
* CHECK dout1_0 vdout1_0ck186 = 0 time = 1870
* CHECK dout1_1 vdout1_1ck186 = 3.3 time = 1870
* CHECK dout1_2 vdout1_2ck186 = 0 time = 1870
* CHECK dout1_3 vdout1_3ck186 = 0 time = 1870
* CHECK dout1_4 vdout1_4ck186 = 0 time = 1870
* CHECK dout1_5 vdout1_5ck186 = 3.3 time = 1870
* CHECK dout1_6 vdout1_6ck186 = 0 time = 1870
* CHECK dout1_7 vdout1_7ck186 = 3.3 time = 1870
* CHECK dout1_8 vdout1_8ck186 = 0 time = 1870
* CHECK dout1_9 vdout1_9ck186 = 3.3 time = 1870
* CHECK dout1_10 vdout1_10ck186 = 0 time = 1870
* CHECK dout1_11 vdout1_11ck186 = 0 time = 1870
* CHECK dout1_12 vdout1_12ck186 = 3.3 time = 1870
* CHECK dout1_13 vdout1_13ck186 = 0 time = 1870
* CHECK dout1_14 vdout1_14ck186 = 0 time = 1870
* CHECK dout1_15 vdout1_15ck186 = 0 time = 1870
* CHECK dout1_16 vdout1_16ck186 = 3.3 time = 1870
* CHECK dout1_17 vdout1_17ck186 = 3.3 time = 1870
* CHECK dout1_18 vdout1_18ck186 = 3.3 time = 1870
* CHECK dout1_19 vdout1_19ck186 = 0 time = 1870
* CHECK dout1_20 vdout1_20ck186 = 0 time = 1870
* CHECK dout1_21 vdout1_21ck186 = 3.3 time = 1870
* CHECK dout1_22 vdout1_22ck186 = 0 time = 1870
* CHECK dout1_23 vdout1_23ck186 = 0 time = 1870
* CHECK dout1_24 vdout1_24ck186 = 0 time = 1870
* CHECK dout1_25 vdout1_25ck186 = 3.3 time = 1870
* CHECK dout1_26 vdout1_26ck186 = 0 time = 1870
* CHECK dout1_27 vdout1_27ck186 = 0 time = 1870
* CHECK dout1_28 vdout1_28ck186 = 0 time = 1870
* CHECK dout1_29 vdout1_29ck186 = 0 time = 1870
* CHECK dout1_30 vdout1_30ck186 = 3.3 time = 1870
* CHECK dout1_31 vdout1_31ck186 = 3.3 time = 1870
* CHECK dout0_0 vdout0_0ck187 = 3.3 time = 1880
* CHECK dout0_1 vdout0_1ck187 = 3.3 time = 1880
* CHECK dout0_2 vdout0_2ck187 = 3.3 time = 1880
* CHECK dout0_3 vdout0_3ck187 = 0 time = 1880
* CHECK dout0_4 vdout0_4ck187 = 3.3 time = 1880
* CHECK dout0_5 vdout0_5ck187 = 3.3 time = 1880
* CHECK dout0_6 vdout0_6ck187 = 3.3 time = 1880
* CHECK dout0_7 vdout0_7ck187 = 3.3 time = 1880
* CHECK dout0_8 vdout0_8ck187 = 0 time = 1880
* CHECK dout0_9 vdout0_9ck187 = 0 time = 1880
* CHECK dout0_10 vdout0_10ck187 = 3.3 time = 1880
* CHECK dout0_11 vdout0_11ck187 = 3.3 time = 1880
* CHECK dout0_12 vdout0_12ck187 = 0 time = 1880
* CHECK dout0_13 vdout0_13ck187 = 3.3 time = 1880
* CHECK dout0_14 vdout0_14ck187 = 3.3 time = 1880
* CHECK dout0_15 vdout0_15ck187 = 0 time = 1880
* CHECK dout0_16 vdout0_16ck187 = 3.3 time = 1880
* CHECK dout0_17 vdout0_17ck187 = 0 time = 1880
* CHECK dout0_18 vdout0_18ck187 = 3.3 time = 1880
* CHECK dout0_19 vdout0_19ck187 = 3.3 time = 1880
* CHECK dout0_20 vdout0_20ck187 = 3.3 time = 1880
* CHECK dout0_21 vdout0_21ck187 = 3.3 time = 1880
* CHECK dout0_22 vdout0_22ck187 = 3.3 time = 1880
* CHECK dout0_23 vdout0_23ck187 = 0 time = 1880
* CHECK dout0_24 vdout0_24ck187 = 3.3 time = 1880
* CHECK dout0_25 vdout0_25ck187 = 3.3 time = 1880
* CHECK dout0_26 vdout0_26ck187 = 0 time = 1880
* CHECK dout0_27 vdout0_27ck187 = 3.3 time = 1880
* CHECK dout0_28 vdout0_28ck187 = 0 time = 1880
* CHECK dout0_29 vdout0_29ck187 = 3.3 time = 1880
* CHECK dout0_30 vdout0_30ck187 = 3.3 time = 1880
* CHECK dout0_31 vdout0_31ck187 = 0 time = 1880
* CHECK dout1_0 vdout1_0ck187 = 3.3 time = 1880
* CHECK dout1_1 vdout1_1ck187 = 3.3 time = 1880
* CHECK dout1_2 vdout1_2ck187 = 3.3 time = 1880
* CHECK dout1_3 vdout1_3ck187 = 0 time = 1880
* CHECK dout1_4 vdout1_4ck187 = 3.3 time = 1880
* CHECK dout1_5 vdout1_5ck187 = 3.3 time = 1880
* CHECK dout1_6 vdout1_6ck187 = 3.3 time = 1880
* CHECK dout1_7 vdout1_7ck187 = 3.3 time = 1880
* CHECK dout1_8 vdout1_8ck187 = 0 time = 1880
* CHECK dout1_9 vdout1_9ck187 = 0 time = 1880
* CHECK dout1_10 vdout1_10ck187 = 3.3 time = 1880
* CHECK dout1_11 vdout1_11ck187 = 3.3 time = 1880
* CHECK dout1_12 vdout1_12ck187 = 0 time = 1880
* CHECK dout1_13 vdout1_13ck187 = 3.3 time = 1880
* CHECK dout1_14 vdout1_14ck187 = 3.3 time = 1880
* CHECK dout1_15 vdout1_15ck187 = 0 time = 1880
* CHECK dout1_16 vdout1_16ck187 = 3.3 time = 1880
* CHECK dout1_17 vdout1_17ck187 = 0 time = 1880
* CHECK dout1_18 vdout1_18ck187 = 3.3 time = 1880
* CHECK dout1_19 vdout1_19ck187 = 3.3 time = 1880
* CHECK dout1_20 vdout1_20ck187 = 3.3 time = 1880
* CHECK dout1_21 vdout1_21ck187 = 3.3 time = 1880
* CHECK dout1_22 vdout1_22ck187 = 3.3 time = 1880
* CHECK dout1_23 vdout1_23ck187 = 0 time = 1880
* CHECK dout1_24 vdout1_24ck187 = 3.3 time = 1880
* CHECK dout1_25 vdout1_25ck187 = 3.3 time = 1880
* CHECK dout1_26 vdout1_26ck187 = 0 time = 1880
* CHECK dout1_27 vdout1_27ck187 = 3.3 time = 1880
* CHECK dout1_28 vdout1_28ck187 = 0 time = 1880
* CHECK dout1_29 vdout1_29ck187 = 3.3 time = 1880
* CHECK dout1_30 vdout1_30ck187 = 3.3 time = 1880
* CHECK dout1_31 vdout1_31ck187 = 0 time = 1880
* CHECK dout0_0 vdout0_0ck190 = 3.3 time = 1910
* CHECK dout0_1 vdout0_1ck190 = 0 time = 1910
* CHECK dout0_2 vdout0_2ck190 = 0 time = 1910
* CHECK dout0_3 vdout0_3ck190 = 0 time = 1910
* CHECK dout0_4 vdout0_4ck190 = 0 time = 1910
* CHECK dout0_5 vdout0_5ck190 = 3.3 time = 1910
* CHECK dout0_6 vdout0_6ck190 = 3.3 time = 1910
* CHECK dout0_7 vdout0_7ck190 = 3.3 time = 1910
* CHECK dout0_8 vdout0_8ck190 = 3.3 time = 1910
* CHECK dout0_9 vdout0_9ck190 = 0 time = 1910
* CHECK dout0_10 vdout0_10ck190 = 0 time = 1910
* CHECK dout0_11 vdout0_11ck190 = 3.3 time = 1910
* CHECK dout0_12 vdout0_12ck190 = 3.3 time = 1910
* CHECK dout0_13 vdout0_13ck190 = 3.3 time = 1910
* CHECK dout0_14 vdout0_14ck190 = 3.3 time = 1910
* CHECK dout0_15 vdout0_15ck190 = 0 time = 1910
* CHECK dout0_16 vdout0_16ck190 = 0 time = 1910
* CHECK dout0_17 vdout0_17ck190 = 3.3 time = 1910
* CHECK dout0_18 vdout0_18ck190 = 3.3 time = 1910
* CHECK dout0_19 vdout0_19ck190 = 0 time = 1910
* CHECK dout0_20 vdout0_20ck190 = 3.3 time = 1910
* CHECK dout0_21 vdout0_21ck190 = 0 time = 1910
* CHECK dout0_22 vdout0_22ck190 = 0 time = 1910
* CHECK dout0_23 vdout0_23ck190 = 3.3 time = 1910
* CHECK dout0_24 vdout0_24ck190 = 3.3 time = 1910
* CHECK dout0_25 vdout0_25ck190 = 0 time = 1910
* CHECK dout0_26 vdout0_26ck190 = 0 time = 1910
* CHECK dout0_27 vdout0_27ck190 = 3.3 time = 1910
* CHECK dout0_28 vdout0_28ck190 = 0 time = 1910
* CHECK dout0_29 vdout0_29ck190 = 3.3 time = 1910
* CHECK dout0_30 vdout0_30ck190 = 0 time = 1910
* CHECK dout0_31 vdout0_31ck190 = 3.3 time = 1910
* CHECK dout1_0 vdout1_0ck190 = 3.3 time = 1910
* CHECK dout1_1 vdout1_1ck190 = 0 time = 1910
* CHECK dout1_2 vdout1_2ck190 = 0 time = 1910
* CHECK dout1_3 vdout1_3ck190 = 0 time = 1910
* CHECK dout1_4 vdout1_4ck190 = 0 time = 1910
* CHECK dout1_5 vdout1_5ck190 = 3.3 time = 1910
* CHECK dout1_6 vdout1_6ck190 = 3.3 time = 1910
* CHECK dout1_7 vdout1_7ck190 = 3.3 time = 1910
* CHECK dout1_8 vdout1_8ck190 = 3.3 time = 1910
* CHECK dout1_9 vdout1_9ck190 = 0 time = 1910
* CHECK dout1_10 vdout1_10ck190 = 0 time = 1910
* CHECK dout1_11 vdout1_11ck190 = 3.3 time = 1910
* CHECK dout1_12 vdout1_12ck190 = 3.3 time = 1910
* CHECK dout1_13 vdout1_13ck190 = 3.3 time = 1910
* CHECK dout1_14 vdout1_14ck190 = 3.3 time = 1910
* CHECK dout1_15 vdout1_15ck190 = 0 time = 1910
* CHECK dout1_16 vdout1_16ck190 = 0 time = 1910
* CHECK dout1_17 vdout1_17ck190 = 3.3 time = 1910
* CHECK dout1_18 vdout1_18ck190 = 3.3 time = 1910
* CHECK dout1_19 vdout1_19ck190 = 0 time = 1910
* CHECK dout1_20 vdout1_20ck190 = 3.3 time = 1910
* CHECK dout1_21 vdout1_21ck190 = 0 time = 1910
* CHECK dout1_22 vdout1_22ck190 = 0 time = 1910
* CHECK dout1_23 vdout1_23ck190 = 3.3 time = 1910
* CHECK dout1_24 vdout1_24ck190 = 3.3 time = 1910
* CHECK dout1_25 vdout1_25ck190 = 0 time = 1910
* CHECK dout1_26 vdout1_26ck190 = 0 time = 1910
* CHECK dout1_27 vdout1_27ck190 = 3.3 time = 1910
* CHECK dout1_28 vdout1_28ck190 = 0 time = 1910
* CHECK dout1_29 vdout1_29ck190 = 3.3 time = 1910
* CHECK dout1_30 vdout1_30ck190 = 0 time = 1910
* CHECK dout1_31 vdout1_31ck190 = 3.3 time = 1910
* CHECK dout0_0 vdout0_0ck191 = 3.3 time = 1920
* CHECK dout0_1 vdout0_1ck191 = 0 time = 1920
* CHECK dout0_2 vdout0_2ck191 = 0 time = 1920
* CHECK dout0_3 vdout0_3ck191 = 0 time = 1920
* CHECK dout0_4 vdout0_4ck191 = 3.3 time = 1920
* CHECK dout0_5 vdout0_5ck191 = 3.3 time = 1920
* CHECK dout0_6 vdout0_6ck191 = 3.3 time = 1920
* CHECK dout0_7 vdout0_7ck191 = 3.3 time = 1920
* CHECK dout0_8 vdout0_8ck191 = 3.3 time = 1920
* CHECK dout0_9 vdout0_9ck191 = 3.3 time = 1920
* CHECK dout0_10 vdout0_10ck191 = 0 time = 1920
* CHECK dout0_11 vdout0_11ck191 = 0 time = 1920
* CHECK dout0_12 vdout0_12ck191 = 3.3 time = 1920
* CHECK dout0_13 vdout0_13ck191 = 0 time = 1920
* CHECK dout0_14 vdout0_14ck191 = 0 time = 1920
* CHECK dout0_15 vdout0_15ck191 = 0 time = 1920
* CHECK dout0_16 vdout0_16ck191 = 3.3 time = 1920
* CHECK dout0_17 vdout0_17ck191 = 0 time = 1920
* CHECK dout0_18 vdout0_18ck191 = 3.3 time = 1920
* CHECK dout0_19 vdout0_19ck191 = 3.3 time = 1920
* CHECK dout0_20 vdout0_20ck191 = 0 time = 1920
* CHECK dout0_21 vdout0_21ck191 = 0 time = 1920
* CHECK dout0_22 vdout0_22ck191 = 0 time = 1920
* CHECK dout0_23 vdout0_23ck191 = 0 time = 1920
* CHECK dout0_24 vdout0_24ck191 = 0 time = 1920
* CHECK dout0_25 vdout0_25ck191 = 0 time = 1920
* CHECK dout0_26 vdout0_26ck191 = 3.3 time = 1920
* CHECK dout0_27 vdout0_27ck191 = 3.3 time = 1920
* CHECK dout0_28 vdout0_28ck191 = 0 time = 1920
* CHECK dout0_29 vdout0_29ck191 = 0 time = 1920
* CHECK dout0_30 vdout0_30ck191 = 3.3 time = 1920
* CHECK dout0_31 vdout0_31ck191 = 3.3 time = 1920
* CHECK dout1_0 vdout1_0ck191 = 3.3 time = 1920
* CHECK dout1_1 vdout1_1ck191 = 0 time = 1920
* CHECK dout1_2 vdout1_2ck191 = 0 time = 1920
* CHECK dout1_3 vdout1_3ck191 = 0 time = 1920
* CHECK dout1_4 vdout1_4ck191 = 0 time = 1920
* CHECK dout1_5 vdout1_5ck191 = 3.3 time = 1920
* CHECK dout1_6 vdout1_6ck191 = 3.3 time = 1920
* CHECK dout1_7 vdout1_7ck191 = 3.3 time = 1920
* CHECK dout1_8 vdout1_8ck191 = 3.3 time = 1920
* CHECK dout1_9 vdout1_9ck191 = 0 time = 1920
* CHECK dout1_10 vdout1_10ck191 = 0 time = 1920
* CHECK dout1_11 vdout1_11ck191 = 3.3 time = 1920
* CHECK dout1_12 vdout1_12ck191 = 3.3 time = 1920
* CHECK dout1_13 vdout1_13ck191 = 3.3 time = 1920
* CHECK dout1_14 vdout1_14ck191 = 3.3 time = 1920
* CHECK dout1_15 vdout1_15ck191 = 0 time = 1920
* CHECK dout1_16 vdout1_16ck191 = 0 time = 1920
* CHECK dout1_17 vdout1_17ck191 = 3.3 time = 1920
* CHECK dout1_18 vdout1_18ck191 = 3.3 time = 1920
* CHECK dout1_19 vdout1_19ck191 = 0 time = 1920
* CHECK dout1_20 vdout1_20ck191 = 3.3 time = 1920
* CHECK dout1_21 vdout1_21ck191 = 0 time = 1920
* CHECK dout1_22 vdout1_22ck191 = 0 time = 1920
* CHECK dout1_23 vdout1_23ck191 = 3.3 time = 1920
* CHECK dout1_24 vdout1_24ck191 = 3.3 time = 1920
* CHECK dout1_25 vdout1_25ck191 = 0 time = 1920
* CHECK dout1_26 vdout1_26ck191 = 0 time = 1920
* CHECK dout1_27 vdout1_27ck191 = 3.3 time = 1920
* CHECK dout1_28 vdout1_28ck191 = 0 time = 1920
* CHECK dout1_29 vdout1_29ck191 = 3.3 time = 1920
* CHECK dout1_30 vdout1_30ck191 = 0 time = 1920
* CHECK dout1_31 vdout1_31ck191 = 3.3 time = 1920
* CHECK dout0_0 vdout0_0ck192 = 3.3 time = 1930
* CHECK dout0_1 vdout0_1ck192 = 0 time = 1930
* CHECK dout0_2 vdout0_2ck192 = 0 time = 1930
* CHECK dout0_3 vdout0_3ck192 = 0 time = 1930
* CHECK dout0_4 vdout0_4ck192 = 3.3 time = 1930
* CHECK dout0_5 vdout0_5ck192 = 3.3 time = 1930
* CHECK dout0_6 vdout0_6ck192 = 3.3 time = 1930
* CHECK dout0_7 vdout0_7ck192 = 3.3 time = 1930
* CHECK dout0_8 vdout0_8ck192 = 3.3 time = 1930
* CHECK dout0_9 vdout0_9ck192 = 3.3 time = 1930
* CHECK dout0_10 vdout0_10ck192 = 0 time = 1930
* CHECK dout0_11 vdout0_11ck192 = 0 time = 1930
* CHECK dout0_12 vdout0_12ck192 = 3.3 time = 1930
* CHECK dout0_13 vdout0_13ck192 = 0 time = 1930
* CHECK dout0_14 vdout0_14ck192 = 0 time = 1930
* CHECK dout0_15 vdout0_15ck192 = 0 time = 1930
* CHECK dout0_16 vdout0_16ck192 = 3.3 time = 1930
* CHECK dout0_17 vdout0_17ck192 = 0 time = 1930
* CHECK dout0_18 vdout0_18ck192 = 3.3 time = 1930
* CHECK dout0_19 vdout0_19ck192 = 3.3 time = 1930
* CHECK dout0_20 vdout0_20ck192 = 0 time = 1930
* CHECK dout0_21 vdout0_21ck192 = 0 time = 1930
* CHECK dout0_22 vdout0_22ck192 = 0 time = 1930
* CHECK dout0_23 vdout0_23ck192 = 0 time = 1930
* CHECK dout0_24 vdout0_24ck192 = 0 time = 1930
* CHECK dout0_25 vdout0_25ck192 = 0 time = 1930
* CHECK dout0_26 vdout0_26ck192 = 3.3 time = 1930
* CHECK dout0_27 vdout0_27ck192 = 3.3 time = 1930
* CHECK dout0_28 vdout0_28ck192 = 0 time = 1930
* CHECK dout0_29 vdout0_29ck192 = 0 time = 1930
* CHECK dout0_30 vdout0_30ck192 = 3.3 time = 1930
* CHECK dout0_31 vdout0_31ck192 = 3.3 time = 1930
* CHECK dout1_0 vdout1_0ck192 = 3.3 time = 1930
* CHECK dout1_1 vdout1_1ck192 = 0 time = 1930
* CHECK dout1_2 vdout1_2ck192 = 0 time = 1930
* CHECK dout1_3 vdout1_3ck192 = 0 time = 1930
* CHECK dout1_4 vdout1_4ck192 = 0 time = 1930
* CHECK dout1_5 vdout1_5ck192 = 3.3 time = 1930
* CHECK dout1_6 vdout1_6ck192 = 3.3 time = 1930
* CHECK dout1_7 vdout1_7ck192 = 3.3 time = 1930
* CHECK dout1_8 vdout1_8ck192 = 3.3 time = 1930
* CHECK dout1_9 vdout1_9ck192 = 0 time = 1930
* CHECK dout1_10 vdout1_10ck192 = 0 time = 1930
* CHECK dout1_11 vdout1_11ck192 = 3.3 time = 1930
* CHECK dout1_12 vdout1_12ck192 = 3.3 time = 1930
* CHECK dout1_13 vdout1_13ck192 = 3.3 time = 1930
* CHECK dout1_14 vdout1_14ck192 = 3.3 time = 1930
* CHECK dout1_15 vdout1_15ck192 = 0 time = 1930
* CHECK dout1_16 vdout1_16ck192 = 0 time = 1930
* CHECK dout1_17 vdout1_17ck192 = 3.3 time = 1930
* CHECK dout1_18 vdout1_18ck192 = 3.3 time = 1930
* CHECK dout1_19 vdout1_19ck192 = 0 time = 1930
* CHECK dout1_20 vdout1_20ck192 = 3.3 time = 1930
* CHECK dout1_21 vdout1_21ck192 = 0 time = 1930
* CHECK dout1_22 vdout1_22ck192 = 0 time = 1930
* CHECK dout1_23 vdout1_23ck192 = 3.3 time = 1930
* CHECK dout1_24 vdout1_24ck192 = 3.3 time = 1930
* CHECK dout1_25 vdout1_25ck192 = 0 time = 1930
* CHECK dout1_26 vdout1_26ck192 = 0 time = 1930
* CHECK dout1_27 vdout1_27ck192 = 3.3 time = 1930
* CHECK dout1_28 vdout1_28ck192 = 0 time = 1930
* CHECK dout1_29 vdout1_29ck192 = 3.3 time = 1930
* CHECK dout1_30 vdout1_30ck192 = 0 time = 1930
* CHECK dout1_31 vdout1_31ck192 = 3.3 time = 1930
* CHECK dout0_0 vdout0_0ck194 = 0 time = 1950
* CHECK dout0_1 vdout0_1ck194 = 3.3 time = 1950
* CHECK dout0_2 vdout0_2ck194 = 3.3 time = 1950
* CHECK dout0_3 vdout0_3ck194 = 0 time = 1950
* CHECK dout0_4 vdout0_4ck194 = 0 time = 1950
* CHECK dout0_5 vdout0_5ck194 = 3.3 time = 1950
* CHECK dout0_6 vdout0_6ck194 = 3.3 time = 1950
* CHECK dout0_7 vdout0_7ck194 = 0 time = 1950
* CHECK dout0_8 vdout0_8ck194 = 3.3 time = 1950
* CHECK dout0_9 vdout0_9ck194 = 0 time = 1950
* CHECK dout0_10 vdout0_10ck194 = 0 time = 1950
* CHECK dout0_11 vdout0_11ck194 = 3.3 time = 1950
* CHECK dout0_12 vdout0_12ck194 = 3.3 time = 1950
* CHECK dout0_13 vdout0_13ck194 = 3.3 time = 1950
* CHECK dout0_14 vdout0_14ck194 = 0 time = 1950
* CHECK dout0_15 vdout0_15ck194 = 0 time = 1950
* CHECK dout0_16 vdout0_16ck194 = 0 time = 1950
* CHECK dout0_17 vdout0_17ck194 = 3.3 time = 1950
* CHECK dout0_18 vdout0_18ck194 = 3.3 time = 1950
* CHECK dout0_19 vdout0_19ck194 = 3.3 time = 1950
* CHECK dout0_20 vdout0_20ck194 = 3.3 time = 1950
* CHECK dout0_21 vdout0_21ck194 = 3.3 time = 1950
* CHECK dout0_22 vdout0_22ck194 = 3.3 time = 1950
* CHECK dout0_23 vdout0_23ck194 = 3.3 time = 1950
* CHECK dout0_24 vdout0_24ck194 = 0 time = 1950
* CHECK dout0_25 vdout0_25ck194 = 0 time = 1950
* CHECK dout0_26 vdout0_26ck194 = 3.3 time = 1950
* CHECK dout0_27 vdout0_27ck194 = 3.3 time = 1950
* CHECK dout0_28 vdout0_28ck194 = 3.3 time = 1950
* CHECK dout0_29 vdout0_29ck194 = 3.3 time = 1950
* CHECK dout0_30 vdout0_30ck194 = 3.3 time = 1950
* CHECK dout0_31 vdout0_31ck194 = 3.3 time = 1950
* CHECK dout1_0 vdout1_0ck194 = 0 time = 1950
* CHECK dout1_1 vdout1_1ck194 = 3.3 time = 1950
* CHECK dout1_2 vdout1_2ck194 = 3.3 time = 1950
* CHECK dout1_3 vdout1_3ck194 = 0 time = 1950
* CHECK dout1_4 vdout1_4ck194 = 0 time = 1950
* CHECK dout1_5 vdout1_5ck194 = 3.3 time = 1950
* CHECK dout1_6 vdout1_6ck194 = 3.3 time = 1950
* CHECK dout1_7 vdout1_7ck194 = 0 time = 1950
* CHECK dout1_8 vdout1_8ck194 = 3.3 time = 1950
* CHECK dout1_9 vdout1_9ck194 = 0 time = 1950
* CHECK dout1_10 vdout1_10ck194 = 0 time = 1950
* CHECK dout1_11 vdout1_11ck194 = 3.3 time = 1950
* CHECK dout1_12 vdout1_12ck194 = 3.3 time = 1950
* CHECK dout1_13 vdout1_13ck194 = 3.3 time = 1950
* CHECK dout1_14 vdout1_14ck194 = 0 time = 1950
* CHECK dout1_15 vdout1_15ck194 = 0 time = 1950
* CHECK dout1_16 vdout1_16ck194 = 0 time = 1950
* CHECK dout1_17 vdout1_17ck194 = 3.3 time = 1950
* CHECK dout1_18 vdout1_18ck194 = 3.3 time = 1950
* CHECK dout1_19 vdout1_19ck194 = 3.3 time = 1950
* CHECK dout1_20 vdout1_20ck194 = 3.3 time = 1950
* CHECK dout1_21 vdout1_21ck194 = 3.3 time = 1950
* CHECK dout1_22 vdout1_22ck194 = 3.3 time = 1950
* CHECK dout1_23 vdout1_23ck194 = 3.3 time = 1950
* CHECK dout1_24 vdout1_24ck194 = 0 time = 1950
* CHECK dout1_25 vdout1_25ck194 = 0 time = 1950
* CHECK dout1_26 vdout1_26ck194 = 3.3 time = 1950
* CHECK dout1_27 vdout1_27ck194 = 3.3 time = 1950
* CHECK dout1_28 vdout1_28ck194 = 3.3 time = 1950
* CHECK dout1_29 vdout1_29ck194 = 3.3 time = 1950
* CHECK dout1_30 vdout1_30ck194 = 3.3 time = 1950
* CHECK dout1_31 vdout1_31ck194 = 3.3 time = 1950
* CHECK dout0_0 vdout0_0ck195 = 0 time = 1960
* CHECK dout0_1 vdout0_1ck195 = 3.3 time = 1960
* CHECK dout0_2 vdout0_2ck195 = 3.3 time = 1960
* CHECK dout0_3 vdout0_3ck195 = 0 time = 1960
* CHECK dout0_4 vdout0_4ck195 = 0 time = 1960
* CHECK dout0_5 vdout0_5ck195 = 3.3 time = 1960
* CHECK dout0_6 vdout0_6ck195 = 3.3 time = 1960
* CHECK dout0_7 vdout0_7ck195 = 0 time = 1960
* CHECK dout0_8 vdout0_8ck195 = 3.3 time = 1960
* CHECK dout0_9 vdout0_9ck195 = 0 time = 1960
* CHECK dout0_10 vdout0_10ck195 = 0 time = 1960
* CHECK dout0_11 vdout0_11ck195 = 3.3 time = 1960
* CHECK dout0_12 vdout0_12ck195 = 3.3 time = 1960
* CHECK dout0_13 vdout0_13ck195 = 3.3 time = 1960
* CHECK dout0_14 vdout0_14ck195 = 0 time = 1960
* CHECK dout0_15 vdout0_15ck195 = 0 time = 1960
* CHECK dout0_16 vdout0_16ck195 = 0 time = 1960
* CHECK dout0_17 vdout0_17ck195 = 3.3 time = 1960
* CHECK dout0_18 vdout0_18ck195 = 3.3 time = 1960
* CHECK dout0_19 vdout0_19ck195 = 3.3 time = 1960
* CHECK dout0_20 vdout0_20ck195 = 3.3 time = 1960
* CHECK dout0_21 vdout0_21ck195 = 3.3 time = 1960
* CHECK dout0_22 vdout0_22ck195 = 3.3 time = 1960
* CHECK dout0_23 vdout0_23ck195 = 3.3 time = 1960
* CHECK dout0_24 vdout0_24ck195 = 0 time = 1960
* CHECK dout0_25 vdout0_25ck195 = 0 time = 1960
* CHECK dout0_26 vdout0_26ck195 = 3.3 time = 1960
* CHECK dout0_27 vdout0_27ck195 = 3.3 time = 1960
* CHECK dout0_28 vdout0_28ck195 = 3.3 time = 1960
* CHECK dout0_29 vdout0_29ck195 = 3.3 time = 1960
* CHECK dout0_30 vdout0_30ck195 = 3.3 time = 1960
* CHECK dout0_31 vdout0_31ck195 = 3.3 time = 1960
* CHECK dout0_0 vdout0_0ck196 = 3.3 time = 1970
* CHECK dout0_1 vdout0_1ck196 = 0 time = 1970
* CHECK dout0_2 vdout0_2ck196 = 0 time = 1970
* CHECK dout0_3 vdout0_3ck196 = 0 time = 1970
* CHECK dout0_4 vdout0_4ck196 = 0 time = 1970
* CHECK dout0_5 vdout0_5ck196 = 3.3 time = 1970
* CHECK dout0_6 vdout0_6ck196 = 3.3 time = 1970
* CHECK dout0_7 vdout0_7ck196 = 3.3 time = 1970
* CHECK dout0_8 vdout0_8ck196 = 3.3 time = 1970
* CHECK dout0_9 vdout0_9ck196 = 0 time = 1970
* CHECK dout0_10 vdout0_10ck196 = 0 time = 1970
* CHECK dout0_11 vdout0_11ck196 = 3.3 time = 1970
* CHECK dout0_12 vdout0_12ck196 = 3.3 time = 1970
* CHECK dout0_13 vdout0_13ck196 = 3.3 time = 1970
* CHECK dout0_14 vdout0_14ck196 = 3.3 time = 1970
* CHECK dout0_15 vdout0_15ck196 = 0 time = 1970
* CHECK dout0_16 vdout0_16ck196 = 0 time = 1970
* CHECK dout0_17 vdout0_17ck196 = 3.3 time = 1970
* CHECK dout0_18 vdout0_18ck196 = 3.3 time = 1970
* CHECK dout0_19 vdout0_19ck196 = 0 time = 1970
* CHECK dout0_20 vdout0_20ck196 = 3.3 time = 1970
* CHECK dout0_21 vdout0_21ck196 = 0 time = 1970
* CHECK dout0_22 vdout0_22ck196 = 0 time = 1970
* CHECK dout0_23 vdout0_23ck196 = 3.3 time = 1970
* CHECK dout0_24 vdout0_24ck196 = 3.3 time = 1970
* CHECK dout0_25 vdout0_25ck196 = 0 time = 1970
* CHECK dout0_26 vdout0_26ck196 = 0 time = 1970
* CHECK dout0_27 vdout0_27ck196 = 3.3 time = 1970
* CHECK dout0_28 vdout0_28ck196 = 0 time = 1970
* CHECK dout0_29 vdout0_29ck196 = 3.3 time = 1970
* CHECK dout0_30 vdout0_30ck196 = 0 time = 1970
* CHECK dout0_31 vdout0_31ck196 = 3.3 time = 1970
* CHECK dout0_0 vdout0_0ck197 = 3.3 time = 1980
* CHECK dout0_1 vdout0_1ck197 = 0 time = 1980
* CHECK dout0_2 vdout0_2ck197 = 0 time = 1980
* CHECK dout0_3 vdout0_3ck197 = 0 time = 1980
* CHECK dout0_4 vdout0_4ck197 = 0 time = 1980
* CHECK dout0_5 vdout0_5ck197 = 3.3 time = 1980
* CHECK dout0_6 vdout0_6ck197 = 3.3 time = 1980
* CHECK dout0_7 vdout0_7ck197 = 3.3 time = 1980
* CHECK dout0_8 vdout0_8ck197 = 3.3 time = 1980
* CHECK dout0_9 vdout0_9ck197 = 0 time = 1980
* CHECK dout0_10 vdout0_10ck197 = 0 time = 1980
* CHECK dout0_11 vdout0_11ck197 = 3.3 time = 1980
* CHECK dout0_12 vdout0_12ck197 = 3.3 time = 1980
* CHECK dout0_13 vdout0_13ck197 = 3.3 time = 1980
* CHECK dout0_14 vdout0_14ck197 = 3.3 time = 1980
* CHECK dout0_15 vdout0_15ck197 = 0 time = 1980
* CHECK dout0_16 vdout0_16ck197 = 0 time = 1980
* CHECK dout0_17 vdout0_17ck197 = 3.3 time = 1980
* CHECK dout0_18 vdout0_18ck197 = 3.3 time = 1980
* CHECK dout0_19 vdout0_19ck197 = 0 time = 1980
* CHECK dout0_20 vdout0_20ck197 = 3.3 time = 1980
* CHECK dout0_21 vdout0_21ck197 = 0 time = 1980
* CHECK dout0_22 vdout0_22ck197 = 0 time = 1980
* CHECK dout0_23 vdout0_23ck197 = 3.3 time = 1980
* CHECK dout0_24 vdout0_24ck197 = 3.3 time = 1980
* CHECK dout0_25 vdout0_25ck197 = 0 time = 1980
* CHECK dout0_26 vdout0_26ck197 = 0 time = 1980
* CHECK dout0_27 vdout0_27ck197 = 3.3 time = 1980
* CHECK dout0_28 vdout0_28ck197 = 0 time = 1980
* CHECK dout0_29 vdout0_29ck197 = 3.3 time = 1980
* CHECK dout0_30 vdout0_30ck197 = 0 time = 1980
* CHECK dout0_31 vdout0_31ck197 = 3.3 time = 1980
* CHECK dout1_0 vdout1_0ck197 = 3.3 time = 1980
* CHECK dout1_1 vdout1_1ck197 = 0 time = 1980
* CHECK dout1_2 vdout1_2ck197 = 0 time = 1980
* CHECK dout1_3 vdout1_3ck197 = 0 time = 1980
* CHECK dout1_4 vdout1_4ck197 = 0 time = 1980
* CHECK dout1_5 vdout1_5ck197 = 3.3 time = 1980
* CHECK dout1_6 vdout1_6ck197 = 3.3 time = 1980
* CHECK dout1_7 vdout1_7ck197 = 3.3 time = 1980
* CHECK dout1_8 vdout1_8ck197 = 3.3 time = 1980
* CHECK dout1_9 vdout1_9ck197 = 0 time = 1980
* CHECK dout1_10 vdout1_10ck197 = 0 time = 1980
* CHECK dout1_11 vdout1_11ck197 = 3.3 time = 1980
* CHECK dout1_12 vdout1_12ck197 = 3.3 time = 1980
* CHECK dout1_13 vdout1_13ck197 = 3.3 time = 1980
* CHECK dout1_14 vdout1_14ck197 = 3.3 time = 1980
* CHECK dout1_15 vdout1_15ck197 = 0 time = 1980
* CHECK dout1_16 vdout1_16ck197 = 0 time = 1980
* CHECK dout1_17 vdout1_17ck197 = 3.3 time = 1980
* CHECK dout1_18 vdout1_18ck197 = 3.3 time = 1980
* CHECK dout1_19 vdout1_19ck197 = 0 time = 1980
* CHECK dout1_20 vdout1_20ck197 = 3.3 time = 1980
* CHECK dout1_21 vdout1_21ck197 = 0 time = 1980
* CHECK dout1_22 vdout1_22ck197 = 0 time = 1980
* CHECK dout1_23 vdout1_23ck197 = 3.3 time = 1980
* CHECK dout1_24 vdout1_24ck197 = 3.3 time = 1980
* CHECK dout1_25 vdout1_25ck197 = 0 time = 1980
* CHECK dout1_26 vdout1_26ck197 = 0 time = 1980
* CHECK dout1_27 vdout1_27ck197 = 3.3 time = 1980
* CHECK dout1_28 vdout1_28ck197 = 0 time = 1980
* CHECK dout1_29 vdout1_29ck197 = 3.3 time = 1980
* CHECK dout1_30 vdout1_30ck197 = 0 time = 1980
* CHECK dout1_31 vdout1_31ck197 = 3.3 time = 1980
* CHECK dout0_0 vdout0_0ck199 = 3.3 time = 2000
* CHECK dout0_1 vdout0_1ck199 = 0 time = 2000
* CHECK dout0_2 vdout0_2ck199 = 0 time = 2000
* CHECK dout0_3 vdout0_3ck199 = 0 time = 2000
* CHECK dout0_4 vdout0_4ck199 = 3.3 time = 2000
* CHECK dout0_5 vdout0_5ck199 = 0 time = 2000
* CHECK dout0_6 vdout0_6ck199 = 3.3 time = 2000
* CHECK dout0_7 vdout0_7ck199 = 3.3 time = 2000
* CHECK dout0_8 vdout0_8ck199 = 3.3 time = 2000
* CHECK dout0_9 vdout0_9ck199 = 3.3 time = 2000
* CHECK dout0_10 vdout0_10ck199 = 3.3 time = 2000
* CHECK dout0_11 vdout0_11ck199 = 3.3 time = 2000
* CHECK dout0_12 vdout0_12ck199 = 0 time = 2000
* CHECK dout0_13 vdout0_13ck199 = 3.3 time = 2000
* CHECK dout0_14 vdout0_14ck199 = 3.3 time = 2000
* CHECK dout0_15 vdout0_15ck199 = 0 time = 2000
* CHECK dout0_16 vdout0_16ck199 = 3.3 time = 2000
* CHECK dout0_17 vdout0_17ck199 = 0 time = 2000
* CHECK dout0_18 vdout0_18ck199 = 3.3 time = 2000
* CHECK dout0_19 vdout0_19ck199 = 3.3 time = 2000
* CHECK dout0_20 vdout0_20ck199 = 0 time = 2000
* CHECK dout0_21 vdout0_21ck199 = 3.3 time = 2000
* CHECK dout0_22 vdout0_22ck199 = 0 time = 2000
* CHECK dout0_23 vdout0_23ck199 = 0 time = 2000
* CHECK dout0_24 vdout0_24ck199 = 0 time = 2000
* CHECK dout0_25 vdout0_25ck199 = 0 time = 2000
* CHECK dout0_26 vdout0_26ck199 = 0 time = 2000
* CHECK dout0_27 vdout0_27ck199 = 0 time = 2000
* CHECK dout0_28 vdout0_28ck199 = 3.3 time = 2000
* CHECK dout0_29 vdout0_29ck199 = 0 time = 2000
* CHECK dout0_30 vdout0_30ck199 = 3.3 time = 2000
* CHECK dout0_31 vdout0_31ck199 = 3.3 time = 2000
* CHECK dout1_0 vdout1_0ck199 = 3.3 time = 2000
* CHECK dout1_1 vdout1_1ck199 = 0 time = 2000
* CHECK dout1_2 vdout1_2ck199 = 0 time = 2000
* CHECK dout1_3 vdout1_3ck199 = 0 time = 2000
* CHECK dout1_4 vdout1_4ck199 = 3.3 time = 2000
* CHECK dout1_5 vdout1_5ck199 = 0 time = 2000
* CHECK dout1_6 vdout1_6ck199 = 3.3 time = 2000
* CHECK dout1_7 vdout1_7ck199 = 3.3 time = 2000
* CHECK dout1_8 vdout1_8ck199 = 3.3 time = 2000
* CHECK dout1_9 vdout1_9ck199 = 3.3 time = 2000
* CHECK dout1_10 vdout1_10ck199 = 3.3 time = 2000
* CHECK dout1_11 vdout1_11ck199 = 3.3 time = 2000
* CHECK dout1_12 vdout1_12ck199 = 0 time = 2000
* CHECK dout1_13 vdout1_13ck199 = 3.3 time = 2000
* CHECK dout1_14 vdout1_14ck199 = 3.3 time = 2000
* CHECK dout1_15 vdout1_15ck199 = 0 time = 2000
* CHECK dout1_16 vdout1_16ck199 = 3.3 time = 2000
* CHECK dout1_17 vdout1_17ck199 = 0 time = 2000
* CHECK dout1_18 vdout1_18ck199 = 3.3 time = 2000
* CHECK dout1_19 vdout1_19ck199 = 3.3 time = 2000
* CHECK dout1_20 vdout1_20ck199 = 0 time = 2000
* CHECK dout1_21 vdout1_21ck199 = 3.3 time = 2000
* CHECK dout1_22 vdout1_22ck199 = 0 time = 2000
* CHECK dout1_23 vdout1_23ck199 = 0 time = 2000
* CHECK dout1_24 vdout1_24ck199 = 0 time = 2000
* CHECK dout1_25 vdout1_25ck199 = 0 time = 2000
* CHECK dout1_26 vdout1_26ck199 = 0 time = 2000
* CHECK dout1_27 vdout1_27ck199 = 0 time = 2000
* CHECK dout1_28 vdout1_28ck199 = 3.3 time = 2000
* CHECK dout1_29 vdout1_29ck199 = 0 time = 2000
* CHECK dout1_30 vdout1_30ck199 = 3.3 time = 2000
* CHECK dout1_31 vdout1_31ck199 = 3.3 time = 2000
* CHECK dout0_0 vdout0_0ck200 = 3.3 time = 2010
* CHECK dout0_1 vdout0_1ck200 = 0 time = 2010
* CHECK dout0_2 vdout0_2ck200 = 0 time = 2010
* CHECK dout0_3 vdout0_3ck200 = 0 time = 2010
* CHECK dout0_4 vdout0_4ck200 = 3.3 time = 2010
* CHECK dout0_5 vdout0_5ck200 = 0 time = 2010
* CHECK dout0_6 vdout0_6ck200 = 3.3 time = 2010
* CHECK dout0_7 vdout0_7ck200 = 3.3 time = 2010
* CHECK dout0_8 vdout0_8ck200 = 3.3 time = 2010
* CHECK dout0_9 vdout0_9ck200 = 3.3 time = 2010
* CHECK dout0_10 vdout0_10ck200 = 3.3 time = 2010
* CHECK dout0_11 vdout0_11ck200 = 3.3 time = 2010
* CHECK dout0_12 vdout0_12ck200 = 0 time = 2010
* CHECK dout0_13 vdout0_13ck200 = 3.3 time = 2010
* CHECK dout0_14 vdout0_14ck200 = 3.3 time = 2010
* CHECK dout0_15 vdout0_15ck200 = 0 time = 2010
* CHECK dout0_16 vdout0_16ck200 = 3.3 time = 2010
* CHECK dout0_17 vdout0_17ck200 = 0 time = 2010
* CHECK dout0_18 vdout0_18ck200 = 3.3 time = 2010
* CHECK dout0_19 vdout0_19ck200 = 3.3 time = 2010
* CHECK dout0_20 vdout0_20ck200 = 0 time = 2010
* CHECK dout0_21 vdout0_21ck200 = 3.3 time = 2010
* CHECK dout0_22 vdout0_22ck200 = 0 time = 2010
* CHECK dout0_23 vdout0_23ck200 = 0 time = 2010
* CHECK dout0_24 vdout0_24ck200 = 0 time = 2010
* CHECK dout0_25 vdout0_25ck200 = 0 time = 2010
* CHECK dout0_26 vdout0_26ck200 = 0 time = 2010
* CHECK dout0_27 vdout0_27ck200 = 0 time = 2010
* CHECK dout0_28 vdout0_28ck200 = 3.3 time = 2010
* CHECK dout0_29 vdout0_29ck200 = 0 time = 2010
* CHECK dout0_30 vdout0_30ck200 = 3.3 time = 2010
* CHECK dout0_31 vdout0_31ck200 = 3.3 time = 2010
* CHECK dout1_0 vdout1_0ck200 = 0 time = 2010
* CHECK dout1_1 vdout1_1ck200 = 3.3 time = 2010
* CHECK dout1_2 vdout1_2ck200 = 0 time = 2010
* CHECK dout1_3 vdout1_3ck200 = 3.3 time = 2010
* CHECK dout1_4 vdout1_4ck200 = 0 time = 2010
* CHECK dout1_5 vdout1_5ck200 = 3.3 time = 2010
* CHECK dout1_6 vdout1_6ck200 = 3.3 time = 2010
* CHECK dout1_7 vdout1_7ck200 = 0 time = 2010
* CHECK dout1_8 vdout1_8ck200 = 0 time = 2010
* CHECK dout1_9 vdout1_9ck200 = 3.3 time = 2010
* CHECK dout1_10 vdout1_10ck200 = 0 time = 2010
* CHECK dout1_11 vdout1_11ck200 = 0 time = 2010
* CHECK dout1_12 vdout1_12ck200 = 3.3 time = 2010
* CHECK dout1_13 vdout1_13ck200 = 0 time = 2010
* CHECK dout1_14 vdout1_14ck200 = 0 time = 2010
* CHECK dout1_15 vdout1_15ck200 = 3.3 time = 2010
* CHECK dout1_16 vdout1_16ck200 = 3.3 time = 2010
* CHECK dout1_17 vdout1_17ck200 = 0 time = 2010
* CHECK dout1_18 vdout1_18ck200 = 0 time = 2010
* CHECK dout1_19 vdout1_19ck200 = 3.3 time = 2010
* CHECK dout1_20 vdout1_20ck200 = 3.3 time = 2010
* CHECK dout1_21 vdout1_21ck200 = 3.3 time = 2010
* CHECK dout1_22 vdout1_22ck200 = 3.3 time = 2010
* CHECK dout1_23 vdout1_23ck200 = 0 time = 2010
* CHECK dout1_24 vdout1_24ck200 = 3.3 time = 2010
* CHECK dout1_25 vdout1_25ck200 = 3.3 time = 2010
* CHECK dout1_26 vdout1_26ck200 = 0 time = 2010
* CHECK dout1_27 vdout1_27ck200 = 3.3 time = 2010
* CHECK dout1_28 vdout1_28ck200 = 3.3 time = 2010
* CHECK dout1_29 vdout1_29ck200 = 3.3 time = 2010
* CHECK dout1_30 vdout1_30ck200 = 0 time = 2010
* CHECK dout1_31 vdout1_31ck200 = 0 time = 2010
* CHECK dout1_0 vdout1_0ck201 = 3.3 time = 2020
* CHECK dout1_1 vdout1_1ck201 = 0 time = 2020
* CHECK dout1_2 vdout1_2ck201 = 0 time = 2020
* CHECK dout1_3 vdout1_3ck201 = 0 time = 2020
* CHECK dout1_4 vdout1_4ck201 = 3.3 time = 2020
* CHECK dout1_5 vdout1_5ck201 = 0 time = 2020
* CHECK dout1_6 vdout1_6ck201 = 3.3 time = 2020
* CHECK dout1_7 vdout1_7ck201 = 3.3 time = 2020
* CHECK dout1_8 vdout1_8ck201 = 3.3 time = 2020
* CHECK dout1_9 vdout1_9ck201 = 3.3 time = 2020
* CHECK dout1_10 vdout1_10ck201 = 3.3 time = 2020
* CHECK dout1_11 vdout1_11ck201 = 3.3 time = 2020
* CHECK dout1_12 vdout1_12ck201 = 0 time = 2020
* CHECK dout1_13 vdout1_13ck201 = 3.3 time = 2020
* CHECK dout1_14 vdout1_14ck201 = 3.3 time = 2020
* CHECK dout1_15 vdout1_15ck201 = 0 time = 2020
* CHECK dout1_16 vdout1_16ck201 = 3.3 time = 2020
* CHECK dout1_17 vdout1_17ck201 = 0 time = 2020
* CHECK dout1_18 vdout1_18ck201 = 3.3 time = 2020
* CHECK dout1_19 vdout1_19ck201 = 3.3 time = 2020
* CHECK dout1_20 vdout1_20ck201 = 0 time = 2020
* CHECK dout1_21 vdout1_21ck201 = 3.3 time = 2020
* CHECK dout1_22 vdout1_22ck201 = 0 time = 2020
* CHECK dout1_23 vdout1_23ck201 = 0 time = 2020
* CHECK dout1_24 vdout1_24ck201 = 0 time = 2020
* CHECK dout1_25 vdout1_25ck201 = 0 time = 2020
* CHECK dout1_26 vdout1_26ck201 = 0 time = 2020
* CHECK dout1_27 vdout1_27ck201 = 0 time = 2020
* CHECK dout1_28 vdout1_28ck201 = 3.3 time = 2020
* CHECK dout1_29 vdout1_29ck201 = 0 time = 2020
* CHECK dout1_30 vdout1_30ck201 = 3.3 time = 2020
* CHECK dout1_31 vdout1_31ck201 = 3.3 time = 2020
* CHECK dout0_0 vdout0_0ck202 = 3.3 time = 2030
* CHECK dout0_1 vdout0_1ck202 = 0 time = 2030
* CHECK dout0_2 vdout0_2ck202 = 0 time = 2030
* CHECK dout0_3 vdout0_3ck202 = 0 time = 2030
* CHECK dout0_4 vdout0_4ck202 = 3.3 time = 2030
* CHECK dout0_5 vdout0_5ck202 = 0 time = 2030
* CHECK dout0_6 vdout0_6ck202 = 3.3 time = 2030
* CHECK dout0_7 vdout0_7ck202 = 3.3 time = 2030
* CHECK dout0_8 vdout0_8ck202 = 3.3 time = 2030
* CHECK dout0_9 vdout0_9ck202 = 3.3 time = 2030
* CHECK dout0_10 vdout0_10ck202 = 3.3 time = 2030
* CHECK dout0_11 vdout0_11ck202 = 3.3 time = 2030
* CHECK dout0_12 vdout0_12ck202 = 0 time = 2030
* CHECK dout0_13 vdout0_13ck202 = 3.3 time = 2030
* CHECK dout0_14 vdout0_14ck202 = 3.3 time = 2030
* CHECK dout0_15 vdout0_15ck202 = 0 time = 2030
* CHECK dout0_16 vdout0_16ck202 = 3.3 time = 2030
* CHECK dout0_17 vdout0_17ck202 = 0 time = 2030
* CHECK dout0_18 vdout0_18ck202 = 3.3 time = 2030
* CHECK dout0_19 vdout0_19ck202 = 3.3 time = 2030
* CHECK dout0_20 vdout0_20ck202 = 0 time = 2030
* CHECK dout0_21 vdout0_21ck202 = 3.3 time = 2030
* CHECK dout0_22 vdout0_22ck202 = 0 time = 2030
* CHECK dout0_23 vdout0_23ck202 = 0 time = 2030
* CHECK dout0_24 vdout0_24ck202 = 0 time = 2030
* CHECK dout0_25 vdout0_25ck202 = 0 time = 2030
* CHECK dout0_26 vdout0_26ck202 = 0 time = 2030
* CHECK dout0_27 vdout0_27ck202 = 0 time = 2030
* CHECK dout0_28 vdout0_28ck202 = 3.3 time = 2030
* CHECK dout0_29 vdout0_29ck202 = 0 time = 2030
* CHECK dout0_30 vdout0_30ck202 = 3.3 time = 2030
* CHECK dout0_31 vdout0_31ck202 = 3.3 time = 2030
* CHECK dout0_0 vdout0_0ck204 = 3.3 time = 2050
* CHECK dout0_1 vdout0_1ck204 = 0 time = 2050
* CHECK dout0_2 vdout0_2ck204 = 3.3 time = 2050
* CHECK dout0_3 vdout0_3ck204 = 3.3 time = 2050
* CHECK dout0_4 vdout0_4ck204 = 3.3 time = 2050
* CHECK dout0_5 vdout0_5ck204 = 3.3 time = 2050
* CHECK dout0_6 vdout0_6ck204 = 0 time = 2050
* CHECK dout0_7 vdout0_7ck204 = 3.3 time = 2050
* CHECK dout0_8 vdout0_8ck204 = 0 time = 2050
* CHECK dout0_9 vdout0_9ck204 = 0 time = 2050
* CHECK dout0_10 vdout0_10ck204 = 0 time = 2050
* CHECK dout0_11 vdout0_11ck204 = 0 time = 2050
* CHECK dout0_12 vdout0_12ck204 = 0 time = 2050
* CHECK dout0_13 vdout0_13ck204 = 0 time = 2050
* CHECK dout0_14 vdout0_14ck204 = 0 time = 2050
* CHECK dout0_15 vdout0_15ck204 = 3.3 time = 2050
* CHECK dout0_16 vdout0_16ck204 = 0 time = 2050
* CHECK dout0_17 vdout0_17ck204 = 3.3 time = 2050
* CHECK dout0_18 vdout0_18ck204 = 3.3 time = 2050
* CHECK dout0_19 vdout0_19ck204 = 3.3 time = 2050
* CHECK dout0_20 vdout0_20ck204 = 0 time = 2050
* CHECK dout0_21 vdout0_21ck204 = 0 time = 2050
* CHECK dout0_22 vdout0_22ck204 = 0 time = 2050
* CHECK dout0_23 vdout0_23ck204 = 3.3 time = 2050
* CHECK dout0_24 vdout0_24ck204 = 3.3 time = 2050
* CHECK dout0_25 vdout0_25ck204 = 0 time = 2050
* CHECK dout0_26 vdout0_26ck204 = 0 time = 2050
* CHECK dout0_27 vdout0_27ck204 = 0 time = 2050
* CHECK dout0_28 vdout0_28ck204 = 3.3 time = 2050
* CHECK dout0_29 vdout0_29ck204 = 3.3 time = 2050
* CHECK dout0_30 vdout0_30ck204 = 0 time = 2050
* CHECK dout0_31 vdout0_31ck204 = 0 time = 2050
.include /lscratch/fanals/asic-data-operation/OpenRAM/temp/functional_meas.sp
* probe is used for hspice/xa, while plot is used in ngspice
*.probe V(*)
*.plot V(*)
.end
