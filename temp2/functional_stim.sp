* Functional test stimulus file for 10ns period

* TT process corner
.lib "/u1/fanals/asic-data-operation/OpenRAM/sky130A/libs.tech/ngspice/sky130.lib.spice" tt
.include "/tmp/openram_fanals_530459_temp/sram.sp"

* Global Power Supplies
Vvdd vdd 0 3.3

*Nodes gnd and 0 are the same global ground node in ngspice/hspice/xa. Otherwise, this source may be needed.
Vgnd gnd 0 0.0

* Instantiation of the SRAM
Xsram_16x2 din0_0 din0_1 din0_2 din0_3 din0_4 din0_5 din0_6 din0_7 din0_8 din0_9 din0_10 din0_11 din0_12 din0_13 din0_14 din0_15 din0_16 din0_17 din0_18 din0_19 din0_20 din0_21 din0_22 din0_23 din0_24 din0_25 din0_26 din0_27 din0_28 din0_29 din0_30 din0_31 din1_0 din1_1 din1_2 din1_3 din1_4 din1_5 din1_6 din1_7 din1_8 din1_9 din1_10 din1_11 din1_12 din1_13 din1_14 din1_15 din1_16 din1_17 din1_18 din1_19 din1_20 din1_21 din1_22 din1_23 din1_24 din1_25 din1_26 din1_27 din1_28 din1_29 din1_30 din1_31 a0_0 a0_1 a0_2 a0_3 a1_0 a1_1 a1_2 a1_3 CSB0 CSB1 WEB0 WEB1 clk0 clk1 dout0_0 dout0_1 dout0_2 dout0_3 dout0_4 dout0_5 dout0_6 dout0_7 dout0_8 dout0_9 dout0_10 dout0_11 dout0_12 dout0_13 dout0_14 dout0_15 dout0_16 dout0_17 dout0_18 dout0_19 dout0_20 dout0_21 dout0_22 dout0_23 dout0_24 dout0_25 dout0_26 dout0_27 dout0_28 dout0_29 dout0_30 dout0_31 dout1_0 dout1_1 dout1_2 dout1_3 dout1_4 dout1_5 dout1_6 dout1_7 dout1_8 dout1_9 dout1_10 dout1_11 dout1_12 dout1_13 dout1_14 dout1_15 dout1_16 dout1_17 dout1_18 dout1_19 dout1_20 dout1_21 dout1_22 dout1_23 dout1_24 dout1_25 dout1_26 dout1_27 dout1_28 dout1_29 dout1_30 dout1_31 vdd gnd sram_16x2

* SRAM output loads
CD00 dout0_0  0 27.56f
CD01 dout0_1  0 27.56f
CD02 dout0_2  0 27.56f
CD03 dout0_3  0 27.56f
CD04 dout0_4  0 27.56f
CD05 dout0_5  0 27.56f
CD06 dout0_6  0 27.56f
CD07 dout0_7  0 27.56f
CD08 dout0_8  0 27.56f
CD09 dout0_9  0 27.56f
CD010 dout0_10  0 27.56f
CD011 dout0_11  0 27.56f
CD012 dout0_12  0 27.56f
CD013 dout0_13  0 27.56f
CD014 dout0_14  0 27.56f
CD015 dout0_15  0 27.56f
CD016 dout0_16  0 27.56f
CD017 dout0_17  0 27.56f
CD018 dout0_18  0 27.56f
CD019 dout0_19  0 27.56f
CD020 dout0_20  0 27.56f
CD021 dout0_21  0 27.56f
CD022 dout0_22  0 27.56f
CD023 dout0_23  0 27.56f
CD024 dout0_24  0 27.56f
CD025 dout0_25  0 27.56f
CD026 dout0_26  0 27.56f
CD027 dout0_27  0 27.56f
CD028 dout0_28  0 27.56f
CD029 dout0_29  0 27.56f
CD030 dout0_30  0 27.56f
CD031 dout0_31  0 27.56f
CD10 dout1_0  0 27.56f
CD11 dout1_1  0 27.56f
CD12 dout1_2  0 27.56f
CD13 dout1_3  0 27.56f
CD14 dout1_4  0 27.56f
CD15 dout1_5  0 27.56f
CD16 dout1_6  0 27.56f
CD17 dout1_7  0 27.56f
CD18 dout1_8  0 27.56f
CD19 dout1_9  0 27.56f
CD110 dout1_10  0 27.56f
CD111 dout1_11  0 27.56f
CD112 dout1_12  0 27.56f
CD113 dout1_13  0 27.56f
CD114 dout1_14  0 27.56f
CD115 dout1_15  0 27.56f
CD116 dout1_16  0 27.56f
CD117 dout1_17  0 27.56f
CD118 dout1_18  0 27.56f
CD119 dout1_19  0 27.56f
CD120 dout1_20  0 27.56f
CD121 dout1_21  0 27.56f
CD122 dout1_22  0 27.56f
CD123 dout1_23  0 27.56f
CD124 dout1_24  0 27.56f
CD125 dout1_25  0 27.56f
CD126 dout1_26  0 27.56f
CD127 dout1_27  0 27.56f
CD128 dout1_28  0 27.56f
CD129 dout1_29  0 27.56f
CD130 dout1_30  0 27.56f
CD131 dout1_31  0 27.56f

* Important signals for debug
* bl:	xsram:xbank0:bl_0_1
* br:	xsram:xbank0:br_0_1
* s_en:	xsram:s_en
* q:	xsram:xbank0:xbitcell_array:xbitcell_array:xbit_r0_c0:Q
* qbar:	xsram:xbank0:xbitcell_array:xbitcell_array:xbit_r0_c0:Q_bar

* Sequence of operations
*	Idle during cycle 0 (0ns - 10ns)
*	Writing 11100011010110101001011000100101  to  address 1110 (from port 0) during cycle 1 (10ns - 20ns)
*	Writing 10100000000110101000111001101101  to  address 0000 (from port 1) during cycle 1 (10ns - 20ns)
*	Writing 10010101001100000101110010000001  to  address 1110 (from port 0) during cycle 2 (20ns - 30ns)
*	Writing 00110100010010001010111001011011  to  address 0000 (from port 1) during cycle 2 (20ns - 30ns)
*	Writing 11011000101110010111100010000011  to  address 1110 (from port 0) during cycle 3 (30ns - 40ns)
*	Writing 00010011100000100101001001001100  to  address 1110 (from port 1) during cycle 3 (30ns - 40ns)
*	Reading 00110100010010001010111001011011 from address 0000 (from port 0) during cycle 4 (40ns - 50ns)
*	Reading 00110100010010001010111001011011 from address 0000 (from port 1) during cycle 4 (40ns - 50ns)
*	Reading 00110100010010001010111001011011 from address 0000 (from port 0) during cycle 5 (50ns - 60ns)
*	Reading 00110100010010001010111001011011 from address 0000 (from port 1) during cycle 5 (50ns - 60ns)
*	Writing 11110011100100010101111110011111  to  address 0000 (from port 0) during cycle 6 (60ns - 70ns)
*	Writing 01110101110111111010101100010110  to  address 0000 (from port 1) during cycle 7 (70ns - 80ns)
*	Writing 10000100000100100001101011100111  to  address 1110 (from port 1) during cycle 8 (80ns - 90ns)
*	Reading 10000100000100100001101011100111 from address 1110 (from port 0) during cycle 9 (90ns - 100ns)
*	Writing 01110111000000111101000011101110  to  address 0000 (from port 0) during cycle 10 (100ns - 110ns)
*	Reading 10000100000100100001101011100111 from address 1110 (from port 1) during cycle 10 (100ns - 110ns)
*	Reading 10000100000100100001101011100111 from address 1110 (from port 0) during cycle 11 (110ns - 120ns)
*	Reading 10000100000100100001101011100111 from address 1110 (from port 0) during cycle 12 (120ns - 130ns)
*	Writing 01100011010001101100010111011101  to  address 0000 (from port 1) during cycle 12 (120ns - 130ns)
*	Reading 10000100000100100001101011100111 from address 1110 (from port 1) during cycle 13 (130ns - 140ns)
*	Writing 01001011100000111011101110011000  to  address 0000 (from port 1) during cycle 14 (140ns - 150ns)
*	Reading 01001011100000111011101110011000 from address 0000 (from port 0) during cycle 15 (150ns - 160ns)
*	Writing 01010111000001101001101000100011  to  address 1110 (from port 0) during cycle 16 (160ns - 170ns)
*	Reading 01010111000001101001101000100011 from address 1110 (from port 0) during cycle 17 (170ns - 180ns)
*	Writing 01011110100111001101100101101000  to  address 1110 (from port 1) during cycle 17 (170ns - 180ns)
*	Reading 01001011100000111011101110011000 from address 0000 (from port 0) during cycle 18 (180ns - 190ns)
*	Reading 01011110100111001101100101101000 from address 1110 (from port 1) during cycle 18 (180ns - 190ns)
*	Reading 01011110100111001101100101101000 from address 1110 (from port 0) during cycle 19 (190ns - 200ns)
*	Reading 01011110100111001101100101101000 from address 1110 (from port 1) during cycle 19 (190ns - 200ns)
*	Reading 01001011100000111011101110011000 from address 0000 (from port 0) during cycle 20 (200ns - 210ns)
*	Reading 01001011100000111011101110011000 from address 0000 (from port 0) during cycle 21 (210ns - 220ns)
*	Writing 10001000001110010011110101110001  to  address 1110 (from port 0) during cycle 22 (220ns - 230ns)
*	Reading 10001000001110010011110101110001 from address 1110 (from port 0) during cycle 23 (230ns - 240ns)
*	Reading 01001011100000111011101110011000 from address 0000 (from port 1) during cycle 23 (230ns - 240ns)
*	Reading 10001000001110010011110101110001 from address 1110 (from port 0) during cycle 24 (240ns - 250ns)
*	Writing 00011011100100001111011100010001  to  address 0000 (from port 1) during cycle 24 (240ns - 250ns)
*	Reading 00011011100100001111011100010001 from address 0000 (from port 0) during cycle 25 (250ns - 260ns)
*	Reading 00011011100100001111011100010001 from address 0000 (from port 1) during cycle 25 (250ns - 260ns)
*	Writing 11110001101111011100001000110000  to  address 0000 (from port 0) during cycle 26 (260ns - 270ns)
*	Writing 11111111011111001001111000101000  to  address 1110 (from port 0) during cycle 27 (270ns - 280ns)
*	Writing 00111100101010001111111001010001  to  address 1110 (from port 0) during cycle 28 (280ns - 290ns)
*	Reading 11110001101111011100001000110000 from address 0000 (from port 1) during cycle 28 (280ns - 290ns)
*	Writing 11100111011001010110101111100111  to  address 0000 (from port 0) during cycle 29 (290ns - 300ns)
*	Writing 10010010000101111110111011010111  to  address 1110 (from port 0) during cycle 31 (310ns - 320ns)
*	Reading 11100111011001010110101111100111 from address 0000 (from port 0) during cycle 32 (320ns - 330ns)
*	Writing 01100100111100010111101001000000  to  address 1110 (from port 0) during cycle 33 (330ns - 340ns)
*	Writing 10111001100000010101001100110001  to  address 1110 (from port 0) during cycle 34 (340ns - 350ns)
*	Reading 11100111011001010110101111100111 from address 0000 (from port 0) during cycle 35 (350ns - 360ns)
*	Reading 11100111011001010110101111100111 from address 0000 (from port 1) during cycle 35 (350ns - 360ns)
*	Reading 11100111011001010110101111100111 from address 0000 (from port 0) during cycle 36 (360ns - 370ns)
*	Reading 11100111011001010110101111100111 from address 0000 (from port 0) during cycle 37 (370ns - 380ns)
*	Writing 00001110110101011011000000001100  to  address 1110 (from port 1) during cycle 37 (370ns - 380ns)
*	Reading 00001110110101011011000000001100 from address 1110 (from port 0) during cycle 38 (380ns - 390ns)
*	Writing 00011011001001001010101111001001  to  address 0000 (from port 1) during cycle 38 (380ns - 390ns)
*	Writing 10111010010111001011100000001001  to  address 0000 (from port 0) during cycle 39 (390ns - 400ns)
*	Reading 00001110110101011011000000001100 from address 1110 (from port 0) during cycle 40 (400ns - 410ns)
*	Writing 11100001010010101011011000011000  to  address 0000 (from port 1) during cycle 40 (400ns - 410ns)
*	Reading 00001110110101011011000000001100 from address 1110 (from port 1) during cycle 41 (410ns - 420ns)
*	Writing 01100001001011111001100000000101  to  address 1110 (from port 0) during cycle 42 (420ns - 430ns)
*	Writing 01101011010001111010110011010101  to  address 1110 (from port 0) during cycle 43 (430ns - 440ns)
*	Reading 11100001010010101011011000011000 from address 0000 (from port 0) during cycle 44 (440ns - 450ns)
*	Reading 11100001010010101011011000011000 from address 0000 (from port 1) during cycle 44 (440ns - 450ns)
*	Reading 11100001010010101011011000011000 from address 0000 (from port 1) during cycle 45 (450ns - 460ns)
*	Writing 00101101100111011111010101101000  to  address 0000 (from port 0) during cycle 46 (460ns - 470ns)
*	Reading 01101011010001111010110011010101 from address 1110 (from port 1) during cycle 46 (460ns - 470ns)
*	Writing 00101110010011101011001011111010  to  address 0000 (from port 0) during cycle 47 (470ns - 480ns)
*	Reading 00101110010011101011001011111010 from address 0000 (from port 1) during cycle 48 (480ns - 490ns)
*	Reading 01101011010001111010110011010101 from address 1110 (from port 1) during cycle 49 (490ns - 500ns)
*	Reading 01101011010001111010110011010101 from address 1110 (from port 0) during cycle 50 (500ns - 510ns)
*	Writing 10101001000010001110000100100001  to  address 0000 (from port 1) during cycle 50 (500ns - 510ns)
*	Reading 01101011010001111010110011010101 from address 1110 (from port 0) during cycle 51 (510ns - 520ns)
*	Reading 10101001000010001110000100100001 from address 0000 (from port 1) during cycle 51 (510ns - 520ns)
*	Reading 01101011010001111010110011010101 from address 1110 (from port 0) during cycle 52 (520ns - 530ns)
*	Reading 10101001000010001110000100100001 from address 0000 (from port 1) during cycle 52 (520ns - 530ns)
*	Writing 01111101100011001111101100010100  to  address 0000 (from port 0) during cycle 53 (530ns - 540ns)
*	Writing 10010011010111100101011111010010  to  address 0000 (from port 0) during cycle 54 (540ns - 550ns)
*	Reading 01101011010001111010110011010101 from address 1110 (from port 1) during cycle 55 (550ns - 560ns)
*	Writing 10101011000100100101100000100010  to  address 1110 (from port 0) during cycle 56 (560ns - 570ns)
*	Reading 10101011000100100101100000100010 from address 1110 (from port 0) during cycle 57 (570ns - 580ns)
*	Reading 10010011010111100101011111010010 from address 0000 (from port 1) during cycle 57 (570ns - 580ns)
*	Writing 00110110111001001101010011011101  to  address 0000 (from port 0) during cycle 58 (580ns - 590ns)
*	Reading 00110110111001001101010011011101 from address 0000 (from port 0) during cycle 59 (590ns - 600ns)
*	Reading 10101011000100100101100000100010 from address 1110 (from port 1) during cycle 59 (590ns - 600ns)
*	Reading 10101011000100100101100000100010 from address 1110 (from port 0) during cycle 60 (600ns - 610ns)
*	Reading 10101011000100100101100000100010 from address 1110 (from port 1) during cycle 60 (600ns - 610ns)
*	Writing 11001101110011100011100010111111  to  address 0000 (from port 0) during cycle 61 (610ns - 620ns)
*	Reading 11001101110011100011100010111111 from address 0000 (from port 1) during cycle 62 (620ns - 630ns)
*	Reading 10101011000100100101100000100010 from address 1110 (from port 0) during cycle 63 (630ns - 640ns)
*	Reading 10101011000100100101100000100010 from address 1110 (from port 1) during cycle 64 (640ns - 650ns)
*	Reading 10101011000100100101100000100010 from address 1110 (from port 1) during cycle 65 (650ns - 660ns)
*	Reading 11001101110011100011100010111111 from address 0000 (from port 0) during cycle 66 (660ns - 670ns)
*	Writing 01110101111011101000101011110000  to  address 1110 (from port 1) during cycle 66 (660ns - 670ns)
*	Reading 01110101111011101000101011110000 from address 1110 (from port 0) during cycle 67 (670ns - 680ns)
*	Reading 01110101111011101000101011110000 from address 1110 (from port 1) during cycle 67 (670ns - 680ns)
*	Writing 10101101110111011000100101001010  to  address 0000 (from port 1) during cycle 68 (680ns - 690ns)
*	Reading 01110101111011101000101011110000 from address 1110 (from port 0) during cycle 69 (690ns - 700ns)
*	Reading 01110101111011101000101011110000 from address 1110 (from port 0) during cycle 70 (700ns - 710ns)
*	Writing 10011110111111010100001110111011  to  address 0000 (from port 0) during cycle 71 (710ns - 720ns)
*	Writing 00000101111111011101000000011010  to  address 1110 (from port 1) during cycle 71 (710ns - 720ns)
*	Reading 10011110111111010100001110111011 from address 0000 (from port 0) during cycle 72 (720ns - 730ns)
*	Writing 01101100000001000100111011000110  to  address 0000 (from port 1) during cycle 72 (720ns - 730ns)
*	Reading 01101100000001000100111011000110 from address 0000 (from port 0) during cycle 73 (730ns - 740ns)
*	Reading 01101100000001000100111011000110 from address 0000 (from port 1) during cycle 73 (730ns - 740ns)
*	Reading 00000101111111011101000000011010 from address 1110 (from port 1) during cycle 74 (740ns - 750ns)
*	Reading 00000101111111011101000000011010 from address 1110 (from port 0) during cycle 75 (750ns - 760ns)
*	Reading 00000101111111011101000000011010 from address 1110 (from port 1) during cycle 75 (750ns - 760ns)
*	Reading 01101100000001000100111011000110 from address 0000 (from port 0) during cycle 76 (760ns - 770ns)
*	Reading 00000101111111011101000000011010 from address 1110 (from port 1) during cycle 76 (760ns - 770ns)
*	Reading 01101100000001000100111011000110 from address 0000 (from port 0) during cycle 77 (770ns - 780ns)
*	Reading 01101100000001000100111011000110 from address 0000 (from port 1) during cycle 77 (770ns - 780ns)
*	Writing 00010110011000000011100011111111  to  address 1110 (from port 0) during cycle 78 (780ns - 790ns)
*	Writing 00100111100101110111111110101001  to  address 0000 (from port 0) during cycle 79 (790ns - 800ns)
*	Reading 00010110011000000011100011111111 from address 1110 (from port 1) during cycle 79 (790ns - 800ns)
*	Reading 00010110011000000011100011111111 from address 1110 (from port 1) during cycle 80 (800ns - 810ns)
*	Reading 00010110011000000011100011111111 from address 1110 (from port 1) during cycle 81 (810ns - 820ns)
*	Reading 00100111100101110111111110101001 from address 0000 (from port 0) during cycle 82 (820ns - 830ns)
*	Reading 00100111100101110111111110101001 from address 0000 (from port 1) during cycle 82 (820ns - 830ns)
*	Reading 00100111100101110111111110101001 from address 0000 (from port 1) during cycle 83 (830ns - 840ns)
*	Reading 00010110011000000011100011111111 from address 1110 (from port 0) during cycle 84 (840ns - 850ns)
*	Writing 00001001100110101000011011100000  to  address 0000 (from port 0) during cycle 85 (850ns - 860ns)
*	Reading 00010110011000000011100011111111 from address 1110 (from port 0) during cycle 86 (860ns - 870ns)
*	Writing 00100010000000110010111001001001  to  address 0000 (from port 1) during cycle 86 (860ns - 870ns)
*	Reading 00100010000000110010111001001001 from address 0000 (from port 0) during cycle 87 (870ns - 880ns)
*	Writing 11010100101101110010000100101010  to  address 1110 (from port 1) during cycle 87 (870ns - 880ns)
*	Reading 11010100101101110010000100101010 from address 1110 (from port 1) during cycle 88 (880ns - 890ns)
*	Reading 00100010000000110010111001001001 from address 0000 (from port 0) during cycle 90 (900ns - 910ns)
*	Reading 11010100101101110010000100101010 from address 1110 (from port 1) during cycle 90 (900ns - 910ns)
*	Reading 00100010000000110010111001001001 from address 0000 (from port 0) during cycle 91 (910ns - 920ns)
*	Reading 11010100101101110010000100101010 from address 1110 (from port 1) during cycle 91 (910ns - 920ns)
*	Reading 00100010000000110010111001001001 from address 0000 (from port 0) during cycle 92 (920ns - 930ns)
*	Reading 11010100101101110010000100101010 from address 1110 (from port 1) during cycle 92 (920ns - 930ns)
*	Reading 00100010000000110010111001001001 from address 0000 (from port 0) during cycle 93 (930ns - 940ns)
*	Reading 11010100101101110010000100101010 from address 1110 (from port 1) during cycle 93 (930ns - 940ns)
*	Reading 00100010000000110010111001001001 from address 0000 (from port 0) during cycle 94 (940ns - 950ns)
*	Writing 01001000101000110010010010100110  to  address 0000 (from port 1) during cycle 94 (940ns - 950ns)
*	Reading 01001000101000110010010010100110 from address 0000 (from port 0) during cycle 95 (950ns - 960ns)
*	Writing 00011010001011111111001100001000  to  address 1110 (from port 1) during cycle 95 (950ns - 960ns)
*	Reading 00011010001011111111001100001000 from address 1110 (from port 0) during cycle 96 (960ns - 970ns)
*	Reading 00011010001011111111001100001000 from address 1110 (from port 1) during cycle 96 (960ns - 970ns)
*	Reading 01001000101000110010010010100110 from address 0000 (from port 0) during cycle 97 (970ns - 980ns)
*	Reading 00011010001011111111001100001000 from address 1110 (from port 1) during cycle 98 (980ns - 990ns)
*	Writing 11110010001101100111111010111010  to  address 1110 (from port 0) during cycle 99 (990ns - 1000ns)
*	Writing 00110111000100111010010101101001  to  address 1110 (from port 0) during cycle 100 (1000ns - 1010ns)
*	Writing 10110101001011111000011001100011  to  address 1110 (from port 0) during cycle 101 (1010ns - 1020ns)
*	Writing 11000100000011110011110000101001  to  address 1110 (from port 0) during cycle 102 (1020ns - 1030ns)
*	Reading 01001000101000110010010010100110 from address 0000 (from port 0) during cycle 103 (1030ns - 1040ns)
*	Reading 11000100000011110011110000101001 from address 1110 (from port 1) during cycle 103 (1030ns - 1040ns)
*	Reading 11000100000011110011110000101001 from address 1110 (from port 0) during cycle 104 (1040ns - 1050ns)
*	Writing 00111011001110010101111000010011  to  address 0000 (from port 1) during cycle 104 (1040ns - 1050ns)
*	Writing 01100010110011010010100101110000  to  address 1110 (from port 0) during cycle 105 (1050ns - 1060ns)
*	Writing 10101001001111001010101110010011  to  address 0000 (from port 1) during cycle 105 (1050ns - 1060ns)
*	Reading 01100010110011010010100101110000 from address 1110 (from port 0) during cycle 106 (1060ns - 1070ns)
*	Reading 10101001001111001010101110010011 from address 0000 (from port 1) during cycle 106 (1060ns - 1070ns)
*	Writing 11111101100000110110010011001001  to  address 1110 (from port 0) during cycle 107 (1070ns - 1080ns)
*	Reading 11111101100000110110010011001001 from address 1110 (from port 1) during cycle 108 (1080ns - 1090ns)
*	Reading 10101001001111001010101110010011 from address 0000 (from port 1) during cycle 109 (1090ns - 1100ns)
*	Reading 11111101100000110110010011001001 from address 1110 (from port 0) during cycle 110 (1100ns - 1110ns)
*	Writing 00100001101011010011111010101100  to  address 1110 (from port 1) during cycle 110 (1100ns - 1110ns)
*	Reading 10101001001111001010101110010011 from address 0000 (from port 0) during cycle 111 (1110ns - 1120ns)
*	Writing 10011011100110000111000010000000  to  address 1110 (from port 1) during cycle 111 (1110ns - 1120ns)
*	Reading 10101001001111001010101110010011 from address 0000 (from port 0) during cycle 112 (1120ns - 1130ns)
*	Reading 10011011100110000111000010000000 from address 1110 (from port 1) during cycle 112 (1120ns - 1130ns)
*	Reading 10101001001111001010101110010011 from address 0000 (from port 0) during cycle 113 (1130ns - 1140ns)
*	Reading 10101001001111001010101110010011 from address 0000 (from port 1) during cycle 113 (1130ns - 1140ns)
*	Writing 00101010011111110011101111110111  to  address 1110 (from port 1) during cycle 114 (1140ns - 1150ns)
*	Writing 11000000110000001011000110001000  to  address 0000 (from port 0) during cycle 115 (1150ns - 1160ns)
*	Reading 00101010011111110011101111110111 from address 1110 (from port 1) during cycle 115 (1150ns - 1160ns)
*	Reading 00101010011111110011101111110111 from address 1110 (from port 0) during cycle 116 (1160ns - 1170ns)
*	Reading 11000000110000001011000110001000 from address 0000 (from port 0) during cycle 117 (1170ns - 1180ns)
*	Reading 11000000110000001011000110001000 from address 0000 (from port 1) during cycle 117 (1170ns - 1180ns)
*	Reading 11000000110000001011000110001000 from address 0000 (from port 0) during cycle 118 (1180ns - 1190ns)
*	Reading 00101010011111110011101111110111 from address 1110 (from port 1) during cycle 119 (1190ns - 1200ns)
*	Reading 11000000110000001011000110001000 from address 0000 (from port 0) during cycle 120 (1200ns - 1210ns)
*	Reading 11000000110000001011000110001000 from address 0000 (from port 1) during cycle 120 (1200ns - 1210ns)
*	Reading 11000000110000001011000110001000 from address 0000 (from port 0) during cycle 121 (1210ns - 1220ns)
*	Writing 11111011110000000110001000111011  to  address 0000 (from port 1) during cycle 121 (1210ns - 1220ns)
*	Reading 11111011110000000110001000111011 from address 0000 (from port 0) during cycle 122 (1220ns - 1230ns)
*	Reading 11111011110000000110001000111011 from address 0000 (from port 1) during cycle 122 (1220ns - 1230ns)
*	Reading 00101010011111110011101111110111 from address 1110 (from port 0) during cycle 123 (1230ns - 1240ns)
*	Writing 00101110110000101001101001010001  to  address 0000 (from port 0) during cycle 124 (1240ns - 1250ns)
*	Reading 00101110110000101001101001010001 from address 0000 (from port 0) during cycle 125 (1250ns - 1260ns)
*	Writing 11101001001010101111111011011011  to  address 1110 (from port 1) during cycle 125 (1250ns - 1260ns)
*	Writing 10011101111010011100101001011100  to  address 0000 (from port 0) during cycle 126 (1260ns - 1270ns)
*	Reading 11101001001010101111111011011011 from address 1110 (from port 1) during cycle 127 (1270ns - 1280ns)
*	Writing 10010101001110000010001011100111  to  address 1110 (from port 0) during cycle 128 (1280ns - 1290ns)
*	Writing 11001111100010100101000010101011  to  address 0000 (from port 0) during cycle 129 (1290ns - 1300ns)
*	Reading 11001111100010100101000010101011 from address 0000 (from port 0) during cycle 130 (1300ns - 1310ns)
*	Reading 10010101001110000010001011100111 from address 1110 (from port 1) during cycle 130 (1300ns - 1310ns)
*	Reading 11001111100010100101000010101011 from address 0000 (from port 0) during cycle 131 (1310ns - 1320ns)
*	Writing 11010010010001100100010011000000  to  address 1110 (from port 1) during cycle 131 (1310ns - 1320ns)
*	Reading 11010010010001100100010011000000 from address 1110 (from port 1) during cycle 132 (1320ns - 1330ns)
*	Reading 11010010010001100100010011000000 from address 1110 (from port 0) during cycle 133 (1330ns - 1340ns)
*	Reading 11010010010001100100010011000000 from address 1110 (from port 1) during cycle 133 (1330ns - 1340ns)
*	Writing 00010010101001011010110100000001  to  address 1110 (from port 0) during cycle 134 (1340ns - 1350ns)
*	Reading 11001111100010100101000010101011 from address 0000 (from port 1) during cycle 134 (1340ns - 1350ns)
*	Reading 11001111100010100101000010101011 from address 0000 (from port 0) during cycle 135 (1350ns - 1360ns)
*	Writing 00001010011001011011010011000001  to  address 1110 (from port 0) during cycle 136 (1360ns - 1370ns)
*	Writing 11010000101100100000110111001010  to  address 0000 (from port 0) during cycle 137 (1370ns - 1380ns)
*	Reading 00001010011001011011010011000001 from address 1110 (from port 1) during cycle 137 (1370ns - 1380ns)
*	Reading 00001010011001011011010011000001 from address 1110 (from port 1) during cycle 139 (1390ns - 1400ns)
*	Reading 11010000101100100000110111001010 from address 0000 (from port 0) during cycle 140 (1400ns - 1410ns)
*	Reading 00001010011001011011010011000001 from address 1110 (from port 1) during cycle 140 (1400ns - 1410ns)
*	Reading 11010000101100100000110111001010 from address 0000 (from port 1) during cycle 141 (1410ns - 1420ns)
*	Reading 00001010011001011011010011000001 from address 1110 (from port 0) during cycle 142 (1420ns - 1430ns)
*	Reading 00001010011001011011010011000001 from address 1110 (from port 1) during cycle 142 (1420ns - 1430ns)
*	Reading 00001010011001011011010011000001 from address 1110 (from port 0) during cycle 144 (1440ns - 1450ns)
*	Writing 00010100011011011111000011000110  to  address 0000 (from port 1) during cycle 144 (1440ns - 1450ns)
*	Reading 00010100011011011111000011000110 from address 0000 (from port 0) during cycle 145 (1450ns - 1460ns)
*	Reading 00010100011011011111000011000110 from address 0000 (from port 1) during cycle 145 (1450ns - 1460ns)
*	Writing 10000001011011100011000110010100  to  address 0000 (from port 0) during cycle 146 (1460ns - 1470ns)
*	Reading 00001010011001011011010011000001 from address 1110 (from port 0) during cycle 147 (1470ns - 1480ns)
*	Reading 10000001011011100011000110010100 from address 0000 (from port 1) during cycle 147 (1470ns - 1480ns)
*	Reading 00001010011001011011010011000001 from address 1110 (from port 0) during cycle 148 (1480ns - 1490ns)
*	Reading 10000001011011100011000110010100 from address 0000 (from port 1) during cycle 148 (1480ns - 1490ns)
*	Reading 00001010011001011011010011000001 from address 1110 (from port 0) during cycle 149 (1490ns - 1500ns)
*	Writing 11000011000010000110111001000101  to  address 1110 (from port 1) during cycle 149 (1490ns - 1500ns)
*	Writing 00001010100000100100111110000100  to  address 1110 (from port 0) during cycle 150 (1500ns - 1510ns)
*	Reading 00001010100000100100111110000100 from address 1110 (from port 0) during cycle 151 (1510ns - 1520ns)
*	Reading 00001010100000100100111110000100 from address 1110 (from port 0) during cycle 152 (1520ns - 1530ns)
*	Writing 00011111000001001111011110011000  to  address 1110 (from port 0) during cycle 153 (1530ns - 1540ns)
*	Reading 10000001011011100011000110010100 from address 0000 (from port 0) during cycle 154 (1540ns - 1550ns)
*	Reading 10000001011011100011000110010100 from address 0000 (from port 1) during cycle 154 (1540ns - 1550ns)
*	Reading 00011111000001001111011110011000 from address 1110 (from port 0) during cycle 155 (1550ns - 1560ns)
*	Writing 00000001010010010100110100110001  to  address 1110 (from port 1) during cycle 155 (1550ns - 1560ns)
*	Reading 10000001011011100011000110010100 from address 0000 (from port 0) during cycle 156 (1560ns - 1570ns)
*	Writing 00100000111000111011000011001001  to  address 0000 (from port 1) during cycle 156 (1560ns - 1570ns)
*	Reading 00000001010010010100110100110001 from address 1110 (from port 0) during cycle 158 (1580ns - 1590ns)
*	Reading 00100000111000111011000011001001 from address 0000 (from port 1) during cycle 158 (1580ns - 1590ns)
*	Reading 00000001010010010100110100110001 from address 1110 (from port 0) during cycle 159 (1590ns - 1600ns)
*	Reading 00000001010010010100110100110001 from address 1110 (from port 1) during cycle 159 (1590ns - 1600ns)
*	Reading 00100000111000111011000011001001 from address 0000 (from port 0) during cycle 160 (1600ns - 1610ns)
*	Writing 11001000010000001010001111110011  to  address 0000 (from port 1) during cycle 160 (1600ns - 1610ns)
*	Reading 00000001010010010100110100110001 from address 1110 (from port 0) during cycle 161 (1610ns - 1620ns)
*	Reading 11001000010000001010001111110011 from address 0000 (from port 1) during cycle 161 (1610ns - 1620ns)
*	Reading 00000001010010010100110100110001 from address 1110 (from port 0) during cycle 162 (1620ns - 1630ns)
*	Reading 11001000010000001010001111110011 from address 0000 (from port 0) during cycle 163 (1630ns - 1640ns)
*	Reading 00000001010010010100110100110001 from address 1110 (from port 1) during cycle 163 (1630ns - 1640ns)
*	Reading 11001000010000001010001111110011 from address 0000 (from port 0) during cycle 164 (1640ns - 1650ns)
*	Reading 00000001010010010100110100110001 from address 1110 (from port 1) during cycle 164 (1640ns - 1650ns)
*	Reading 00000001010010010100110100110001 from address 1110 (from port 1) during cycle 165 (1650ns - 1660ns)
*	Writing 01011001101101111010101001101101  to  address 1110 (from port 0) during cycle 166 (1660ns - 1670ns)
*	Reading 01011001101101111010101001101101 from address 1110 (from port 0) during cycle 167 (1670ns - 1680ns)
*	Reading 11001000010000001010001111110011 from address 0000 (from port 1) during cycle 167 (1670ns - 1680ns)
*	Reading 11001000010000001010001111110011 from address 0000 (from port 0) during cycle 168 (1680ns - 1690ns)
*	Reading 11001000010000001010001111110011 from address 0000 (from port 1) during cycle 168 (1680ns - 1690ns)
*	Reading 11001000010000001010001111110011 from address 0000 (from port 0) during cycle 169 (1690ns - 1700ns)
*	Reading 11001000010000001010001111110011 from address 0000 (from port 0) during cycle 170 (1700ns - 1710ns)
*	Writing 10100111001001100101110001111000  to  address 0000 (from port 0) during cycle 171 (1710ns - 1720ns)
*	Reading 10100111001001100101110001111000 from address 0000 (from port 0) during cycle 172 (1720ns - 1730ns)
*	Reading 01011001101101111010101001101101 from address 1110 (from port 1) during cycle 172 (1720ns - 1730ns)
*	Reading 10100111001001100101110001111000 from address 0000 (from port 0) during cycle 173 (1730ns - 1740ns)
*	Writing 10100000001011100111110110101111  to  address 1110 (from port 1) during cycle 173 (1730ns - 1740ns)
*	Reading 10100000001011100111110110101111 from address 1110 (from port 0) during cycle 174 (1740ns - 1750ns)
*	Reading 10100000001011100111110110101111 from address 1110 (from port 1) during cycle 174 (1740ns - 1750ns)
*	Reading 10100000001011100111110110101111 from address 1110 (from port 0) during cycle 175 (1750ns - 1760ns)
*	Writing 01101110100000100111101101100100  to  address 0000 (from port 1) during cycle 175 (1750ns - 1760ns)
*	Reading 10100000001011100111110110101111 from address 1110 (from port 0) during cycle 176 (1760ns - 1770ns)
*	Reading 10100000001011100111110110101111 from address 1110 (from port 1) during cycle 176 (1760ns - 1770ns)
*	Writing 01101100111100101100001011111000  to  address 1110 (from port 1) during cycle 177 (1770ns - 1780ns)
*	Writing 01101111010010101000100001111000  to  address 1110 (from port 0) during cycle 178 (1780ns - 1790ns)
*	Writing 01010000001000110000001010111111  to  address 0000 (from port 0) during cycle 179 (1790ns - 1800ns)
*	Reading 01101111010010101000100001111000 from address 1110 (from port 0) during cycle 180 (1800ns - 1810ns)
*	Reading 01010000001000110000001010111111 from address 0000 (from port 1) during cycle 180 (1800ns - 1810ns)
*	Reading 01101111010010101000100001111000 from address 1110 (from port 0) during cycle 181 (1810ns - 1820ns)
*	Reading 01010000001000110000001010111111 from address 0000 (from port 1) during cycle 181 (1810ns - 1820ns)
*	Writing 10010110000100110000100101010010  to  address 0000 (from port 0) during cycle 182 (1820ns - 1830ns)
*	Writing 10011111001100101111000011000110  to  address 1110 (from port 1) during cycle 182 (1820ns - 1830ns)
*	Reading 10010110000100110000100101010010 from address 0000 (from port 0) during cycle 183 (1830ns - 1840ns)
*	Reading 10010110000100110000100101010010 from address 0000 (from port 0) during cycle 184 (1840ns - 1850ns)
*	Reading 10011111001100101111000011000110 from address 1110 (from port 1) during cycle 184 (1840ns - 1850ns)
*	Writing 11110100100111101000010000000011  to  address 0000 (from port 0) during cycle 185 (1850ns - 1860ns)
*	Reading 10011111001100101111000011000110 from address 1110 (from port 0) during cycle 186 (1860ns - 1870ns)
*	Writing 01011100101101010100011000111001  to  address 1110 (from port 1) during cycle 186 (1860ns - 1870ns)
*	Reading 01011100101101010100011000111001 from address 1110 (from port 0) during cycle 187 (1870ns - 1880ns)
*	Reading 11110100100111101000010000000011 from address 0000 (from port 1) during cycle 187 (1870ns - 1880ns)
*	Writing 10010010110100011111110101001111  to  address 0000 (from port 0) during cycle 188 (1880ns - 1890ns)
*	Writing 10110100110011000110001001110010  to  address 1110 (from port 1) during cycle 188 (1880ns - 1890ns)
*	Reading 10010010110100011111110101001111 from address 0000 (from port 1) during cycle 189 (1890ns - 1900ns)
*	Writing 10011111101110011001110000100100  to  address 1110 (from port 0) during cycle 190 (1900ns - 1910ns)
*	Reading 10010010110100011111110101001111 from address 0000 (from port 1) during cycle 190 (1900ns - 1910ns)
*	Reading 10011111101110011001110000100100 from address 1110 (from port 0) during cycle 191 (1910ns - 1920ns)
*	Writing 10100001111000110010011010101101  to  address 1110 (from port 1) during cycle 191 (1910ns - 1920ns)
*	Reading 10100001111000110010011010101101 from address 1110 (from port 0) during cycle 192 (1920ns - 1930ns)
*	Reading 10100001111000110010011010101101 from address 1110 (from port 0) during cycle 193 (1930ns - 1940ns)
*	Reading 10100001111000110010011010101101 from address 1110 (from port 0) during cycle 194 (1940ns - 1950ns)
*	Writing 11000010111110101010100110111000  to  address 0000 (from port 1) during cycle 194 (1940ns - 1950ns)
*	Reading 10100001111000110010011010101101 from address 1110 (from port 0) during cycle 195 (1950ns - 1960ns)
*	Reading 11000010111110101010100110111000 from address 0000 (from port 1) during cycle 195 (1950ns - 1960ns)
*	Writing 00101110010000011010001111110011  to  address 1110 (from port 0) during cycle 196 (1960ns - 1970ns)
*	Reading 00101110010000011010001111110011 from address 1110 (from port 1) during cycle 197 (1970ns - 1980ns)
*	Reading 11000010111110101010100110111000 from address 0000 (from port 0) during cycle 198 (1980ns - 1990ns)
*	Writing 01101001001111100101110001100010  to  address 1110 (from port 1) during cycle 198 (1980ns - 1990ns)
*	Writing 10111111011000010111000001000111  to  address 0000 (from port 0) during cycle 199 (1990ns - 2000ns)
*	Writing 01110110010010101000111011000001  to  address 1110 (from port 1) during cycle 200 (2000ns - 2010ns)
*	Reading 01110110010010101000111011000001 from address 1110 (from port 0) during cycle 201 (2010ns - 2020ns)
*	Reading 10111111011000010111000001000111 from address 0000 (from port 0) during cycle 202 (2020ns - 2030ns)
*	Writing 01000100011100010101010010011100  to  address 1110 (from port 1) during cycle 202 (2020ns - 2030ns)
*	Reading 01000100011100010101010010011100 from address 1110 (from port 0) during cycle 203 (2030ns - 2040ns)
*	Writing 11100011000110100111101011110101  to  address 1110 (from port 1) during cycle 203 (2030ns - 2040ns)
*	Reading 10111111011000010111000001000111 from address 0000 (from port 0) during cycle 204 (2040ns - 2050ns)
*	Idle during cycle 205 (2050ns - 2060ns)

* Generation of data and address signals
* (time, data): [(0, 0), (10, 1), (20, 1), (30, 1), (40, 1), (50, 1), (60, 1), (70, 1), (80, 1), (90, 1), (100, 0), (110, 0), (120, 0), (130, 0), (140, 0), (150, 0), (160, 1), (170, 1), (180, 1), (190, 1), (200, 1), (210, 1), (220, 1), (230, 1), (240, 1), (250, 1), (260, 0), (270, 0), (280, 1), (290, 1), (300, 1), (310, 1), (320, 1), (330, 0), (340, 1), (350, 1), (360, 1), (370, 1), (380, 1), (390, 1), (400, 1), (410, 1), (420, 1), (430, 1), (440, 1), (450, 1), (460, 0), (470, 0), (480, 0), (490, 0), (500, 0), (510, 0), (520, 0), (530, 0), (540, 0), (550, 0), (560, 0), (570, 0), (580, 1), (590, 1), (600, 1), (610, 1), (620, 1), (630, 1), (640, 1), (650, 1), (660, 1), (670, 1), (680, 1), (690, 1), (700, 1), (710, 1), (720, 1), (730, 1), (740, 1), (750, 1), (760, 1), (770, 1), (780, 1), (790, 1), (800, 1), (810, 1), (820, 1), (830, 1), (840, 1), (850, 0), (860, 0), (870, 0), (880, 0), (890, 0), (900, 0), (910, 0), (920, 0), (930, 0), (940, 0), (950, 0), (960, 0), (970, 0), (980, 0), (990, 0), (1000, 1), (1010, 1), (1020, 1), (1030, 1), (1040, 1), (1050, 0), (1060, 0), (1070, 1), (1080, 1), (1090, 1), (1100, 1), (1110, 1), (1120, 1), (1130, 1), (1140, 1), (1150, 0), (1160, 0), (1170, 0), (1180, 0), (1190, 0), (1200, 0), (1210, 0), (1220, 0), (1230, 0), (1240, 1), (1250, 1), (1260, 0), (1270, 0), (1280, 1), (1290, 1), (1300, 1), (1310, 1), (1320, 1), (1330, 1), (1340, 1), (1350, 1), (1360, 1), (1370, 0), (1380, 0), (1390, 0), (1400, 0), (1410, 0), (1420, 0), (1430, 0), (1440, 0), (1450, 0), (1460, 0), (1470, 0), (1480, 0), (1490, 0), (1500, 0), (1510, 0), (1520, 0), (1530, 0), (1540, 0), (1550, 0), (1560, 0), (1570, 0), (1580, 0), (1590, 0), (1600, 0), (1610, 0), (1620, 0), (1630, 0), (1640, 0), (1650, 0), (1660, 1), (1670, 1), (1680, 1), (1690, 1), (1700, 1), (1710, 0), (1720, 0), (1730, 0), (1740, 0), (1750, 0), (1760, 0), (1770, 0), (1780, 0), (1790, 1), (1800, 1), (1810, 1), (1820, 0), (1830, 0), (1840, 0), (1850, 1), (1860, 1), (1870, 1), (1880, 1), (1890, 1), (1900, 0), (1910, 0), (1920, 0), (1930, 0), (1940, 0), (1950, 0), (1960, 1), (1970, 1), (1980, 1), (1990, 1), (2000, 1), (2010, 1), (2020, 1), (2030, 1), (2040, 1), (2050, 1)]
Vdin0_0  din0_0  0 PWL (0n 0.0v 9.495n 0.0v 9.505n 3.3v 19.495n 3.3v 19.505n 3.3v 29.495n 3.3v 29.505n 3.3v 39.495n 3.3v 39.505n 3.3v 49.495n 3.3v 49.505n 3.3v 59.495n 3.3v 59.505n 3.3v 69.495n 3.3v 69.505n 3.3v 79.495n 3.3v 79.505n 3.3v 89.495n 3.3v 89.505n 3.3v 99.495n 3.3v 99.505n 0.0v 109.495n 0.0v 109.505n 0.0v 119.495n 0.0v 119.505n 0.0v 129.495n 0.0v 129.505n 0.0v 139.495n 0.0v 139.505n 0.0v 149.495n 0.0v 149.505n 0.0v 159.495n 0.0v 159.505n 3.3v 169.495n 3.3v 169.505n 3.3v 179.495n 3.3v 179.505n 3.3v 189.495n 3.3v 189.505n 3.3v 199.495n 3.3v 199.505n 3.3v 209.495n 3.3v 209.505n 3.3v 219.495n 3.3v 219.505n 3.3v 229.495n 3.3v 229.505n 3.3v 239.495n 3.3v 239.505n 3.3v 249.495n 3.3v 249.505n 3.3v 259.495n 3.3v 259.505n 0.0v 269.495n 0.0v 269.505n 0.0v 279.495n 0.0v 279.505n 3.3v 289.495n 3.3v 289.505n 3.3v 299.495n 3.3v 299.505n 3.3v 309.495n 3.3v 309.505n 3.3v 319.495n 3.3v 319.505n 3.3v 329.495n 3.3v 329.505n 0.0v 339.495n 0.0v 339.505n 3.3v 349.495n 3.3v 349.505n 3.3v 359.495n 3.3v 359.505n 3.3v 369.495n 3.3v 369.505n 3.3v 379.495n 3.3v 379.505n 3.3v 389.495n 3.3v 389.505n 3.3v 399.495n 3.3v 399.505n 3.3v 409.495n 3.3v 409.505n 3.3v 419.495n 3.3v 419.505n 3.3v 429.495n 3.3v 429.505n 3.3v 439.495n 3.3v 439.505n 3.3v 449.495n 3.3v 449.505n 3.3v 459.495n 3.3v 459.505n 0.0v 469.495n 0.0v 469.505n 0.0v 479.495n 0.0v 479.505n 0.0v 489.495n 0.0v 489.505n 0.0v 499.495n 0.0v 499.505n 0.0v 509.495n 0.0v 509.505n 0.0v 519.495n 0.0v 519.505n 0.0v 529.495n 0.0v 529.505n 0.0v 539.495n 0.0v 539.505n 0.0v 549.495n 0.0v 549.505n 0.0v 559.495n 0.0v 559.505n 0.0v 569.495n 0.0v 569.505n 0.0v 579.495n 0.0v 579.505n 3.3v 589.495n 3.3v 589.505n 3.3v 599.495n 3.3v 599.505n 3.3v 609.495n 3.3v 609.505n 3.3v 619.495n 3.3v 619.505n 3.3v 629.495n 3.3v 629.505n 3.3v 639.495n 3.3v 639.505n 3.3v 649.495n 3.3v 649.505n 3.3v 659.495n 3.3v 659.505n 3.3v 669.495n 3.3v 669.505n 3.3v 679.495n 3.3v 679.505n 3.3v 689.495n 3.3v 689.505n 3.3v 699.495n 3.3v 699.505n 3.3v 709.495n 3.3v 709.505n 3.3v 719.495n 3.3v 719.505n 3.3v 729.495n 3.3v 729.505n 3.3v 739.495n 3.3v 739.505n 3.3v 749.495n 3.3v 749.505n 3.3v 759.495n 3.3v 759.505n 3.3v 769.495n 3.3v 769.505n 3.3v 779.495n 3.3v 779.505n 3.3v 789.495n 3.3v 789.505n 3.3v 799.495n 3.3v 799.505n 3.3v 809.495n 3.3v 809.505n 3.3v 819.495n 3.3v 819.505n 3.3v 829.495n 3.3v 829.505n 3.3v 839.495n 3.3v 839.505n 3.3v 849.495n 3.3v 849.505n 0.0v 859.495n 0.0v 859.505n 0.0v 869.495n 0.0v 869.505n 0.0v 879.495n 0.0v 879.505n 0.0v 889.495n 0.0v 889.505n 0.0v 899.495n 0.0v 899.505n 0.0v 909.495n 0.0v 909.505n 0.0v 919.495n 0.0v 919.505n 0.0v 929.495n 0.0v 929.505n 0.0v 939.495n 0.0v 939.505n 0.0v 949.495n 0.0v 949.505n 0.0v 959.495n 0.0v 959.505n 0.0v 969.495n 0.0v 969.505n 0.0v 979.495n 0.0v 979.505n 0.0v 989.495n 0.0v 989.505n 0.0v 999.495n 0.0v 999.505n 3.3v 1009.495n 3.3v 1009.505n 3.3v 1019.495n 3.3v 1019.505n 3.3v 1029.495n 3.3v 1029.505n 3.3v 1039.495n 3.3v 1039.505n 3.3v 1049.495n 3.3v 1049.505n 0.0v 1059.495n 0.0v 1059.505n 0.0v 1069.495n 0.0v 1069.505n 3.3v 1079.495n 3.3v 1079.505n 3.3v 1089.495n 3.3v 1089.505n 3.3v 1099.495n 3.3v 1099.505n 3.3v 1109.495n 3.3v 1109.505n 3.3v 1119.495n 3.3v 1119.505n 3.3v 1129.495n 3.3v 1129.505n 3.3v 1139.495n 3.3v 1139.505n 3.3v 1149.495n 3.3v 1149.505n 0.0v 1159.495n 0.0v 1159.505n 0.0v 1169.495n 0.0v 1169.505n 0.0v 1179.495n 0.0v 1179.505n 0.0v 1189.495n 0.0v 1189.505n 0.0v 1199.495n 0.0v 1199.505n 0.0v 1209.495n 0.0v 1209.505n 0.0v 1219.495n 0.0v 1219.505n 0.0v 1229.495n 0.0v 1229.505n 0.0v 1239.495n 0.0v 1239.505n 3.3v 1249.495n 3.3v 1249.505n 3.3v 1259.495n 3.3v 1259.505n 0.0v 1269.495n 0.0v 1269.505n 0.0v 1279.495n 0.0v 1279.505n 3.3v 1289.495n 3.3v 1289.505n 3.3v 1299.495n 3.3v 1299.505n 3.3v 1309.495n 3.3v 1309.505n 3.3v 1319.495n 3.3v 1319.505n 3.3v 1329.495n 3.3v 1329.505n 3.3v 1339.495n 3.3v 1339.505n 3.3v 1349.495n 3.3v 1349.505n 3.3v 1359.495n 3.3v 1359.505n 3.3v 1369.495n 3.3v 1369.505n 0.0v 1379.495n 0.0v 1379.505n 0.0v 1389.495n 0.0v 1389.505n 0.0v 1399.495n 0.0v 1399.505n 0.0v 1409.495n 0.0v 1409.505n 0.0v 1419.495n 0.0v 1419.505n 0.0v 1429.495n 0.0v 1429.505n 0.0v 1439.495n 0.0v 1439.505n 0.0v 1449.495n 0.0v 1449.505n 0.0v 1459.495n 0.0v 1459.505n 0.0v 1469.495n 0.0v 1469.505n 0.0v 1479.495n 0.0v 1479.505n 0.0v 1489.495n 0.0v 1489.505n 0.0v 1499.495n 0.0v 1499.505n 0.0v 1509.495n 0.0v 1509.505n 0.0v 1519.495n 0.0v 1519.505n 0.0v 1529.495n 0.0v 1529.505n 0.0v 1539.495n 0.0v 1539.505n 0.0v 1549.495n 0.0v 1549.505n 0.0v 1559.495n 0.0v 1559.505n 0.0v 1569.495n 0.0v 1569.505n 0.0v 1579.495n 0.0v 1579.505n 0.0v 1589.495n 0.0v 1589.505n 0.0v 1599.495n 0.0v 1599.505n 0.0v 1609.495n 0.0v 1609.505n 0.0v 1619.495n 0.0v 1619.505n 0.0v 1629.495n 0.0v 1629.505n 0.0v 1639.495n 0.0v 1639.505n 0.0v 1649.495n 0.0v 1649.505n 0.0v 1659.495n 0.0v 1659.505n 3.3v 1669.495n 3.3v 1669.505n 3.3v 1679.495n 3.3v 1679.505n 3.3v 1689.495n 3.3v 1689.505n 3.3v 1699.495n 3.3v 1699.505n 3.3v 1709.495n 3.3v 1709.505n 0.0v 1719.495n 0.0v 1719.505n 0.0v 1729.495n 0.0v 1729.505n 0.0v 1739.495n 0.0v 1739.505n 0.0v 1749.495n 0.0v 1749.505n 0.0v 1759.495n 0.0v 1759.505n 0.0v 1769.495n 0.0v 1769.505n 0.0v 1779.495n 0.0v 1779.505n 0.0v 1789.495n 0.0v 1789.505n 3.3v 1799.495n 3.3v 1799.505n 3.3v 1809.495n 3.3v 1809.505n 3.3v 1819.495n 3.3v 1819.505n 0.0v 1829.495n 0.0v 1829.505n 0.0v 1839.495n 0.0v 1839.505n 0.0v 1849.495n 0.0v 1849.505n 3.3v 1859.495n 3.3v 1859.505n 3.3v 1869.495n 3.3v 1869.505n 3.3v 1879.495n 3.3v 1879.505n 3.3v 1889.495n 3.3v 1889.505n 3.3v 1899.495n 3.3v 1899.505n 0.0v 1909.495n 0.0v 1909.505n 0.0v 1919.495n 0.0v 1919.505n 0.0v 1929.495n 0.0v 1929.505n 0.0v 1939.495n 0.0v 1939.505n 0.0v 1949.495n 0.0v 1949.505n 0.0v 1959.495n 0.0v 1959.505n 3.3v 1969.495n 3.3v 1969.505n 3.3v 1979.495n 3.3v 1979.505n 3.3v 1989.495n 3.3v 1989.505n 3.3v 1999.495n 3.3v 1999.505n 3.3v 2009.495n 3.3v 2009.505n 3.3v 2019.495n 3.3v 2019.505n 3.3v 2029.495n 3.3v 2029.505n 3.3v 2039.495n 3.3v 2039.505n 3.3v 2049.495n 3.3v 2049.505n 3.3v )
* (time, data): [(0, 0), (10, 0), (20, 0), (30, 1), (40, 1), (50, 1), (60, 1), (70, 1), (80, 1), (90, 1), (100, 1), (110, 1), (120, 1), (130, 1), (140, 1), (150, 1), (160, 1), (170, 1), (180, 1), (190, 1), (200, 1), (210, 1), (220, 0), (230, 0), (240, 0), (250, 0), (260, 0), (270, 0), (280, 0), (290, 1), (300, 1), (310, 1), (320, 1), (330, 0), (340, 0), (350, 0), (360, 0), (370, 0), (380, 0), (390, 0), (400, 0), (410, 0), (420, 0), (430, 0), (440, 0), (450, 0), (460, 0), (470, 1), (480, 1), (490, 1), (500, 1), (510, 1), (520, 1), (530, 0), (540, 1), (550, 1), (560, 1), (570, 1), (580, 0), (590, 0), (600, 0), (610, 1), (620, 1), (630, 1), (640, 1), (650, 1), (660, 1), (670, 1), (680, 1), (690, 1), (700, 1), (710, 1), (720, 1), (730, 1), (740, 1), (750, 1), (760, 1), (770, 1), (780, 1), (790, 0), (800, 0), (810, 0), (820, 0), (830, 0), (840, 0), (850, 0), (860, 0), (870, 0), (880, 0), (890, 0), (900, 0), (910, 0), (920, 0), (930, 0), (940, 0), (950, 0), (960, 0), (970, 0), (980, 0), (990, 1), (1000, 0), (1010, 1), (1020, 0), (1030, 0), (1040, 0), (1050, 0), (1060, 0), (1070, 0), (1080, 0), (1090, 0), (1100, 0), (1110, 0), (1120, 0), (1130, 0), (1140, 0), (1150, 0), (1160, 0), (1170, 0), (1180, 0), (1190, 0), (1200, 0), (1210, 0), (1220, 0), (1230, 0), (1240, 0), (1250, 0), (1260, 0), (1270, 0), (1280, 1), (1290, 1), (1300, 1), (1310, 1), (1320, 1), (1330, 1), (1340, 0), (1350, 0), (1360, 0), (1370, 1), (1380, 1), (1390, 1), (1400, 1), (1410, 1), (1420, 1), (1430, 1), (1440, 1), (1450, 1), (1460, 0), (1470, 0), (1480, 0), (1490, 0), (1500, 0), (1510, 0), (1520, 0), (1530, 0), (1540, 0), (1550, 0), (1560, 0), (1570, 0), (1580, 0), (1590, 0), (1600, 0), (1610, 0), (1620, 0), (1630, 0), (1640, 0), (1650, 0), (1660, 0), (1670, 0), (1680, 0), (1690, 0), (1700, 0), (1710, 0), (1720, 0), (1730, 0), (1740, 0), (1750, 0), (1760, 0), (1770, 0), (1780, 0), (1790, 1), (1800, 1), (1810, 1), (1820, 1), (1830, 1), (1840, 1), (1850, 1), (1860, 1), (1870, 1), (1880, 1), (1890, 1), (1900, 0), (1910, 0), (1920, 0), (1930, 0), (1940, 0), (1950, 0), (1960, 1), (1970, 1), (1980, 1), (1990, 1), (2000, 1), (2010, 1), (2020, 1), (2030, 1), (2040, 1), (2050, 1)]
Vdin0_1  din0_1  0 PWL (0n 0.0v 9.495n 0.0v 9.505n 0.0v 19.495n 0.0v 19.505n 0.0v 29.495n 0.0v 29.505n 3.3v 39.495n 3.3v 39.505n 3.3v 49.495n 3.3v 49.505n 3.3v 59.495n 3.3v 59.505n 3.3v 69.495n 3.3v 69.505n 3.3v 79.495n 3.3v 79.505n 3.3v 89.495n 3.3v 89.505n 3.3v 99.495n 3.3v 99.505n 3.3v 109.495n 3.3v 109.505n 3.3v 119.495n 3.3v 119.505n 3.3v 129.495n 3.3v 129.505n 3.3v 139.495n 3.3v 139.505n 3.3v 149.495n 3.3v 149.505n 3.3v 159.495n 3.3v 159.505n 3.3v 169.495n 3.3v 169.505n 3.3v 179.495n 3.3v 179.505n 3.3v 189.495n 3.3v 189.505n 3.3v 199.495n 3.3v 199.505n 3.3v 209.495n 3.3v 209.505n 3.3v 219.495n 3.3v 219.505n 0.0v 229.495n 0.0v 229.505n 0.0v 239.495n 0.0v 239.505n 0.0v 249.495n 0.0v 249.505n 0.0v 259.495n 0.0v 259.505n 0.0v 269.495n 0.0v 269.505n 0.0v 279.495n 0.0v 279.505n 0.0v 289.495n 0.0v 289.505n 3.3v 299.495n 3.3v 299.505n 3.3v 309.495n 3.3v 309.505n 3.3v 319.495n 3.3v 319.505n 3.3v 329.495n 3.3v 329.505n 0.0v 339.495n 0.0v 339.505n 0.0v 349.495n 0.0v 349.505n 0.0v 359.495n 0.0v 359.505n 0.0v 369.495n 0.0v 369.505n 0.0v 379.495n 0.0v 379.505n 0.0v 389.495n 0.0v 389.505n 0.0v 399.495n 0.0v 399.505n 0.0v 409.495n 0.0v 409.505n 0.0v 419.495n 0.0v 419.505n 0.0v 429.495n 0.0v 429.505n 0.0v 439.495n 0.0v 439.505n 0.0v 449.495n 0.0v 449.505n 0.0v 459.495n 0.0v 459.505n 0.0v 469.495n 0.0v 469.505n 3.3v 479.495n 3.3v 479.505n 3.3v 489.495n 3.3v 489.505n 3.3v 499.495n 3.3v 499.505n 3.3v 509.495n 3.3v 509.505n 3.3v 519.495n 3.3v 519.505n 3.3v 529.495n 3.3v 529.505n 0.0v 539.495n 0.0v 539.505n 3.3v 549.495n 3.3v 549.505n 3.3v 559.495n 3.3v 559.505n 3.3v 569.495n 3.3v 569.505n 3.3v 579.495n 3.3v 579.505n 0.0v 589.495n 0.0v 589.505n 0.0v 599.495n 0.0v 599.505n 0.0v 609.495n 0.0v 609.505n 3.3v 619.495n 3.3v 619.505n 3.3v 629.495n 3.3v 629.505n 3.3v 639.495n 3.3v 639.505n 3.3v 649.495n 3.3v 649.505n 3.3v 659.495n 3.3v 659.505n 3.3v 669.495n 3.3v 669.505n 3.3v 679.495n 3.3v 679.505n 3.3v 689.495n 3.3v 689.505n 3.3v 699.495n 3.3v 699.505n 3.3v 709.495n 3.3v 709.505n 3.3v 719.495n 3.3v 719.505n 3.3v 729.495n 3.3v 729.505n 3.3v 739.495n 3.3v 739.505n 3.3v 749.495n 3.3v 749.505n 3.3v 759.495n 3.3v 759.505n 3.3v 769.495n 3.3v 769.505n 3.3v 779.495n 3.3v 779.505n 3.3v 789.495n 3.3v 789.505n 0.0v 799.495n 0.0v 799.505n 0.0v 809.495n 0.0v 809.505n 0.0v 819.495n 0.0v 819.505n 0.0v 829.495n 0.0v 829.505n 0.0v 839.495n 0.0v 839.505n 0.0v 849.495n 0.0v 849.505n 0.0v 859.495n 0.0v 859.505n 0.0v 869.495n 0.0v 869.505n 0.0v 879.495n 0.0v 879.505n 0.0v 889.495n 0.0v 889.505n 0.0v 899.495n 0.0v 899.505n 0.0v 909.495n 0.0v 909.505n 0.0v 919.495n 0.0v 919.505n 0.0v 929.495n 0.0v 929.505n 0.0v 939.495n 0.0v 939.505n 0.0v 949.495n 0.0v 949.505n 0.0v 959.495n 0.0v 959.505n 0.0v 969.495n 0.0v 969.505n 0.0v 979.495n 0.0v 979.505n 0.0v 989.495n 0.0v 989.505n 3.3v 999.495n 3.3v 999.505n 0.0v 1009.495n 0.0v 1009.505n 3.3v 1019.495n 3.3v 1019.505n 0.0v 1029.495n 0.0v 1029.505n 0.0v 1039.495n 0.0v 1039.505n 0.0v 1049.495n 0.0v 1049.505n 0.0v 1059.495n 0.0v 1059.505n 0.0v 1069.495n 0.0v 1069.505n 0.0v 1079.495n 0.0v 1079.505n 0.0v 1089.495n 0.0v 1089.505n 0.0v 1099.495n 0.0v 1099.505n 0.0v 1109.495n 0.0v 1109.505n 0.0v 1119.495n 0.0v 1119.505n 0.0v 1129.495n 0.0v 1129.505n 0.0v 1139.495n 0.0v 1139.505n 0.0v 1149.495n 0.0v 1149.505n 0.0v 1159.495n 0.0v 1159.505n 0.0v 1169.495n 0.0v 1169.505n 0.0v 1179.495n 0.0v 1179.505n 0.0v 1189.495n 0.0v 1189.505n 0.0v 1199.495n 0.0v 1199.505n 0.0v 1209.495n 0.0v 1209.505n 0.0v 1219.495n 0.0v 1219.505n 0.0v 1229.495n 0.0v 1229.505n 0.0v 1239.495n 0.0v 1239.505n 0.0v 1249.495n 0.0v 1249.505n 0.0v 1259.495n 0.0v 1259.505n 0.0v 1269.495n 0.0v 1269.505n 0.0v 1279.495n 0.0v 1279.505n 3.3v 1289.495n 3.3v 1289.505n 3.3v 1299.495n 3.3v 1299.505n 3.3v 1309.495n 3.3v 1309.505n 3.3v 1319.495n 3.3v 1319.505n 3.3v 1329.495n 3.3v 1329.505n 3.3v 1339.495n 3.3v 1339.505n 0.0v 1349.495n 0.0v 1349.505n 0.0v 1359.495n 0.0v 1359.505n 0.0v 1369.495n 0.0v 1369.505n 3.3v 1379.495n 3.3v 1379.505n 3.3v 1389.495n 3.3v 1389.505n 3.3v 1399.495n 3.3v 1399.505n 3.3v 1409.495n 3.3v 1409.505n 3.3v 1419.495n 3.3v 1419.505n 3.3v 1429.495n 3.3v 1429.505n 3.3v 1439.495n 3.3v 1439.505n 3.3v 1449.495n 3.3v 1449.505n 3.3v 1459.495n 3.3v 1459.505n 0.0v 1469.495n 0.0v 1469.505n 0.0v 1479.495n 0.0v 1479.505n 0.0v 1489.495n 0.0v 1489.505n 0.0v 1499.495n 0.0v 1499.505n 0.0v 1509.495n 0.0v 1509.505n 0.0v 1519.495n 0.0v 1519.505n 0.0v 1529.495n 0.0v 1529.505n 0.0v 1539.495n 0.0v 1539.505n 0.0v 1549.495n 0.0v 1549.505n 0.0v 1559.495n 0.0v 1559.505n 0.0v 1569.495n 0.0v 1569.505n 0.0v 1579.495n 0.0v 1579.505n 0.0v 1589.495n 0.0v 1589.505n 0.0v 1599.495n 0.0v 1599.505n 0.0v 1609.495n 0.0v 1609.505n 0.0v 1619.495n 0.0v 1619.505n 0.0v 1629.495n 0.0v 1629.505n 0.0v 1639.495n 0.0v 1639.505n 0.0v 1649.495n 0.0v 1649.505n 0.0v 1659.495n 0.0v 1659.505n 0.0v 1669.495n 0.0v 1669.505n 0.0v 1679.495n 0.0v 1679.505n 0.0v 1689.495n 0.0v 1689.505n 0.0v 1699.495n 0.0v 1699.505n 0.0v 1709.495n 0.0v 1709.505n 0.0v 1719.495n 0.0v 1719.505n 0.0v 1729.495n 0.0v 1729.505n 0.0v 1739.495n 0.0v 1739.505n 0.0v 1749.495n 0.0v 1749.505n 0.0v 1759.495n 0.0v 1759.505n 0.0v 1769.495n 0.0v 1769.505n 0.0v 1779.495n 0.0v 1779.505n 0.0v 1789.495n 0.0v 1789.505n 3.3v 1799.495n 3.3v 1799.505n 3.3v 1809.495n 3.3v 1809.505n 3.3v 1819.495n 3.3v 1819.505n 3.3v 1829.495n 3.3v 1829.505n 3.3v 1839.495n 3.3v 1839.505n 3.3v 1849.495n 3.3v 1849.505n 3.3v 1859.495n 3.3v 1859.505n 3.3v 1869.495n 3.3v 1869.505n 3.3v 1879.495n 3.3v 1879.505n 3.3v 1889.495n 3.3v 1889.505n 3.3v 1899.495n 3.3v 1899.505n 0.0v 1909.495n 0.0v 1909.505n 0.0v 1919.495n 0.0v 1919.505n 0.0v 1929.495n 0.0v 1929.505n 0.0v 1939.495n 0.0v 1939.505n 0.0v 1949.495n 0.0v 1949.505n 0.0v 1959.495n 0.0v 1959.505n 3.3v 1969.495n 3.3v 1969.505n 3.3v 1979.495n 3.3v 1979.505n 3.3v 1989.495n 3.3v 1989.505n 3.3v 1999.495n 3.3v 1999.505n 3.3v 2009.495n 3.3v 2009.505n 3.3v 2019.495n 3.3v 2019.505n 3.3v 2029.495n 3.3v 2029.505n 3.3v 2039.495n 3.3v 2039.505n 3.3v 2049.495n 3.3v 2049.505n 3.3v )
* (time, data): [(0, 0), (10, 1), (20, 0), (30, 0), (40, 0), (50, 0), (60, 1), (70, 1), (80, 1), (90, 1), (100, 1), (110, 1), (120, 1), (130, 1), (140, 1), (150, 1), (160, 0), (170, 0), (180, 0), (190, 0), (200, 0), (210, 0), (220, 0), (230, 0), (240, 0), (250, 0), (260, 0), (270, 0), (280, 0), (290, 1), (300, 1), (310, 1), (320, 1), (330, 0), (340, 0), (350, 0), (360, 0), (370, 0), (380, 0), (390, 0), (400, 0), (410, 0), (420, 1), (430, 1), (440, 1), (450, 1), (460, 0), (470, 0), (480, 0), (490, 0), (500, 0), (510, 0), (520, 0), (530, 1), (540, 0), (550, 0), (560, 0), (570, 0), (580, 1), (590, 1), (600, 1), (610, 1), (620, 1), (630, 1), (640, 1), (650, 1), (660, 1), (670, 1), (680, 1), (690, 1), (700, 1), (710, 0), (720, 0), (730, 0), (740, 0), (750, 0), (760, 0), (770, 0), (780, 1), (790, 0), (800, 0), (810, 0), (820, 0), (830, 0), (840, 0), (850, 0), (860, 0), (870, 0), (880, 0), (890, 0), (900, 0), (910, 0), (920, 0), (930, 0), (940, 0), (950, 0), (960, 0), (970, 0), (980, 0), (990, 0), (1000, 0), (1010, 0), (1020, 0), (1030, 0), (1040, 0), (1050, 0), (1060, 0), (1070, 0), (1080, 0), (1090, 0), (1100, 0), (1110, 0), (1120, 0), (1130, 0), (1140, 0), (1150, 0), (1160, 0), (1170, 0), (1180, 0), (1190, 0), (1200, 0), (1210, 0), (1220, 0), (1230, 0), (1240, 0), (1250, 0), (1260, 1), (1270, 1), (1280, 1), (1290, 0), (1300, 0), (1310, 0), (1320, 0), (1330, 0), (1340, 0), (1350, 0), (1360, 0), (1370, 0), (1380, 0), (1390, 0), (1400, 0), (1410, 0), (1420, 0), (1430, 0), (1440, 0), (1450, 0), (1460, 1), (1470, 1), (1480, 1), (1490, 1), (1500, 1), (1510, 1), (1520, 1), (1530, 0), (1540, 0), (1550, 0), (1560, 0), (1570, 0), (1580, 0), (1590, 0), (1600, 0), (1610, 0), (1620, 0), (1630, 0), (1640, 0), (1650, 0), (1660, 1), (1670, 1), (1680, 1), (1690, 1), (1700, 1), (1710, 0), (1720, 0), (1730, 0), (1740, 0), (1750, 0), (1760, 0), (1770, 0), (1780, 0), (1790, 1), (1800, 1), (1810, 1), (1820, 0), (1830, 0), (1840, 0), (1850, 0), (1860, 0), (1870, 0), (1880, 1), (1890, 1), (1900, 1), (1910, 1), (1920, 1), (1930, 1), (1940, 1), (1950, 1), (1960, 0), (1970, 0), (1980, 0), (1990, 1), (2000, 1), (2010, 1), (2020, 1), (2030, 1), (2040, 1), (2050, 1)]
Vdin0_2  din0_2  0 PWL (0n 0.0v 9.495n 0.0v 9.505n 3.3v 19.495n 3.3v 19.505n 0.0v 29.495n 0.0v 29.505n 0.0v 39.495n 0.0v 39.505n 0.0v 49.495n 0.0v 49.505n 0.0v 59.495n 0.0v 59.505n 3.3v 69.495n 3.3v 69.505n 3.3v 79.495n 3.3v 79.505n 3.3v 89.495n 3.3v 89.505n 3.3v 99.495n 3.3v 99.505n 3.3v 109.495n 3.3v 109.505n 3.3v 119.495n 3.3v 119.505n 3.3v 129.495n 3.3v 129.505n 3.3v 139.495n 3.3v 139.505n 3.3v 149.495n 3.3v 149.505n 3.3v 159.495n 3.3v 159.505n 0.0v 169.495n 0.0v 169.505n 0.0v 179.495n 0.0v 179.505n 0.0v 189.495n 0.0v 189.505n 0.0v 199.495n 0.0v 199.505n 0.0v 209.495n 0.0v 209.505n 0.0v 219.495n 0.0v 219.505n 0.0v 229.495n 0.0v 229.505n 0.0v 239.495n 0.0v 239.505n 0.0v 249.495n 0.0v 249.505n 0.0v 259.495n 0.0v 259.505n 0.0v 269.495n 0.0v 269.505n 0.0v 279.495n 0.0v 279.505n 0.0v 289.495n 0.0v 289.505n 3.3v 299.495n 3.3v 299.505n 3.3v 309.495n 3.3v 309.505n 3.3v 319.495n 3.3v 319.505n 3.3v 329.495n 3.3v 329.505n 0.0v 339.495n 0.0v 339.505n 0.0v 349.495n 0.0v 349.505n 0.0v 359.495n 0.0v 359.505n 0.0v 369.495n 0.0v 369.505n 0.0v 379.495n 0.0v 379.505n 0.0v 389.495n 0.0v 389.505n 0.0v 399.495n 0.0v 399.505n 0.0v 409.495n 0.0v 409.505n 0.0v 419.495n 0.0v 419.505n 3.3v 429.495n 3.3v 429.505n 3.3v 439.495n 3.3v 439.505n 3.3v 449.495n 3.3v 449.505n 3.3v 459.495n 3.3v 459.505n 0.0v 469.495n 0.0v 469.505n 0.0v 479.495n 0.0v 479.505n 0.0v 489.495n 0.0v 489.505n 0.0v 499.495n 0.0v 499.505n 0.0v 509.495n 0.0v 509.505n 0.0v 519.495n 0.0v 519.505n 0.0v 529.495n 0.0v 529.505n 3.3v 539.495n 3.3v 539.505n 0.0v 549.495n 0.0v 549.505n 0.0v 559.495n 0.0v 559.505n 0.0v 569.495n 0.0v 569.505n 0.0v 579.495n 0.0v 579.505n 3.3v 589.495n 3.3v 589.505n 3.3v 599.495n 3.3v 599.505n 3.3v 609.495n 3.3v 609.505n 3.3v 619.495n 3.3v 619.505n 3.3v 629.495n 3.3v 629.505n 3.3v 639.495n 3.3v 639.505n 3.3v 649.495n 3.3v 649.505n 3.3v 659.495n 3.3v 659.505n 3.3v 669.495n 3.3v 669.505n 3.3v 679.495n 3.3v 679.505n 3.3v 689.495n 3.3v 689.505n 3.3v 699.495n 3.3v 699.505n 3.3v 709.495n 3.3v 709.505n 0.0v 719.495n 0.0v 719.505n 0.0v 729.495n 0.0v 729.505n 0.0v 739.495n 0.0v 739.505n 0.0v 749.495n 0.0v 749.505n 0.0v 759.495n 0.0v 759.505n 0.0v 769.495n 0.0v 769.505n 0.0v 779.495n 0.0v 779.505n 3.3v 789.495n 3.3v 789.505n 0.0v 799.495n 0.0v 799.505n 0.0v 809.495n 0.0v 809.505n 0.0v 819.495n 0.0v 819.505n 0.0v 829.495n 0.0v 829.505n 0.0v 839.495n 0.0v 839.505n 0.0v 849.495n 0.0v 849.505n 0.0v 859.495n 0.0v 859.505n 0.0v 869.495n 0.0v 869.505n 0.0v 879.495n 0.0v 879.505n 0.0v 889.495n 0.0v 889.505n 0.0v 899.495n 0.0v 899.505n 0.0v 909.495n 0.0v 909.505n 0.0v 919.495n 0.0v 919.505n 0.0v 929.495n 0.0v 929.505n 0.0v 939.495n 0.0v 939.505n 0.0v 949.495n 0.0v 949.505n 0.0v 959.495n 0.0v 959.505n 0.0v 969.495n 0.0v 969.505n 0.0v 979.495n 0.0v 979.505n 0.0v 989.495n 0.0v 989.505n 0.0v 999.495n 0.0v 999.505n 0.0v 1009.495n 0.0v 1009.505n 0.0v 1019.495n 0.0v 1019.505n 0.0v 1029.495n 0.0v 1029.505n 0.0v 1039.495n 0.0v 1039.505n 0.0v 1049.495n 0.0v 1049.505n 0.0v 1059.495n 0.0v 1059.505n 0.0v 1069.495n 0.0v 1069.505n 0.0v 1079.495n 0.0v 1079.505n 0.0v 1089.495n 0.0v 1089.505n 0.0v 1099.495n 0.0v 1099.505n 0.0v 1109.495n 0.0v 1109.505n 0.0v 1119.495n 0.0v 1119.505n 0.0v 1129.495n 0.0v 1129.505n 0.0v 1139.495n 0.0v 1139.505n 0.0v 1149.495n 0.0v 1149.505n 0.0v 1159.495n 0.0v 1159.505n 0.0v 1169.495n 0.0v 1169.505n 0.0v 1179.495n 0.0v 1179.505n 0.0v 1189.495n 0.0v 1189.505n 0.0v 1199.495n 0.0v 1199.505n 0.0v 1209.495n 0.0v 1209.505n 0.0v 1219.495n 0.0v 1219.505n 0.0v 1229.495n 0.0v 1229.505n 0.0v 1239.495n 0.0v 1239.505n 0.0v 1249.495n 0.0v 1249.505n 0.0v 1259.495n 0.0v 1259.505n 3.3v 1269.495n 3.3v 1269.505n 3.3v 1279.495n 3.3v 1279.505n 3.3v 1289.495n 3.3v 1289.505n 0.0v 1299.495n 0.0v 1299.505n 0.0v 1309.495n 0.0v 1309.505n 0.0v 1319.495n 0.0v 1319.505n 0.0v 1329.495n 0.0v 1329.505n 0.0v 1339.495n 0.0v 1339.505n 0.0v 1349.495n 0.0v 1349.505n 0.0v 1359.495n 0.0v 1359.505n 0.0v 1369.495n 0.0v 1369.505n 0.0v 1379.495n 0.0v 1379.505n 0.0v 1389.495n 0.0v 1389.505n 0.0v 1399.495n 0.0v 1399.505n 0.0v 1409.495n 0.0v 1409.505n 0.0v 1419.495n 0.0v 1419.505n 0.0v 1429.495n 0.0v 1429.505n 0.0v 1439.495n 0.0v 1439.505n 0.0v 1449.495n 0.0v 1449.505n 0.0v 1459.495n 0.0v 1459.505n 3.3v 1469.495n 3.3v 1469.505n 3.3v 1479.495n 3.3v 1479.505n 3.3v 1489.495n 3.3v 1489.505n 3.3v 1499.495n 3.3v 1499.505n 3.3v 1509.495n 3.3v 1509.505n 3.3v 1519.495n 3.3v 1519.505n 3.3v 1529.495n 3.3v 1529.505n 0.0v 1539.495n 0.0v 1539.505n 0.0v 1549.495n 0.0v 1549.505n 0.0v 1559.495n 0.0v 1559.505n 0.0v 1569.495n 0.0v 1569.505n 0.0v 1579.495n 0.0v 1579.505n 0.0v 1589.495n 0.0v 1589.505n 0.0v 1599.495n 0.0v 1599.505n 0.0v 1609.495n 0.0v 1609.505n 0.0v 1619.495n 0.0v 1619.505n 0.0v 1629.495n 0.0v 1629.505n 0.0v 1639.495n 0.0v 1639.505n 0.0v 1649.495n 0.0v 1649.505n 0.0v 1659.495n 0.0v 1659.505n 3.3v 1669.495n 3.3v 1669.505n 3.3v 1679.495n 3.3v 1679.505n 3.3v 1689.495n 3.3v 1689.505n 3.3v 1699.495n 3.3v 1699.505n 3.3v 1709.495n 3.3v 1709.505n 0.0v 1719.495n 0.0v 1719.505n 0.0v 1729.495n 0.0v 1729.505n 0.0v 1739.495n 0.0v 1739.505n 0.0v 1749.495n 0.0v 1749.505n 0.0v 1759.495n 0.0v 1759.505n 0.0v 1769.495n 0.0v 1769.505n 0.0v 1779.495n 0.0v 1779.505n 0.0v 1789.495n 0.0v 1789.505n 3.3v 1799.495n 3.3v 1799.505n 3.3v 1809.495n 3.3v 1809.505n 3.3v 1819.495n 3.3v 1819.505n 0.0v 1829.495n 0.0v 1829.505n 0.0v 1839.495n 0.0v 1839.505n 0.0v 1849.495n 0.0v 1849.505n 0.0v 1859.495n 0.0v 1859.505n 0.0v 1869.495n 0.0v 1869.505n 0.0v 1879.495n 0.0v 1879.505n 3.3v 1889.495n 3.3v 1889.505n 3.3v 1899.495n 3.3v 1899.505n 3.3v 1909.495n 3.3v 1909.505n 3.3v 1919.495n 3.3v 1919.505n 3.3v 1929.495n 3.3v 1929.505n 3.3v 1939.495n 3.3v 1939.505n 3.3v 1949.495n 3.3v 1949.505n 3.3v 1959.495n 3.3v 1959.505n 0.0v 1969.495n 0.0v 1969.505n 0.0v 1979.495n 0.0v 1979.505n 0.0v 1989.495n 0.0v 1989.505n 3.3v 1999.495n 3.3v 1999.505n 3.3v 2009.495n 3.3v 2009.505n 3.3v 2019.495n 3.3v 2019.505n 3.3v 2029.495n 3.3v 2029.505n 3.3v 2039.495n 3.3v 2039.505n 3.3v 2049.495n 3.3v 2049.505n 3.3v )
* (time, data): [(0, 0), (10, 0), (20, 0), (30, 0), (40, 0), (50, 0), (60, 1), (70, 1), (80, 1), (90, 1), (100, 1), (110, 1), (120, 1), (130, 1), (140, 1), (150, 1), (160, 0), (170, 0), (180, 0), (190, 0), (200, 0), (210, 0), (220, 0), (230, 0), (240, 0), (250, 0), (260, 0), (270, 1), (280, 0), (290, 0), (300, 0), (310, 0), (320, 0), (330, 0), (340, 0), (350, 0), (360, 0), (370, 0), (380, 0), (390, 1), (400, 1), (410, 1), (420, 0), (430, 0), (440, 0), (450, 0), (460, 1), (470, 1), (480, 1), (490, 1), (500, 1), (510, 1), (520, 1), (530, 0), (540, 0), (550, 0), (560, 0), (570, 0), (580, 1), (590, 1), (600, 1), (610, 1), (620, 1), (630, 1), (640, 1), (650, 1), (660, 1), (670, 1), (680, 1), (690, 1), (700, 1), (710, 1), (720, 1), (730, 1), (740, 1), (750, 1), (760, 1), (770, 1), (780, 1), (790, 1), (800, 1), (810, 1), (820, 1), (830, 1), (840, 1), (850, 0), (860, 0), (870, 0), (880, 0), (890, 0), (900, 0), (910, 0), (920, 0), (930, 0), (940, 0), (950, 0), (960, 0), (970, 0), (980, 0), (990, 1), (1000, 1), (1010, 0), (1020, 1), (1030, 1), (1040, 1), (1050, 0), (1060, 0), (1070, 1), (1080, 1), (1090, 1), (1100, 1), (1110, 1), (1120, 1), (1130, 1), (1140, 1), (1150, 1), (1160, 1), (1170, 1), (1180, 1), (1190, 1), (1200, 1), (1210, 1), (1220, 1), (1230, 1), (1240, 0), (1250, 0), (1260, 1), (1270, 1), (1280, 0), (1290, 1), (1300, 1), (1310, 1), (1320, 1), (1330, 1), (1340, 0), (1350, 0), (1360, 0), (1370, 1), (1380, 1), (1390, 1), (1400, 1), (1410, 1), (1420, 1), (1430, 1), (1440, 1), (1450, 1), (1460, 0), (1470, 0), (1480, 0), (1490, 0), (1500, 0), (1510, 0), (1520, 0), (1530, 1), (1540, 1), (1550, 1), (1560, 1), (1570, 1), (1580, 1), (1590, 1), (1600, 1), (1610, 1), (1620, 1), (1630, 1), (1640, 1), (1650, 1), (1660, 1), (1670, 1), (1680, 1), (1690, 1), (1700, 1), (1710, 1), (1720, 1), (1730, 1), (1740, 1), (1750, 1), (1760, 1), (1770, 1), (1780, 1), (1790, 1), (1800, 1), (1810, 1), (1820, 0), (1830, 0), (1840, 0), (1850, 0), (1860, 0), (1870, 0), (1880, 1), (1890, 1), (1900, 0), (1910, 0), (1920, 0), (1930, 0), (1940, 0), (1950, 0), (1960, 0), (1970, 0), (1980, 0), (1990, 0), (2000, 0), (2010, 0), (2020, 0), (2030, 0), (2040, 0), (2050, 0)]
Vdin0_3  din0_3  0 PWL (0n 0.0v 9.495n 0.0v 9.505n 0.0v 19.495n 0.0v 19.505n 0.0v 29.495n 0.0v 29.505n 0.0v 39.495n 0.0v 39.505n 0.0v 49.495n 0.0v 49.505n 0.0v 59.495n 0.0v 59.505n 3.3v 69.495n 3.3v 69.505n 3.3v 79.495n 3.3v 79.505n 3.3v 89.495n 3.3v 89.505n 3.3v 99.495n 3.3v 99.505n 3.3v 109.495n 3.3v 109.505n 3.3v 119.495n 3.3v 119.505n 3.3v 129.495n 3.3v 129.505n 3.3v 139.495n 3.3v 139.505n 3.3v 149.495n 3.3v 149.505n 3.3v 159.495n 3.3v 159.505n 0.0v 169.495n 0.0v 169.505n 0.0v 179.495n 0.0v 179.505n 0.0v 189.495n 0.0v 189.505n 0.0v 199.495n 0.0v 199.505n 0.0v 209.495n 0.0v 209.505n 0.0v 219.495n 0.0v 219.505n 0.0v 229.495n 0.0v 229.505n 0.0v 239.495n 0.0v 239.505n 0.0v 249.495n 0.0v 249.505n 0.0v 259.495n 0.0v 259.505n 0.0v 269.495n 0.0v 269.505n 3.3v 279.495n 3.3v 279.505n 0.0v 289.495n 0.0v 289.505n 0.0v 299.495n 0.0v 299.505n 0.0v 309.495n 0.0v 309.505n 0.0v 319.495n 0.0v 319.505n 0.0v 329.495n 0.0v 329.505n 0.0v 339.495n 0.0v 339.505n 0.0v 349.495n 0.0v 349.505n 0.0v 359.495n 0.0v 359.505n 0.0v 369.495n 0.0v 369.505n 0.0v 379.495n 0.0v 379.505n 0.0v 389.495n 0.0v 389.505n 3.3v 399.495n 3.3v 399.505n 3.3v 409.495n 3.3v 409.505n 3.3v 419.495n 3.3v 419.505n 0.0v 429.495n 0.0v 429.505n 0.0v 439.495n 0.0v 439.505n 0.0v 449.495n 0.0v 449.505n 0.0v 459.495n 0.0v 459.505n 3.3v 469.495n 3.3v 469.505n 3.3v 479.495n 3.3v 479.505n 3.3v 489.495n 3.3v 489.505n 3.3v 499.495n 3.3v 499.505n 3.3v 509.495n 3.3v 509.505n 3.3v 519.495n 3.3v 519.505n 3.3v 529.495n 3.3v 529.505n 0.0v 539.495n 0.0v 539.505n 0.0v 549.495n 0.0v 549.505n 0.0v 559.495n 0.0v 559.505n 0.0v 569.495n 0.0v 569.505n 0.0v 579.495n 0.0v 579.505n 3.3v 589.495n 3.3v 589.505n 3.3v 599.495n 3.3v 599.505n 3.3v 609.495n 3.3v 609.505n 3.3v 619.495n 3.3v 619.505n 3.3v 629.495n 3.3v 629.505n 3.3v 639.495n 3.3v 639.505n 3.3v 649.495n 3.3v 649.505n 3.3v 659.495n 3.3v 659.505n 3.3v 669.495n 3.3v 669.505n 3.3v 679.495n 3.3v 679.505n 3.3v 689.495n 3.3v 689.505n 3.3v 699.495n 3.3v 699.505n 3.3v 709.495n 3.3v 709.505n 3.3v 719.495n 3.3v 719.505n 3.3v 729.495n 3.3v 729.505n 3.3v 739.495n 3.3v 739.505n 3.3v 749.495n 3.3v 749.505n 3.3v 759.495n 3.3v 759.505n 3.3v 769.495n 3.3v 769.505n 3.3v 779.495n 3.3v 779.505n 3.3v 789.495n 3.3v 789.505n 3.3v 799.495n 3.3v 799.505n 3.3v 809.495n 3.3v 809.505n 3.3v 819.495n 3.3v 819.505n 3.3v 829.495n 3.3v 829.505n 3.3v 839.495n 3.3v 839.505n 3.3v 849.495n 3.3v 849.505n 0.0v 859.495n 0.0v 859.505n 0.0v 869.495n 0.0v 869.505n 0.0v 879.495n 0.0v 879.505n 0.0v 889.495n 0.0v 889.505n 0.0v 899.495n 0.0v 899.505n 0.0v 909.495n 0.0v 909.505n 0.0v 919.495n 0.0v 919.505n 0.0v 929.495n 0.0v 929.505n 0.0v 939.495n 0.0v 939.505n 0.0v 949.495n 0.0v 949.505n 0.0v 959.495n 0.0v 959.505n 0.0v 969.495n 0.0v 969.505n 0.0v 979.495n 0.0v 979.505n 0.0v 989.495n 0.0v 989.505n 3.3v 999.495n 3.3v 999.505n 3.3v 1009.495n 3.3v 1009.505n 0.0v 1019.495n 0.0v 1019.505n 3.3v 1029.495n 3.3v 1029.505n 3.3v 1039.495n 3.3v 1039.505n 3.3v 1049.495n 3.3v 1049.505n 0.0v 1059.495n 0.0v 1059.505n 0.0v 1069.495n 0.0v 1069.505n 3.3v 1079.495n 3.3v 1079.505n 3.3v 1089.495n 3.3v 1089.505n 3.3v 1099.495n 3.3v 1099.505n 3.3v 1109.495n 3.3v 1109.505n 3.3v 1119.495n 3.3v 1119.505n 3.3v 1129.495n 3.3v 1129.505n 3.3v 1139.495n 3.3v 1139.505n 3.3v 1149.495n 3.3v 1149.505n 3.3v 1159.495n 3.3v 1159.505n 3.3v 1169.495n 3.3v 1169.505n 3.3v 1179.495n 3.3v 1179.505n 3.3v 1189.495n 3.3v 1189.505n 3.3v 1199.495n 3.3v 1199.505n 3.3v 1209.495n 3.3v 1209.505n 3.3v 1219.495n 3.3v 1219.505n 3.3v 1229.495n 3.3v 1229.505n 3.3v 1239.495n 3.3v 1239.505n 0.0v 1249.495n 0.0v 1249.505n 0.0v 1259.495n 0.0v 1259.505n 3.3v 1269.495n 3.3v 1269.505n 3.3v 1279.495n 3.3v 1279.505n 0.0v 1289.495n 0.0v 1289.505n 3.3v 1299.495n 3.3v 1299.505n 3.3v 1309.495n 3.3v 1309.505n 3.3v 1319.495n 3.3v 1319.505n 3.3v 1329.495n 3.3v 1329.505n 3.3v 1339.495n 3.3v 1339.505n 0.0v 1349.495n 0.0v 1349.505n 0.0v 1359.495n 0.0v 1359.505n 0.0v 1369.495n 0.0v 1369.505n 3.3v 1379.495n 3.3v 1379.505n 3.3v 1389.495n 3.3v 1389.505n 3.3v 1399.495n 3.3v 1399.505n 3.3v 1409.495n 3.3v 1409.505n 3.3v 1419.495n 3.3v 1419.505n 3.3v 1429.495n 3.3v 1429.505n 3.3v 1439.495n 3.3v 1439.505n 3.3v 1449.495n 3.3v 1449.505n 3.3v 1459.495n 3.3v 1459.505n 0.0v 1469.495n 0.0v 1469.505n 0.0v 1479.495n 0.0v 1479.505n 0.0v 1489.495n 0.0v 1489.505n 0.0v 1499.495n 0.0v 1499.505n 0.0v 1509.495n 0.0v 1509.505n 0.0v 1519.495n 0.0v 1519.505n 0.0v 1529.495n 0.0v 1529.505n 3.3v 1539.495n 3.3v 1539.505n 3.3v 1549.495n 3.3v 1549.505n 3.3v 1559.495n 3.3v 1559.505n 3.3v 1569.495n 3.3v 1569.505n 3.3v 1579.495n 3.3v 1579.505n 3.3v 1589.495n 3.3v 1589.505n 3.3v 1599.495n 3.3v 1599.505n 3.3v 1609.495n 3.3v 1609.505n 3.3v 1619.495n 3.3v 1619.505n 3.3v 1629.495n 3.3v 1629.505n 3.3v 1639.495n 3.3v 1639.505n 3.3v 1649.495n 3.3v 1649.505n 3.3v 1659.495n 3.3v 1659.505n 3.3v 1669.495n 3.3v 1669.505n 3.3v 1679.495n 3.3v 1679.505n 3.3v 1689.495n 3.3v 1689.505n 3.3v 1699.495n 3.3v 1699.505n 3.3v 1709.495n 3.3v 1709.505n 3.3v 1719.495n 3.3v 1719.505n 3.3v 1729.495n 3.3v 1729.505n 3.3v 1739.495n 3.3v 1739.505n 3.3v 1749.495n 3.3v 1749.505n 3.3v 1759.495n 3.3v 1759.505n 3.3v 1769.495n 3.3v 1769.505n 3.3v 1779.495n 3.3v 1779.505n 3.3v 1789.495n 3.3v 1789.505n 3.3v 1799.495n 3.3v 1799.505n 3.3v 1809.495n 3.3v 1809.505n 3.3v 1819.495n 3.3v 1819.505n 0.0v 1829.495n 0.0v 1829.505n 0.0v 1839.495n 0.0v 1839.505n 0.0v 1849.495n 0.0v 1849.505n 0.0v 1859.495n 0.0v 1859.505n 0.0v 1869.495n 0.0v 1869.505n 0.0v 1879.495n 0.0v 1879.505n 3.3v 1889.495n 3.3v 1889.505n 3.3v 1899.495n 3.3v 1899.505n 0.0v 1909.495n 0.0v 1909.505n 0.0v 1919.495n 0.0v 1919.505n 0.0v 1929.495n 0.0v 1929.505n 0.0v 1939.495n 0.0v 1939.505n 0.0v 1949.495n 0.0v 1949.505n 0.0v 1959.495n 0.0v 1959.505n 0.0v 1969.495n 0.0v 1969.505n 0.0v 1979.495n 0.0v 1979.505n 0.0v 1989.495n 0.0v 1989.505n 0.0v 1999.495n 0.0v 1999.505n 0.0v 2009.495n 0.0v 2009.505n 0.0v 2019.495n 0.0v 2019.505n 0.0v 2029.495n 0.0v 2029.505n 0.0v 2039.495n 0.0v 2039.505n 0.0v 2049.495n 0.0v 2049.505n 0.0v )
* (time, data): [(0, 0), (10, 0), (20, 0), (30, 0), (40, 0), (50, 0), (60, 1), (70, 1), (80, 1), (90, 1), (100, 0), (110, 0), (120, 0), (130, 0), (140, 0), (150, 0), (160, 0), (170, 0), (180, 0), (190, 0), (200, 0), (210, 0), (220, 1), (230, 1), (240, 1), (250, 1), (260, 1), (270, 0), (280, 1), (290, 0), (300, 0), (310, 1), (320, 1), (330, 0), (340, 1), (350, 1), (360, 1), (370, 1), (380, 1), (390, 0), (400, 0), (410, 0), (420, 0), (430, 1), (440, 1), (450, 1), (460, 0), (470, 1), (480, 1), (490, 1), (500, 1), (510, 1), (520, 1), (530, 1), (540, 1), (550, 1), (560, 0), (570, 0), (580, 1), (590, 1), (600, 1), (610, 1), (620, 1), (630, 1), (640, 1), (650, 1), (660, 1), (670, 1), (680, 1), (690, 1), (700, 1), (710, 1), (720, 1), (730, 1), (740, 1), (750, 1), (760, 1), (770, 1), (780, 1), (790, 0), (800, 0), (810, 0), (820, 0), (830, 0), (840, 0), (850, 0), (860, 0), (870, 0), (880, 0), (890, 0), (900, 0), (910, 0), (920, 0), (930, 0), (940, 0), (950, 0), (960, 0), (970, 0), (980, 0), (990, 1), (1000, 0), (1010, 0), (1020, 0), (1030, 0), (1040, 0), (1050, 1), (1060, 1), (1070, 0), (1080, 0), (1090, 0), (1100, 0), (1110, 0), (1120, 0), (1130, 0), (1140, 0), (1150, 0), (1160, 0), (1170, 0), (1180, 0), (1190, 0), (1200, 0), (1210, 0), (1220, 0), (1230, 0), (1240, 1), (1250, 1), (1260, 1), (1270, 1), (1280, 0), (1290, 0), (1300, 0), (1310, 0), (1320, 0), (1330, 0), (1340, 0), (1350, 0), (1360, 0), (1370, 0), (1380, 0), (1390, 0), (1400, 0), (1410, 0), (1420, 0), (1430, 0), (1440, 0), (1450, 0), (1460, 1), (1470, 1), (1480, 1), (1490, 1), (1500, 0), (1510, 0), (1520, 0), (1530, 1), (1540, 1), (1550, 1), (1560, 1), (1570, 1), (1580, 1), (1590, 1), (1600, 1), (1610, 1), (1620, 1), (1630, 1), (1640, 1), (1650, 1), (1660, 0), (1670, 0), (1680, 0), (1690, 0), (1700, 0), (1710, 1), (1720, 1), (1730, 1), (1740, 1), (1750, 1), (1760, 1), (1770, 1), (1780, 1), (1790, 1), (1800, 1), (1810, 1), (1820, 1), (1830, 1), (1840, 1), (1850, 0), (1860, 0), (1870, 0), (1880, 0), (1890, 0), (1900, 0), (1910, 0), (1920, 0), (1930, 0), (1940, 0), (1950, 0), (1960, 1), (1970, 1), (1980, 1), (1990, 0), (2000, 0), (2010, 0), (2020, 0), (2030, 0), (2040, 0), (2050, 0)]
Vdin0_4  din0_4  0 PWL (0n 0.0v 9.495n 0.0v 9.505n 0.0v 19.495n 0.0v 19.505n 0.0v 29.495n 0.0v 29.505n 0.0v 39.495n 0.0v 39.505n 0.0v 49.495n 0.0v 49.505n 0.0v 59.495n 0.0v 59.505n 3.3v 69.495n 3.3v 69.505n 3.3v 79.495n 3.3v 79.505n 3.3v 89.495n 3.3v 89.505n 3.3v 99.495n 3.3v 99.505n 0.0v 109.495n 0.0v 109.505n 0.0v 119.495n 0.0v 119.505n 0.0v 129.495n 0.0v 129.505n 0.0v 139.495n 0.0v 139.505n 0.0v 149.495n 0.0v 149.505n 0.0v 159.495n 0.0v 159.505n 0.0v 169.495n 0.0v 169.505n 0.0v 179.495n 0.0v 179.505n 0.0v 189.495n 0.0v 189.505n 0.0v 199.495n 0.0v 199.505n 0.0v 209.495n 0.0v 209.505n 0.0v 219.495n 0.0v 219.505n 3.3v 229.495n 3.3v 229.505n 3.3v 239.495n 3.3v 239.505n 3.3v 249.495n 3.3v 249.505n 3.3v 259.495n 3.3v 259.505n 3.3v 269.495n 3.3v 269.505n 0.0v 279.495n 0.0v 279.505n 3.3v 289.495n 3.3v 289.505n 0.0v 299.495n 0.0v 299.505n 0.0v 309.495n 0.0v 309.505n 3.3v 319.495n 3.3v 319.505n 3.3v 329.495n 3.3v 329.505n 0.0v 339.495n 0.0v 339.505n 3.3v 349.495n 3.3v 349.505n 3.3v 359.495n 3.3v 359.505n 3.3v 369.495n 3.3v 369.505n 3.3v 379.495n 3.3v 379.505n 3.3v 389.495n 3.3v 389.505n 0.0v 399.495n 0.0v 399.505n 0.0v 409.495n 0.0v 409.505n 0.0v 419.495n 0.0v 419.505n 0.0v 429.495n 0.0v 429.505n 3.3v 439.495n 3.3v 439.505n 3.3v 449.495n 3.3v 449.505n 3.3v 459.495n 3.3v 459.505n 0.0v 469.495n 0.0v 469.505n 3.3v 479.495n 3.3v 479.505n 3.3v 489.495n 3.3v 489.505n 3.3v 499.495n 3.3v 499.505n 3.3v 509.495n 3.3v 509.505n 3.3v 519.495n 3.3v 519.505n 3.3v 529.495n 3.3v 529.505n 3.3v 539.495n 3.3v 539.505n 3.3v 549.495n 3.3v 549.505n 3.3v 559.495n 3.3v 559.505n 0.0v 569.495n 0.0v 569.505n 0.0v 579.495n 0.0v 579.505n 3.3v 589.495n 3.3v 589.505n 3.3v 599.495n 3.3v 599.505n 3.3v 609.495n 3.3v 609.505n 3.3v 619.495n 3.3v 619.505n 3.3v 629.495n 3.3v 629.505n 3.3v 639.495n 3.3v 639.505n 3.3v 649.495n 3.3v 649.505n 3.3v 659.495n 3.3v 659.505n 3.3v 669.495n 3.3v 669.505n 3.3v 679.495n 3.3v 679.505n 3.3v 689.495n 3.3v 689.505n 3.3v 699.495n 3.3v 699.505n 3.3v 709.495n 3.3v 709.505n 3.3v 719.495n 3.3v 719.505n 3.3v 729.495n 3.3v 729.505n 3.3v 739.495n 3.3v 739.505n 3.3v 749.495n 3.3v 749.505n 3.3v 759.495n 3.3v 759.505n 3.3v 769.495n 3.3v 769.505n 3.3v 779.495n 3.3v 779.505n 3.3v 789.495n 3.3v 789.505n 0.0v 799.495n 0.0v 799.505n 0.0v 809.495n 0.0v 809.505n 0.0v 819.495n 0.0v 819.505n 0.0v 829.495n 0.0v 829.505n 0.0v 839.495n 0.0v 839.505n 0.0v 849.495n 0.0v 849.505n 0.0v 859.495n 0.0v 859.505n 0.0v 869.495n 0.0v 869.505n 0.0v 879.495n 0.0v 879.505n 0.0v 889.495n 0.0v 889.505n 0.0v 899.495n 0.0v 899.505n 0.0v 909.495n 0.0v 909.505n 0.0v 919.495n 0.0v 919.505n 0.0v 929.495n 0.0v 929.505n 0.0v 939.495n 0.0v 939.505n 0.0v 949.495n 0.0v 949.505n 0.0v 959.495n 0.0v 959.505n 0.0v 969.495n 0.0v 969.505n 0.0v 979.495n 0.0v 979.505n 0.0v 989.495n 0.0v 989.505n 3.3v 999.495n 3.3v 999.505n 0.0v 1009.495n 0.0v 1009.505n 0.0v 1019.495n 0.0v 1019.505n 0.0v 1029.495n 0.0v 1029.505n 0.0v 1039.495n 0.0v 1039.505n 0.0v 1049.495n 0.0v 1049.505n 3.3v 1059.495n 3.3v 1059.505n 3.3v 1069.495n 3.3v 1069.505n 0.0v 1079.495n 0.0v 1079.505n 0.0v 1089.495n 0.0v 1089.505n 0.0v 1099.495n 0.0v 1099.505n 0.0v 1109.495n 0.0v 1109.505n 0.0v 1119.495n 0.0v 1119.505n 0.0v 1129.495n 0.0v 1129.505n 0.0v 1139.495n 0.0v 1139.505n 0.0v 1149.495n 0.0v 1149.505n 0.0v 1159.495n 0.0v 1159.505n 0.0v 1169.495n 0.0v 1169.505n 0.0v 1179.495n 0.0v 1179.505n 0.0v 1189.495n 0.0v 1189.505n 0.0v 1199.495n 0.0v 1199.505n 0.0v 1209.495n 0.0v 1209.505n 0.0v 1219.495n 0.0v 1219.505n 0.0v 1229.495n 0.0v 1229.505n 0.0v 1239.495n 0.0v 1239.505n 3.3v 1249.495n 3.3v 1249.505n 3.3v 1259.495n 3.3v 1259.505n 3.3v 1269.495n 3.3v 1269.505n 3.3v 1279.495n 3.3v 1279.505n 0.0v 1289.495n 0.0v 1289.505n 0.0v 1299.495n 0.0v 1299.505n 0.0v 1309.495n 0.0v 1309.505n 0.0v 1319.495n 0.0v 1319.505n 0.0v 1329.495n 0.0v 1329.505n 0.0v 1339.495n 0.0v 1339.505n 0.0v 1349.495n 0.0v 1349.505n 0.0v 1359.495n 0.0v 1359.505n 0.0v 1369.495n 0.0v 1369.505n 0.0v 1379.495n 0.0v 1379.505n 0.0v 1389.495n 0.0v 1389.505n 0.0v 1399.495n 0.0v 1399.505n 0.0v 1409.495n 0.0v 1409.505n 0.0v 1419.495n 0.0v 1419.505n 0.0v 1429.495n 0.0v 1429.505n 0.0v 1439.495n 0.0v 1439.505n 0.0v 1449.495n 0.0v 1449.505n 0.0v 1459.495n 0.0v 1459.505n 3.3v 1469.495n 3.3v 1469.505n 3.3v 1479.495n 3.3v 1479.505n 3.3v 1489.495n 3.3v 1489.505n 3.3v 1499.495n 3.3v 1499.505n 0.0v 1509.495n 0.0v 1509.505n 0.0v 1519.495n 0.0v 1519.505n 0.0v 1529.495n 0.0v 1529.505n 3.3v 1539.495n 3.3v 1539.505n 3.3v 1549.495n 3.3v 1549.505n 3.3v 1559.495n 3.3v 1559.505n 3.3v 1569.495n 3.3v 1569.505n 3.3v 1579.495n 3.3v 1579.505n 3.3v 1589.495n 3.3v 1589.505n 3.3v 1599.495n 3.3v 1599.505n 3.3v 1609.495n 3.3v 1609.505n 3.3v 1619.495n 3.3v 1619.505n 3.3v 1629.495n 3.3v 1629.505n 3.3v 1639.495n 3.3v 1639.505n 3.3v 1649.495n 3.3v 1649.505n 3.3v 1659.495n 3.3v 1659.505n 0.0v 1669.495n 0.0v 1669.505n 0.0v 1679.495n 0.0v 1679.505n 0.0v 1689.495n 0.0v 1689.505n 0.0v 1699.495n 0.0v 1699.505n 0.0v 1709.495n 0.0v 1709.505n 3.3v 1719.495n 3.3v 1719.505n 3.3v 1729.495n 3.3v 1729.505n 3.3v 1739.495n 3.3v 1739.505n 3.3v 1749.495n 3.3v 1749.505n 3.3v 1759.495n 3.3v 1759.505n 3.3v 1769.495n 3.3v 1769.505n 3.3v 1779.495n 3.3v 1779.505n 3.3v 1789.495n 3.3v 1789.505n 3.3v 1799.495n 3.3v 1799.505n 3.3v 1809.495n 3.3v 1809.505n 3.3v 1819.495n 3.3v 1819.505n 3.3v 1829.495n 3.3v 1829.505n 3.3v 1839.495n 3.3v 1839.505n 3.3v 1849.495n 3.3v 1849.505n 0.0v 1859.495n 0.0v 1859.505n 0.0v 1869.495n 0.0v 1869.505n 0.0v 1879.495n 0.0v 1879.505n 0.0v 1889.495n 0.0v 1889.505n 0.0v 1899.495n 0.0v 1899.505n 0.0v 1909.495n 0.0v 1909.505n 0.0v 1919.495n 0.0v 1919.505n 0.0v 1929.495n 0.0v 1929.505n 0.0v 1939.495n 0.0v 1939.505n 0.0v 1949.495n 0.0v 1949.505n 0.0v 1959.495n 0.0v 1959.505n 3.3v 1969.495n 3.3v 1969.505n 3.3v 1979.495n 3.3v 1979.505n 3.3v 1989.495n 3.3v 1989.505n 0.0v 1999.495n 0.0v 1999.505n 0.0v 2009.495n 0.0v 2009.505n 0.0v 2019.495n 0.0v 2019.505n 0.0v 2029.495n 0.0v 2029.505n 0.0v 2039.495n 0.0v 2039.505n 0.0v 2049.495n 0.0v 2049.505n 0.0v )
* (time, data): [(0, 0), (10, 1), (20, 0), (30, 0), (40, 0), (50, 0), (60, 0), (70, 0), (80, 0), (90, 0), (100, 1), (110, 1), (120, 1), (130, 1), (140, 1), (150, 1), (160, 1), (170, 1), (180, 1), (190, 1), (200, 1), (210, 1), (220, 1), (230, 1), (240, 1), (250, 1), (260, 1), (270, 1), (280, 0), (290, 1), (300, 1), (310, 0), (320, 0), (330, 0), (340, 1), (350, 1), (360, 1), (370, 1), (380, 1), (390, 0), (400, 0), (410, 0), (420, 0), (430, 0), (440, 0), (450, 0), (460, 1), (470, 1), (480, 1), (490, 1), (500, 1), (510, 1), (520, 1), (530, 0), (540, 0), (550, 0), (560, 1), (570, 1), (580, 0), (590, 0), (600, 0), (610, 1), (620, 1), (630, 1), (640, 1), (650, 1), (660, 1), (670, 1), (680, 1), (690, 1), (700, 1), (710, 1), (720, 1), (730, 1), (740, 1), (750, 1), (760, 1), (770, 1), (780, 1), (790, 1), (800, 1), (810, 1), (820, 1), (830, 1), (840, 1), (850, 1), (860, 1), (870, 1), (880, 1), (890, 1), (900, 1), (910, 1), (920, 1), (930, 1), (940, 1), (950, 1), (960, 1), (970, 1), (980, 1), (990, 1), (1000, 1), (1010, 1), (1020, 1), (1030, 1), (1040, 1), (1050, 1), (1060, 1), (1070, 0), (1080, 0), (1090, 0), (1100, 0), (1110, 0), (1120, 0), (1130, 0), (1140, 0), (1150, 0), (1160, 0), (1170, 0), (1180, 0), (1190, 0), (1200, 0), (1210, 0), (1220, 0), (1230, 0), (1240, 0), (1250, 0), (1260, 0), (1270, 0), (1280, 1), (1290, 1), (1300, 1), (1310, 1), (1320, 1), (1330, 1), (1340, 0), (1350, 0), (1360, 0), (1370, 0), (1380, 0), (1390, 0), (1400, 0), (1410, 0), (1420, 0), (1430, 0), (1440, 0), (1450, 0), (1460, 0), (1470, 0), (1480, 0), (1490, 0), (1500, 0), (1510, 0), (1520, 0), (1530, 0), (1540, 0), (1550, 0), (1560, 0), (1570, 0), (1580, 0), (1590, 0), (1600, 0), (1610, 0), (1620, 0), (1630, 0), (1640, 0), (1650, 0), (1660, 1), (1670, 1), (1680, 1), (1690, 1), (1700, 1), (1710, 1), (1720, 1), (1730, 1), (1740, 1), (1750, 1), (1760, 1), (1770, 1), (1780, 1), (1790, 1), (1800, 1), (1810, 1), (1820, 0), (1830, 0), (1840, 0), (1850, 0), (1860, 0), (1870, 0), (1880, 0), (1890, 0), (1900, 1), (1910, 1), (1920, 1), (1930, 1), (1940, 1), (1950, 1), (1960, 1), (1970, 1), (1980, 1), (1990, 0), (2000, 0), (2010, 0), (2020, 0), (2030, 0), (2040, 0), (2050, 0)]
Vdin0_5  din0_5  0 PWL (0n 0.0v 9.495n 0.0v 9.505n 3.3v 19.495n 3.3v 19.505n 0.0v 29.495n 0.0v 29.505n 0.0v 39.495n 0.0v 39.505n 0.0v 49.495n 0.0v 49.505n 0.0v 59.495n 0.0v 59.505n 0.0v 69.495n 0.0v 69.505n 0.0v 79.495n 0.0v 79.505n 0.0v 89.495n 0.0v 89.505n 0.0v 99.495n 0.0v 99.505n 3.3v 109.495n 3.3v 109.505n 3.3v 119.495n 3.3v 119.505n 3.3v 129.495n 3.3v 129.505n 3.3v 139.495n 3.3v 139.505n 3.3v 149.495n 3.3v 149.505n 3.3v 159.495n 3.3v 159.505n 3.3v 169.495n 3.3v 169.505n 3.3v 179.495n 3.3v 179.505n 3.3v 189.495n 3.3v 189.505n 3.3v 199.495n 3.3v 199.505n 3.3v 209.495n 3.3v 209.505n 3.3v 219.495n 3.3v 219.505n 3.3v 229.495n 3.3v 229.505n 3.3v 239.495n 3.3v 239.505n 3.3v 249.495n 3.3v 249.505n 3.3v 259.495n 3.3v 259.505n 3.3v 269.495n 3.3v 269.505n 3.3v 279.495n 3.3v 279.505n 0.0v 289.495n 0.0v 289.505n 3.3v 299.495n 3.3v 299.505n 3.3v 309.495n 3.3v 309.505n 0.0v 319.495n 0.0v 319.505n 0.0v 329.495n 0.0v 329.505n 0.0v 339.495n 0.0v 339.505n 3.3v 349.495n 3.3v 349.505n 3.3v 359.495n 3.3v 359.505n 3.3v 369.495n 3.3v 369.505n 3.3v 379.495n 3.3v 379.505n 3.3v 389.495n 3.3v 389.505n 0.0v 399.495n 0.0v 399.505n 0.0v 409.495n 0.0v 409.505n 0.0v 419.495n 0.0v 419.505n 0.0v 429.495n 0.0v 429.505n 0.0v 439.495n 0.0v 439.505n 0.0v 449.495n 0.0v 449.505n 0.0v 459.495n 0.0v 459.505n 3.3v 469.495n 3.3v 469.505n 3.3v 479.495n 3.3v 479.505n 3.3v 489.495n 3.3v 489.505n 3.3v 499.495n 3.3v 499.505n 3.3v 509.495n 3.3v 509.505n 3.3v 519.495n 3.3v 519.505n 3.3v 529.495n 3.3v 529.505n 0.0v 539.495n 0.0v 539.505n 0.0v 549.495n 0.0v 549.505n 0.0v 559.495n 0.0v 559.505n 3.3v 569.495n 3.3v 569.505n 3.3v 579.495n 3.3v 579.505n 0.0v 589.495n 0.0v 589.505n 0.0v 599.495n 0.0v 599.505n 0.0v 609.495n 0.0v 609.505n 3.3v 619.495n 3.3v 619.505n 3.3v 629.495n 3.3v 629.505n 3.3v 639.495n 3.3v 639.505n 3.3v 649.495n 3.3v 649.505n 3.3v 659.495n 3.3v 659.505n 3.3v 669.495n 3.3v 669.505n 3.3v 679.495n 3.3v 679.505n 3.3v 689.495n 3.3v 689.505n 3.3v 699.495n 3.3v 699.505n 3.3v 709.495n 3.3v 709.505n 3.3v 719.495n 3.3v 719.505n 3.3v 729.495n 3.3v 729.505n 3.3v 739.495n 3.3v 739.505n 3.3v 749.495n 3.3v 749.505n 3.3v 759.495n 3.3v 759.505n 3.3v 769.495n 3.3v 769.505n 3.3v 779.495n 3.3v 779.505n 3.3v 789.495n 3.3v 789.505n 3.3v 799.495n 3.3v 799.505n 3.3v 809.495n 3.3v 809.505n 3.3v 819.495n 3.3v 819.505n 3.3v 829.495n 3.3v 829.505n 3.3v 839.495n 3.3v 839.505n 3.3v 849.495n 3.3v 849.505n 3.3v 859.495n 3.3v 859.505n 3.3v 869.495n 3.3v 869.505n 3.3v 879.495n 3.3v 879.505n 3.3v 889.495n 3.3v 889.505n 3.3v 899.495n 3.3v 899.505n 3.3v 909.495n 3.3v 909.505n 3.3v 919.495n 3.3v 919.505n 3.3v 929.495n 3.3v 929.505n 3.3v 939.495n 3.3v 939.505n 3.3v 949.495n 3.3v 949.505n 3.3v 959.495n 3.3v 959.505n 3.3v 969.495n 3.3v 969.505n 3.3v 979.495n 3.3v 979.505n 3.3v 989.495n 3.3v 989.505n 3.3v 999.495n 3.3v 999.505n 3.3v 1009.495n 3.3v 1009.505n 3.3v 1019.495n 3.3v 1019.505n 3.3v 1029.495n 3.3v 1029.505n 3.3v 1039.495n 3.3v 1039.505n 3.3v 1049.495n 3.3v 1049.505n 3.3v 1059.495n 3.3v 1059.505n 3.3v 1069.495n 3.3v 1069.505n 0.0v 1079.495n 0.0v 1079.505n 0.0v 1089.495n 0.0v 1089.505n 0.0v 1099.495n 0.0v 1099.505n 0.0v 1109.495n 0.0v 1109.505n 0.0v 1119.495n 0.0v 1119.505n 0.0v 1129.495n 0.0v 1129.505n 0.0v 1139.495n 0.0v 1139.505n 0.0v 1149.495n 0.0v 1149.505n 0.0v 1159.495n 0.0v 1159.505n 0.0v 1169.495n 0.0v 1169.505n 0.0v 1179.495n 0.0v 1179.505n 0.0v 1189.495n 0.0v 1189.505n 0.0v 1199.495n 0.0v 1199.505n 0.0v 1209.495n 0.0v 1209.505n 0.0v 1219.495n 0.0v 1219.505n 0.0v 1229.495n 0.0v 1229.505n 0.0v 1239.495n 0.0v 1239.505n 0.0v 1249.495n 0.0v 1249.505n 0.0v 1259.495n 0.0v 1259.505n 0.0v 1269.495n 0.0v 1269.505n 0.0v 1279.495n 0.0v 1279.505n 3.3v 1289.495n 3.3v 1289.505n 3.3v 1299.495n 3.3v 1299.505n 3.3v 1309.495n 3.3v 1309.505n 3.3v 1319.495n 3.3v 1319.505n 3.3v 1329.495n 3.3v 1329.505n 3.3v 1339.495n 3.3v 1339.505n 0.0v 1349.495n 0.0v 1349.505n 0.0v 1359.495n 0.0v 1359.505n 0.0v 1369.495n 0.0v 1369.505n 0.0v 1379.495n 0.0v 1379.505n 0.0v 1389.495n 0.0v 1389.505n 0.0v 1399.495n 0.0v 1399.505n 0.0v 1409.495n 0.0v 1409.505n 0.0v 1419.495n 0.0v 1419.505n 0.0v 1429.495n 0.0v 1429.505n 0.0v 1439.495n 0.0v 1439.505n 0.0v 1449.495n 0.0v 1449.505n 0.0v 1459.495n 0.0v 1459.505n 0.0v 1469.495n 0.0v 1469.505n 0.0v 1479.495n 0.0v 1479.505n 0.0v 1489.495n 0.0v 1489.505n 0.0v 1499.495n 0.0v 1499.505n 0.0v 1509.495n 0.0v 1509.505n 0.0v 1519.495n 0.0v 1519.505n 0.0v 1529.495n 0.0v 1529.505n 0.0v 1539.495n 0.0v 1539.505n 0.0v 1549.495n 0.0v 1549.505n 0.0v 1559.495n 0.0v 1559.505n 0.0v 1569.495n 0.0v 1569.505n 0.0v 1579.495n 0.0v 1579.505n 0.0v 1589.495n 0.0v 1589.505n 0.0v 1599.495n 0.0v 1599.505n 0.0v 1609.495n 0.0v 1609.505n 0.0v 1619.495n 0.0v 1619.505n 0.0v 1629.495n 0.0v 1629.505n 0.0v 1639.495n 0.0v 1639.505n 0.0v 1649.495n 0.0v 1649.505n 0.0v 1659.495n 0.0v 1659.505n 3.3v 1669.495n 3.3v 1669.505n 3.3v 1679.495n 3.3v 1679.505n 3.3v 1689.495n 3.3v 1689.505n 3.3v 1699.495n 3.3v 1699.505n 3.3v 1709.495n 3.3v 1709.505n 3.3v 1719.495n 3.3v 1719.505n 3.3v 1729.495n 3.3v 1729.505n 3.3v 1739.495n 3.3v 1739.505n 3.3v 1749.495n 3.3v 1749.505n 3.3v 1759.495n 3.3v 1759.505n 3.3v 1769.495n 3.3v 1769.505n 3.3v 1779.495n 3.3v 1779.505n 3.3v 1789.495n 3.3v 1789.505n 3.3v 1799.495n 3.3v 1799.505n 3.3v 1809.495n 3.3v 1809.505n 3.3v 1819.495n 3.3v 1819.505n 0.0v 1829.495n 0.0v 1829.505n 0.0v 1839.495n 0.0v 1839.505n 0.0v 1849.495n 0.0v 1849.505n 0.0v 1859.495n 0.0v 1859.505n 0.0v 1869.495n 0.0v 1869.505n 0.0v 1879.495n 0.0v 1879.505n 0.0v 1889.495n 0.0v 1889.505n 0.0v 1899.495n 0.0v 1899.505n 3.3v 1909.495n 3.3v 1909.505n 3.3v 1919.495n 3.3v 1919.505n 3.3v 1929.495n 3.3v 1929.505n 3.3v 1939.495n 3.3v 1939.505n 3.3v 1949.495n 3.3v 1949.505n 3.3v 1959.495n 3.3v 1959.505n 3.3v 1969.495n 3.3v 1969.505n 3.3v 1979.495n 3.3v 1979.505n 3.3v 1989.495n 3.3v 1989.505n 0.0v 1999.495n 0.0v 1999.505n 0.0v 2009.495n 0.0v 2009.505n 0.0v 2019.495n 0.0v 2019.505n 0.0v 2029.495n 0.0v 2029.505n 0.0v 2039.495n 0.0v 2039.505n 0.0v 2049.495n 0.0v 2049.505n 0.0v )
* (time, data): [(0, 0), (10, 0), (20, 0), (30, 0), (40, 0), (50, 0), (60, 0), (70, 0), (80, 0), (90, 0), (100, 1), (110, 1), (120, 1), (130, 1), (140, 1), (150, 1), (160, 0), (170, 0), (180, 0), (190, 0), (200, 0), (210, 0), (220, 1), (230, 1), (240, 1), (250, 1), (260, 0), (270, 0), (280, 1), (290, 1), (300, 1), (310, 1), (320, 1), (330, 1), (340, 0), (350, 0), (360, 0), (370, 0), (380, 0), (390, 0), (400, 0), (410, 0), (420, 0), (430, 1), (440, 1), (450, 1), (460, 1), (470, 1), (480, 1), (490, 1), (500, 1), (510, 1), (520, 1), (530, 0), (540, 1), (550, 1), (560, 0), (570, 0), (580, 1), (590, 1), (600, 1), (610, 0), (620, 0), (630, 0), (640, 0), (650, 0), (660, 0), (670, 0), (680, 0), (690, 0), (700, 0), (710, 0), (720, 0), (730, 0), (740, 0), (750, 0), (760, 0), (770, 0), (780, 1), (790, 0), (800, 0), (810, 0), (820, 0), (830, 0), (840, 0), (850, 1), (860, 1), (870, 1), (880, 1), (890, 1), (900, 1), (910, 1), (920, 1), (930, 1), (940, 1), (950, 1), (960, 1), (970, 1), (980, 1), (990, 0), (1000, 1), (1010, 1), (1020, 0), (1030, 0), (1040, 0), (1050, 1), (1060, 1), (1070, 1), (1080, 1), (1090, 1), (1100, 1), (1110, 1), (1120, 1), (1130, 1), (1140, 1), (1150, 0), (1160, 0), (1170, 0), (1180, 0), (1190, 0), (1200, 0), (1210, 0), (1220, 0), (1230, 0), (1240, 1), (1250, 1), (1260, 1), (1270, 1), (1280, 1), (1290, 0), (1300, 0), (1310, 0), (1320, 0), (1330, 0), (1340, 0), (1350, 0), (1360, 1), (1370, 1), (1380, 1), (1390, 1), (1400, 1), (1410, 1), (1420, 1), (1430, 1), (1440, 1), (1450, 1), (1460, 0), (1470, 0), (1480, 0), (1490, 0), (1500, 0), (1510, 0), (1520, 0), (1530, 0), (1540, 0), (1550, 0), (1560, 0), (1570, 0), (1580, 0), (1590, 0), (1600, 0), (1610, 0), (1620, 0), (1630, 0), (1640, 0), (1650, 0), (1660, 1), (1670, 1), (1680, 1), (1690, 1), (1700, 1), (1710, 1), (1720, 1), (1730, 1), (1740, 1), (1750, 1), (1760, 1), (1770, 1), (1780, 1), (1790, 0), (1800, 0), (1810, 0), (1820, 1), (1830, 1), (1840, 1), (1850, 0), (1860, 0), (1870, 0), (1880, 1), (1890, 1), (1900, 0), (1910, 0), (1920, 0), (1930, 0), (1940, 0), (1950, 0), (1960, 1), (1970, 1), (1980, 1), (1990, 1), (2000, 1), (2010, 1), (2020, 1), (2030, 1), (2040, 1), (2050, 1)]
Vdin0_6  din0_6  0 PWL (0n 0.0v 9.495n 0.0v 9.505n 0.0v 19.495n 0.0v 19.505n 0.0v 29.495n 0.0v 29.505n 0.0v 39.495n 0.0v 39.505n 0.0v 49.495n 0.0v 49.505n 0.0v 59.495n 0.0v 59.505n 0.0v 69.495n 0.0v 69.505n 0.0v 79.495n 0.0v 79.505n 0.0v 89.495n 0.0v 89.505n 0.0v 99.495n 0.0v 99.505n 3.3v 109.495n 3.3v 109.505n 3.3v 119.495n 3.3v 119.505n 3.3v 129.495n 3.3v 129.505n 3.3v 139.495n 3.3v 139.505n 3.3v 149.495n 3.3v 149.505n 3.3v 159.495n 3.3v 159.505n 0.0v 169.495n 0.0v 169.505n 0.0v 179.495n 0.0v 179.505n 0.0v 189.495n 0.0v 189.505n 0.0v 199.495n 0.0v 199.505n 0.0v 209.495n 0.0v 209.505n 0.0v 219.495n 0.0v 219.505n 3.3v 229.495n 3.3v 229.505n 3.3v 239.495n 3.3v 239.505n 3.3v 249.495n 3.3v 249.505n 3.3v 259.495n 3.3v 259.505n 0.0v 269.495n 0.0v 269.505n 0.0v 279.495n 0.0v 279.505n 3.3v 289.495n 3.3v 289.505n 3.3v 299.495n 3.3v 299.505n 3.3v 309.495n 3.3v 309.505n 3.3v 319.495n 3.3v 319.505n 3.3v 329.495n 3.3v 329.505n 3.3v 339.495n 3.3v 339.505n 0.0v 349.495n 0.0v 349.505n 0.0v 359.495n 0.0v 359.505n 0.0v 369.495n 0.0v 369.505n 0.0v 379.495n 0.0v 379.505n 0.0v 389.495n 0.0v 389.505n 0.0v 399.495n 0.0v 399.505n 0.0v 409.495n 0.0v 409.505n 0.0v 419.495n 0.0v 419.505n 0.0v 429.495n 0.0v 429.505n 3.3v 439.495n 3.3v 439.505n 3.3v 449.495n 3.3v 449.505n 3.3v 459.495n 3.3v 459.505n 3.3v 469.495n 3.3v 469.505n 3.3v 479.495n 3.3v 479.505n 3.3v 489.495n 3.3v 489.505n 3.3v 499.495n 3.3v 499.505n 3.3v 509.495n 3.3v 509.505n 3.3v 519.495n 3.3v 519.505n 3.3v 529.495n 3.3v 529.505n 0.0v 539.495n 0.0v 539.505n 3.3v 549.495n 3.3v 549.505n 3.3v 559.495n 3.3v 559.505n 0.0v 569.495n 0.0v 569.505n 0.0v 579.495n 0.0v 579.505n 3.3v 589.495n 3.3v 589.505n 3.3v 599.495n 3.3v 599.505n 3.3v 609.495n 3.3v 609.505n 0.0v 619.495n 0.0v 619.505n 0.0v 629.495n 0.0v 629.505n 0.0v 639.495n 0.0v 639.505n 0.0v 649.495n 0.0v 649.505n 0.0v 659.495n 0.0v 659.505n 0.0v 669.495n 0.0v 669.505n 0.0v 679.495n 0.0v 679.505n 0.0v 689.495n 0.0v 689.505n 0.0v 699.495n 0.0v 699.505n 0.0v 709.495n 0.0v 709.505n 0.0v 719.495n 0.0v 719.505n 0.0v 729.495n 0.0v 729.505n 0.0v 739.495n 0.0v 739.505n 0.0v 749.495n 0.0v 749.505n 0.0v 759.495n 0.0v 759.505n 0.0v 769.495n 0.0v 769.505n 0.0v 779.495n 0.0v 779.505n 3.3v 789.495n 3.3v 789.505n 0.0v 799.495n 0.0v 799.505n 0.0v 809.495n 0.0v 809.505n 0.0v 819.495n 0.0v 819.505n 0.0v 829.495n 0.0v 829.505n 0.0v 839.495n 0.0v 839.505n 0.0v 849.495n 0.0v 849.505n 3.3v 859.495n 3.3v 859.505n 3.3v 869.495n 3.3v 869.505n 3.3v 879.495n 3.3v 879.505n 3.3v 889.495n 3.3v 889.505n 3.3v 899.495n 3.3v 899.505n 3.3v 909.495n 3.3v 909.505n 3.3v 919.495n 3.3v 919.505n 3.3v 929.495n 3.3v 929.505n 3.3v 939.495n 3.3v 939.505n 3.3v 949.495n 3.3v 949.505n 3.3v 959.495n 3.3v 959.505n 3.3v 969.495n 3.3v 969.505n 3.3v 979.495n 3.3v 979.505n 3.3v 989.495n 3.3v 989.505n 0.0v 999.495n 0.0v 999.505n 3.3v 1009.495n 3.3v 1009.505n 3.3v 1019.495n 3.3v 1019.505n 0.0v 1029.495n 0.0v 1029.505n 0.0v 1039.495n 0.0v 1039.505n 0.0v 1049.495n 0.0v 1049.505n 3.3v 1059.495n 3.3v 1059.505n 3.3v 1069.495n 3.3v 1069.505n 3.3v 1079.495n 3.3v 1079.505n 3.3v 1089.495n 3.3v 1089.505n 3.3v 1099.495n 3.3v 1099.505n 3.3v 1109.495n 3.3v 1109.505n 3.3v 1119.495n 3.3v 1119.505n 3.3v 1129.495n 3.3v 1129.505n 3.3v 1139.495n 3.3v 1139.505n 3.3v 1149.495n 3.3v 1149.505n 0.0v 1159.495n 0.0v 1159.505n 0.0v 1169.495n 0.0v 1169.505n 0.0v 1179.495n 0.0v 1179.505n 0.0v 1189.495n 0.0v 1189.505n 0.0v 1199.495n 0.0v 1199.505n 0.0v 1209.495n 0.0v 1209.505n 0.0v 1219.495n 0.0v 1219.505n 0.0v 1229.495n 0.0v 1229.505n 0.0v 1239.495n 0.0v 1239.505n 3.3v 1249.495n 3.3v 1249.505n 3.3v 1259.495n 3.3v 1259.505n 3.3v 1269.495n 3.3v 1269.505n 3.3v 1279.495n 3.3v 1279.505n 3.3v 1289.495n 3.3v 1289.505n 0.0v 1299.495n 0.0v 1299.505n 0.0v 1309.495n 0.0v 1309.505n 0.0v 1319.495n 0.0v 1319.505n 0.0v 1329.495n 0.0v 1329.505n 0.0v 1339.495n 0.0v 1339.505n 0.0v 1349.495n 0.0v 1349.505n 0.0v 1359.495n 0.0v 1359.505n 3.3v 1369.495n 3.3v 1369.505n 3.3v 1379.495n 3.3v 1379.505n 3.3v 1389.495n 3.3v 1389.505n 3.3v 1399.495n 3.3v 1399.505n 3.3v 1409.495n 3.3v 1409.505n 3.3v 1419.495n 3.3v 1419.505n 3.3v 1429.495n 3.3v 1429.505n 3.3v 1439.495n 3.3v 1439.505n 3.3v 1449.495n 3.3v 1449.505n 3.3v 1459.495n 3.3v 1459.505n 0.0v 1469.495n 0.0v 1469.505n 0.0v 1479.495n 0.0v 1479.505n 0.0v 1489.495n 0.0v 1489.505n 0.0v 1499.495n 0.0v 1499.505n 0.0v 1509.495n 0.0v 1509.505n 0.0v 1519.495n 0.0v 1519.505n 0.0v 1529.495n 0.0v 1529.505n 0.0v 1539.495n 0.0v 1539.505n 0.0v 1549.495n 0.0v 1549.505n 0.0v 1559.495n 0.0v 1559.505n 0.0v 1569.495n 0.0v 1569.505n 0.0v 1579.495n 0.0v 1579.505n 0.0v 1589.495n 0.0v 1589.505n 0.0v 1599.495n 0.0v 1599.505n 0.0v 1609.495n 0.0v 1609.505n 0.0v 1619.495n 0.0v 1619.505n 0.0v 1629.495n 0.0v 1629.505n 0.0v 1639.495n 0.0v 1639.505n 0.0v 1649.495n 0.0v 1649.505n 0.0v 1659.495n 0.0v 1659.505n 3.3v 1669.495n 3.3v 1669.505n 3.3v 1679.495n 3.3v 1679.505n 3.3v 1689.495n 3.3v 1689.505n 3.3v 1699.495n 3.3v 1699.505n 3.3v 1709.495n 3.3v 1709.505n 3.3v 1719.495n 3.3v 1719.505n 3.3v 1729.495n 3.3v 1729.505n 3.3v 1739.495n 3.3v 1739.505n 3.3v 1749.495n 3.3v 1749.505n 3.3v 1759.495n 3.3v 1759.505n 3.3v 1769.495n 3.3v 1769.505n 3.3v 1779.495n 3.3v 1779.505n 3.3v 1789.495n 3.3v 1789.505n 0.0v 1799.495n 0.0v 1799.505n 0.0v 1809.495n 0.0v 1809.505n 0.0v 1819.495n 0.0v 1819.505n 3.3v 1829.495n 3.3v 1829.505n 3.3v 1839.495n 3.3v 1839.505n 3.3v 1849.495n 3.3v 1849.505n 0.0v 1859.495n 0.0v 1859.505n 0.0v 1869.495n 0.0v 1869.505n 0.0v 1879.495n 0.0v 1879.505n 3.3v 1889.495n 3.3v 1889.505n 3.3v 1899.495n 3.3v 1899.505n 0.0v 1909.495n 0.0v 1909.505n 0.0v 1919.495n 0.0v 1919.505n 0.0v 1929.495n 0.0v 1929.505n 0.0v 1939.495n 0.0v 1939.505n 0.0v 1949.495n 0.0v 1949.505n 0.0v 1959.495n 0.0v 1959.505n 3.3v 1969.495n 3.3v 1969.505n 3.3v 1979.495n 3.3v 1979.505n 3.3v 1989.495n 3.3v 1989.505n 3.3v 1999.495n 3.3v 1999.505n 3.3v 2009.495n 3.3v 2009.505n 3.3v 2019.495n 3.3v 2019.505n 3.3v 2029.495n 3.3v 2029.505n 3.3v 2039.495n 3.3v 2039.505n 3.3v 2049.495n 3.3v 2049.505n 3.3v )
* (time, data): [(0, 0), (10, 0), (20, 1), (30, 1), (40, 1), (50, 1), (60, 1), (70, 1), (80, 1), (90, 1), (100, 1), (110, 1), (120, 1), (130, 1), (140, 1), (150, 1), (160, 0), (170, 0), (180, 0), (190, 0), (200, 0), (210, 0), (220, 0), (230, 0), (240, 0), (250, 0), (260, 0), (270, 0), (280, 0), (290, 1), (300, 1), (310, 1), (320, 1), (330, 0), (340, 0), (350, 0), (360, 0), (370, 0), (380, 0), (390, 0), (400, 0), (410, 0), (420, 0), (430, 1), (440, 1), (450, 1), (460, 0), (470, 1), (480, 1), (490, 1), (500, 1), (510, 1), (520, 1), (530, 0), (540, 1), (550, 1), (560, 0), (570, 0), (580, 1), (590, 1), (600, 1), (610, 1), (620, 1), (630, 1), (640, 1), (650, 1), (660, 1), (670, 1), (680, 1), (690, 1), (700, 1), (710, 1), (720, 1), (730, 1), (740, 1), (750, 1), (760, 1), (770, 1), (780, 1), (790, 1), (800, 1), (810, 1), (820, 1), (830, 1), (840, 1), (850, 1), (860, 1), (870, 1), (880, 1), (890, 1), (900, 1), (910, 1), (920, 1), (930, 1), (940, 1), (950, 1), (960, 1), (970, 1), (980, 1), (990, 1), (1000, 0), (1010, 0), (1020, 0), (1030, 0), (1040, 0), (1050, 0), (1060, 0), (1070, 1), (1080, 1), (1090, 1), (1100, 1), (1110, 1), (1120, 1), (1130, 1), (1140, 1), (1150, 1), (1160, 1), (1170, 1), (1180, 1), (1190, 1), (1200, 1), (1210, 1), (1220, 1), (1230, 1), (1240, 0), (1250, 0), (1260, 0), (1270, 0), (1280, 1), (1290, 1), (1300, 1), (1310, 1), (1320, 1), (1330, 1), (1340, 0), (1350, 0), (1360, 1), (1370, 1), (1380, 1), (1390, 1), (1400, 1), (1410, 1), (1420, 1), (1430, 1), (1440, 1), (1450, 1), (1460, 1), (1470, 1), (1480, 1), (1490, 1), (1500, 1), (1510, 1), (1520, 1), (1530, 1), (1540, 1), (1550, 1), (1560, 1), (1570, 1), (1580, 1), (1590, 1), (1600, 1), (1610, 1), (1620, 1), (1630, 1), (1640, 1), (1650, 1), (1660, 0), (1670, 0), (1680, 0), (1690, 0), (1700, 0), (1710, 0), (1720, 0), (1730, 0), (1740, 0), (1750, 0), (1760, 0), (1770, 0), (1780, 0), (1790, 1), (1800, 1), (1810, 1), (1820, 0), (1830, 0), (1840, 0), (1850, 0), (1860, 0), (1870, 0), (1880, 0), (1890, 0), (1900, 0), (1910, 0), (1920, 0), (1930, 0), (1940, 0), (1950, 0), (1960, 1), (1970, 1), (1980, 1), (1990, 0), (2000, 0), (2010, 0), (2020, 0), (2030, 0), (2040, 0), (2050, 0)]
Vdin0_7  din0_7  0 PWL (0n 0.0v 9.495n 0.0v 9.505n 0.0v 19.495n 0.0v 19.505n 3.3v 29.495n 3.3v 29.505n 3.3v 39.495n 3.3v 39.505n 3.3v 49.495n 3.3v 49.505n 3.3v 59.495n 3.3v 59.505n 3.3v 69.495n 3.3v 69.505n 3.3v 79.495n 3.3v 79.505n 3.3v 89.495n 3.3v 89.505n 3.3v 99.495n 3.3v 99.505n 3.3v 109.495n 3.3v 109.505n 3.3v 119.495n 3.3v 119.505n 3.3v 129.495n 3.3v 129.505n 3.3v 139.495n 3.3v 139.505n 3.3v 149.495n 3.3v 149.505n 3.3v 159.495n 3.3v 159.505n 0.0v 169.495n 0.0v 169.505n 0.0v 179.495n 0.0v 179.505n 0.0v 189.495n 0.0v 189.505n 0.0v 199.495n 0.0v 199.505n 0.0v 209.495n 0.0v 209.505n 0.0v 219.495n 0.0v 219.505n 0.0v 229.495n 0.0v 229.505n 0.0v 239.495n 0.0v 239.505n 0.0v 249.495n 0.0v 249.505n 0.0v 259.495n 0.0v 259.505n 0.0v 269.495n 0.0v 269.505n 0.0v 279.495n 0.0v 279.505n 0.0v 289.495n 0.0v 289.505n 3.3v 299.495n 3.3v 299.505n 3.3v 309.495n 3.3v 309.505n 3.3v 319.495n 3.3v 319.505n 3.3v 329.495n 3.3v 329.505n 0.0v 339.495n 0.0v 339.505n 0.0v 349.495n 0.0v 349.505n 0.0v 359.495n 0.0v 359.505n 0.0v 369.495n 0.0v 369.505n 0.0v 379.495n 0.0v 379.505n 0.0v 389.495n 0.0v 389.505n 0.0v 399.495n 0.0v 399.505n 0.0v 409.495n 0.0v 409.505n 0.0v 419.495n 0.0v 419.505n 0.0v 429.495n 0.0v 429.505n 3.3v 439.495n 3.3v 439.505n 3.3v 449.495n 3.3v 449.505n 3.3v 459.495n 3.3v 459.505n 0.0v 469.495n 0.0v 469.505n 3.3v 479.495n 3.3v 479.505n 3.3v 489.495n 3.3v 489.505n 3.3v 499.495n 3.3v 499.505n 3.3v 509.495n 3.3v 509.505n 3.3v 519.495n 3.3v 519.505n 3.3v 529.495n 3.3v 529.505n 0.0v 539.495n 0.0v 539.505n 3.3v 549.495n 3.3v 549.505n 3.3v 559.495n 3.3v 559.505n 0.0v 569.495n 0.0v 569.505n 0.0v 579.495n 0.0v 579.505n 3.3v 589.495n 3.3v 589.505n 3.3v 599.495n 3.3v 599.505n 3.3v 609.495n 3.3v 609.505n 3.3v 619.495n 3.3v 619.505n 3.3v 629.495n 3.3v 629.505n 3.3v 639.495n 3.3v 639.505n 3.3v 649.495n 3.3v 649.505n 3.3v 659.495n 3.3v 659.505n 3.3v 669.495n 3.3v 669.505n 3.3v 679.495n 3.3v 679.505n 3.3v 689.495n 3.3v 689.505n 3.3v 699.495n 3.3v 699.505n 3.3v 709.495n 3.3v 709.505n 3.3v 719.495n 3.3v 719.505n 3.3v 729.495n 3.3v 729.505n 3.3v 739.495n 3.3v 739.505n 3.3v 749.495n 3.3v 749.505n 3.3v 759.495n 3.3v 759.505n 3.3v 769.495n 3.3v 769.505n 3.3v 779.495n 3.3v 779.505n 3.3v 789.495n 3.3v 789.505n 3.3v 799.495n 3.3v 799.505n 3.3v 809.495n 3.3v 809.505n 3.3v 819.495n 3.3v 819.505n 3.3v 829.495n 3.3v 829.505n 3.3v 839.495n 3.3v 839.505n 3.3v 849.495n 3.3v 849.505n 3.3v 859.495n 3.3v 859.505n 3.3v 869.495n 3.3v 869.505n 3.3v 879.495n 3.3v 879.505n 3.3v 889.495n 3.3v 889.505n 3.3v 899.495n 3.3v 899.505n 3.3v 909.495n 3.3v 909.505n 3.3v 919.495n 3.3v 919.505n 3.3v 929.495n 3.3v 929.505n 3.3v 939.495n 3.3v 939.505n 3.3v 949.495n 3.3v 949.505n 3.3v 959.495n 3.3v 959.505n 3.3v 969.495n 3.3v 969.505n 3.3v 979.495n 3.3v 979.505n 3.3v 989.495n 3.3v 989.505n 3.3v 999.495n 3.3v 999.505n 0.0v 1009.495n 0.0v 1009.505n 0.0v 1019.495n 0.0v 1019.505n 0.0v 1029.495n 0.0v 1029.505n 0.0v 1039.495n 0.0v 1039.505n 0.0v 1049.495n 0.0v 1049.505n 0.0v 1059.495n 0.0v 1059.505n 0.0v 1069.495n 0.0v 1069.505n 3.3v 1079.495n 3.3v 1079.505n 3.3v 1089.495n 3.3v 1089.505n 3.3v 1099.495n 3.3v 1099.505n 3.3v 1109.495n 3.3v 1109.505n 3.3v 1119.495n 3.3v 1119.505n 3.3v 1129.495n 3.3v 1129.505n 3.3v 1139.495n 3.3v 1139.505n 3.3v 1149.495n 3.3v 1149.505n 3.3v 1159.495n 3.3v 1159.505n 3.3v 1169.495n 3.3v 1169.505n 3.3v 1179.495n 3.3v 1179.505n 3.3v 1189.495n 3.3v 1189.505n 3.3v 1199.495n 3.3v 1199.505n 3.3v 1209.495n 3.3v 1209.505n 3.3v 1219.495n 3.3v 1219.505n 3.3v 1229.495n 3.3v 1229.505n 3.3v 1239.495n 3.3v 1239.505n 0.0v 1249.495n 0.0v 1249.505n 0.0v 1259.495n 0.0v 1259.505n 0.0v 1269.495n 0.0v 1269.505n 0.0v 1279.495n 0.0v 1279.505n 3.3v 1289.495n 3.3v 1289.505n 3.3v 1299.495n 3.3v 1299.505n 3.3v 1309.495n 3.3v 1309.505n 3.3v 1319.495n 3.3v 1319.505n 3.3v 1329.495n 3.3v 1329.505n 3.3v 1339.495n 3.3v 1339.505n 0.0v 1349.495n 0.0v 1349.505n 0.0v 1359.495n 0.0v 1359.505n 3.3v 1369.495n 3.3v 1369.505n 3.3v 1379.495n 3.3v 1379.505n 3.3v 1389.495n 3.3v 1389.505n 3.3v 1399.495n 3.3v 1399.505n 3.3v 1409.495n 3.3v 1409.505n 3.3v 1419.495n 3.3v 1419.505n 3.3v 1429.495n 3.3v 1429.505n 3.3v 1439.495n 3.3v 1439.505n 3.3v 1449.495n 3.3v 1449.505n 3.3v 1459.495n 3.3v 1459.505n 3.3v 1469.495n 3.3v 1469.505n 3.3v 1479.495n 3.3v 1479.505n 3.3v 1489.495n 3.3v 1489.505n 3.3v 1499.495n 3.3v 1499.505n 3.3v 1509.495n 3.3v 1509.505n 3.3v 1519.495n 3.3v 1519.505n 3.3v 1529.495n 3.3v 1529.505n 3.3v 1539.495n 3.3v 1539.505n 3.3v 1549.495n 3.3v 1549.505n 3.3v 1559.495n 3.3v 1559.505n 3.3v 1569.495n 3.3v 1569.505n 3.3v 1579.495n 3.3v 1579.505n 3.3v 1589.495n 3.3v 1589.505n 3.3v 1599.495n 3.3v 1599.505n 3.3v 1609.495n 3.3v 1609.505n 3.3v 1619.495n 3.3v 1619.505n 3.3v 1629.495n 3.3v 1629.505n 3.3v 1639.495n 3.3v 1639.505n 3.3v 1649.495n 3.3v 1649.505n 3.3v 1659.495n 3.3v 1659.505n 0.0v 1669.495n 0.0v 1669.505n 0.0v 1679.495n 0.0v 1679.505n 0.0v 1689.495n 0.0v 1689.505n 0.0v 1699.495n 0.0v 1699.505n 0.0v 1709.495n 0.0v 1709.505n 0.0v 1719.495n 0.0v 1719.505n 0.0v 1729.495n 0.0v 1729.505n 0.0v 1739.495n 0.0v 1739.505n 0.0v 1749.495n 0.0v 1749.505n 0.0v 1759.495n 0.0v 1759.505n 0.0v 1769.495n 0.0v 1769.505n 0.0v 1779.495n 0.0v 1779.505n 0.0v 1789.495n 0.0v 1789.505n 3.3v 1799.495n 3.3v 1799.505n 3.3v 1809.495n 3.3v 1809.505n 3.3v 1819.495n 3.3v 1819.505n 0.0v 1829.495n 0.0v 1829.505n 0.0v 1839.495n 0.0v 1839.505n 0.0v 1849.495n 0.0v 1849.505n 0.0v 1859.495n 0.0v 1859.505n 0.0v 1869.495n 0.0v 1869.505n 0.0v 1879.495n 0.0v 1879.505n 0.0v 1889.495n 0.0v 1889.505n 0.0v 1899.495n 0.0v 1899.505n 0.0v 1909.495n 0.0v 1909.505n 0.0v 1919.495n 0.0v 1919.505n 0.0v 1929.495n 0.0v 1929.505n 0.0v 1939.495n 0.0v 1939.505n 0.0v 1949.495n 0.0v 1949.505n 0.0v 1959.495n 0.0v 1959.505n 3.3v 1969.495n 3.3v 1969.505n 3.3v 1979.495n 3.3v 1979.505n 3.3v 1989.495n 3.3v 1989.505n 0.0v 1999.495n 0.0v 1999.505n 0.0v 2009.495n 0.0v 2009.505n 0.0v 2019.495n 0.0v 2019.505n 0.0v 2029.495n 0.0v 2029.505n 0.0v 2039.495n 0.0v 2039.505n 0.0v 2049.495n 0.0v 2049.505n 0.0v )
* (time, data): [(0, 0), (10, 0), (20, 0), (30, 0), (40, 0), (50, 0), (60, 1), (70, 1), (80, 1), (90, 1), (100, 0), (110, 0), (120, 0), (130, 0), (140, 0), (150, 0), (160, 0), (170, 0), (180, 0), (190, 0), (200, 0), (210, 0), (220, 1), (230, 1), (240, 1), (250, 1), (260, 0), (270, 0), (280, 0), (290, 1), (300, 1), (310, 0), (320, 0), (330, 0), (340, 1), (350, 1), (360, 1), (370, 1), (380, 1), (390, 0), (400, 0), (410, 0), (420, 0), (430, 0), (440, 0), (450, 0), (460, 1), (470, 0), (480, 0), (490, 0), (500, 0), (510, 0), (520, 0), (530, 1), (540, 1), (550, 1), (560, 0), (570, 0), (580, 0), (590, 0), (600, 0), (610, 0), (620, 0), (630, 0), (640, 0), (650, 0), (660, 0), (670, 0), (680, 0), (690, 0), (700, 0), (710, 1), (720, 1), (730, 1), (740, 1), (750, 1), (760, 1), (770, 1), (780, 0), (790, 1), (800, 1), (810, 1), (820, 1), (830, 1), (840, 1), (850, 0), (860, 0), (870, 0), (880, 0), (890, 0), (900, 0), (910, 0), (920, 0), (930, 0), (940, 0), (950, 0), (960, 0), (970, 0), (980, 0), (990, 0), (1000, 1), (1010, 0), (1020, 0), (1030, 0), (1040, 0), (1050, 1), (1060, 1), (1070, 0), (1080, 0), (1090, 0), (1100, 0), (1110, 0), (1120, 0), (1130, 0), (1140, 0), (1150, 1), (1160, 1), (1170, 1), (1180, 1), (1190, 1), (1200, 1), (1210, 1), (1220, 1), (1230, 1), (1240, 0), (1250, 0), (1260, 0), (1270, 0), (1280, 0), (1290, 0), (1300, 0), (1310, 0), (1320, 0), (1330, 0), (1340, 1), (1350, 1), (1360, 0), (1370, 1), (1380, 1), (1390, 1), (1400, 1), (1410, 1), (1420, 1), (1430, 1), (1440, 1), (1450, 1), (1460, 1), (1470, 1), (1480, 1), (1490, 1), (1500, 1), (1510, 1), (1520, 1), (1530, 1), (1540, 1), (1550, 1), (1560, 1), (1570, 1), (1580, 1), (1590, 1), (1600, 1), (1610, 1), (1620, 1), (1630, 1), (1640, 1), (1650, 1), (1660, 0), (1670, 0), (1680, 0), (1690, 0), (1700, 0), (1710, 0), (1720, 0), (1730, 0), (1740, 0), (1750, 0), (1760, 0), (1770, 0), (1780, 0), (1790, 0), (1800, 0), (1810, 0), (1820, 1), (1830, 1), (1840, 1), (1850, 0), (1860, 0), (1870, 0), (1880, 1), (1890, 1), (1900, 0), (1910, 0), (1920, 0), (1930, 0), (1940, 0), (1950, 0), (1960, 1), (1970, 1), (1980, 1), (1990, 0), (2000, 0), (2010, 0), (2020, 0), (2030, 0), (2040, 0), (2050, 0)]
Vdin0_8  din0_8  0 PWL (0n 0.0v 9.495n 0.0v 9.505n 0.0v 19.495n 0.0v 19.505n 0.0v 29.495n 0.0v 29.505n 0.0v 39.495n 0.0v 39.505n 0.0v 49.495n 0.0v 49.505n 0.0v 59.495n 0.0v 59.505n 3.3v 69.495n 3.3v 69.505n 3.3v 79.495n 3.3v 79.505n 3.3v 89.495n 3.3v 89.505n 3.3v 99.495n 3.3v 99.505n 0.0v 109.495n 0.0v 109.505n 0.0v 119.495n 0.0v 119.505n 0.0v 129.495n 0.0v 129.505n 0.0v 139.495n 0.0v 139.505n 0.0v 149.495n 0.0v 149.505n 0.0v 159.495n 0.0v 159.505n 0.0v 169.495n 0.0v 169.505n 0.0v 179.495n 0.0v 179.505n 0.0v 189.495n 0.0v 189.505n 0.0v 199.495n 0.0v 199.505n 0.0v 209.495n 0.0v 209.505n 0.0v 219.495n 0.0v 219.505n 3.3v 229.495n 3.3v 229.505n 3.3v 239.495n 3.3v 239.505n 3.3v 249.495n 3.3v 249.505n 3.3v 259.495n 3.3v 259.505n 0.0v 269.495n 0.0v 269.505n 0.0v 279.495n 0.0v 279.505n 0.0v 289.495n 0.0v 289.505n 3.3v 299.495n 3.3v 299.505n 3.3v 309.495n 3.3v 309.505n 0.0v 319.495n 0.0v 319.505n 0.0v 329.495n 0.0v 329.505n 0.0v 339.495n 0.0v 339.505n 3.3v 349.495n 3.3v 349.505n 3.3v 359.495n 3.3v 359.505n 3.3v 369.495n 3.3v 369.505n 3.3v 379.495n 3.3v 379.505n 3.3v 389.495n 3.3v 389.505n 0.0v 399.495n 0.0v 399.505n 0.0v 409.495n 0.0v 409.505n 0.0v 419.495n 0.0v 419.505n 0.0v 429.495n 0.0v 429.505n 0.0v 439.495n 0.0v 439.505n 0.0v 449.495n 0.0v 449.505n 0.0v 459.495n 0.0v 459.505n 3.3v 469.495n 3.3v 469.505n 0.0v 479.495n 0.0v 479.505n 0.0v 489.495n 0.0v 489.505n 0.0v 499.495n 0.0v 499.505n 0.0v 509.495n 0.0v 509.505n 0.0v 519.495n 0.0v 519.505n 0.0v 529.495n 0.0v 529.505n 3.3v 539.495n 3.3v 539.505n 3.3v 549.495n 3.3v 549.505n 3.3v 559.495n 3.3v 559.505n 0.0v 569.495n 0.0v 569.505n 0.0v 579.495n 0.0v 579.505n 0.0v 589.495n 0.0v 589.505n 0.0v 599.495n 0.0v 599.505n 0.0v 609.495n 0.0v 609.505n 0.0v 619.495n 0.0v 619.505n 0.0v 629.495n 0.0v 629.505n 0.0v 639.495n 0.0v 639.505n 0.0v 649.495n 0.0v 649.505n 0.0v 659.495n 0.0v 659.505n 0.0v 669.495n 0.0v 669.505n 0.0v 679.495n 0.0v 679.505n 0.0v 689.495n 0.0v 689.505n 0.0v 699.495n 0.0v 699.505n 0.0v 709.495n 0.0v 709.505n 3.3v 719.495n 3.3v 719.505n 3.3v 729.495n 3.3v 729.505n 3.3v 739.495n 3.3v 739.505n 3.3v 749.495n 3.3v 749.505n 3.3v 759.495n 3.3v 759.505n 3.3v 769.495n 3.3v 769.505n 3.3v 779.495n 3.3v 779.505n 0.0v 789.495n 0.0v 789.505n 3.3v 799.495n 3.3v 799.505n 3.3v 809.495n 3.3v 809.505n 3.3v 819.495n 3.3v 819.505n 3.3v 829.495n 3.3v 829.505n 3.3v 839.495n 3.3v 839.505n 3.3v 849.495n 3.3v 849.505n 0.0v 859.495n 0.0v 859.505n 0.0v 869.495n 0.0v 869.505n 0.0v 879.495n 0.0v 879.505n 0.0v 889.495n 0.0v 889.505n 0.0v 899.495n 0.0v 899.505n 0.0v 909.495n 0.0v 909.505n 0.0v 919.495n 0.0v 919.505n 0.0v 929.495n 0.0v 929.505n 0.0v 939.495n 0.0v 939.505n 0.0v 949.495n 0.0v 949.505n 0.0v 959.495n 0.0v 959.505n 0.0v 969.495n 0.0v 969.505n 0.0v 979.495n 0.0v 979.505n 0.0v 989.495n 0.0v 989.505n 0.0v 999.495n 0.0v 999.505n 3.3v 1009.495n 3.3v 1009.505n 0.0v 1019.495n 0.0v 1019.505n 0.0v 1029.495n 0.0v 1029.505n 0.0v 1039.495n 0.0v 1039.505n 0.0v 1049.495n 0.0v 1049.505n 3.3v 1059.495n 3.3v 1059.505n 3.3v 1069.495n 3.3v 1069.505n 0.0v 1079.495n 0.0v 1079.505n 0.0v 1089.495n 0.0v 1089.505n 0.0v 1099.495n 0.0v 1099.505n 0.0v 1109.495n 0.0v 1109.505n 0.0v 1119.495n 0.0v 1119.505n 0.0v 1129.495n 0.0v 1129.505n 0.0v 1139.495n 0.0v 1139.505n 0.0v 1149.495n 0.0v 1149.505n 3.3v 1159.495n 3.3v 1159.505n 3.3v 1169.495n 3.3v 1169.505n 3.3v 1179.495n 3.3v 1179.505n 3.3v 1189.495n 3.3v 1189.505n 3.3v 1199.495n 3.3v 1199.505n 3.3v 1209.495n 3.3v 1209.505n 3.3v 1219.495n 3.3v 1219.505n 3.3v 1229.495n 3.3v 1229.505n 3.3v 1239.495n 3.3v 1239.505n 0.0v 1249.495n 0.0v 1249.505n 0.0v 1259.495n 0.0v 1259.505n 0.0v 1269.495n 0.0v 1269.505n 0.0v 1279.495n 0.0v 1279.505n 0.0v 1289.495n 0.0v 1289.505n 0.0v 1299.495n 0.0v 1299.505n 0.0v 1309.495n 0.0v 1309.505n 0.0v 1319.495n 0.0v 1319.505n 0.0v 1329.495n 0.0v 1329.505n 0.0v 1339.495n 0.0v 1339.505n 3.3v 1349.495n 3.3v 1349.505n 3.3v 1359.495n 3.3v 1359.505n 0.0v 1369.495n 0.0v 1369.505n 3.3v 1379.495n 3.3v 1379.505n 3.3v 1389.495n 3.3v 1389.505n 3.3v 1399.495n 3.3v 1399.505n 3.3v 1409.495n 3.3v 1409.505n 3.3v 1419.495n 3.3v 1419.505n 3.3v 1429.495n 3.3v 1429.505n 3.3v 1439.495n 3.3v 1439.505n 3.3v 1449.495n 3.3v 1449.505n 3.3v 1459.495n 3.3v 1459.505n 3.3v 1469.495n 3.3v 1469.505n 3.3v 1479.495n 3.3v 1479.505n 3.3v 1489.495n 3.3v 1489.505n 3.3v 1499.495n 3.3v 1499.505n 3.3v 1509.495n 3.3v 1509.505n 3.3v 1519.495n 3.3v 1519.505n 3.3v 1529.495n 3.3v 1529.505n 3.3v 1539.495n 3.3v 1539.505n 3.3v 1549.495n 3.3v 1549.505n 3.3v 1559.495n 3.3v 1559.505n 3.3v 1569.495n 3.3v 1569.505n 3.3v 1579.495n 3.3v 1579.505n 3.3v 1589.495n 3.3v 1589.505n 3.3v 1599.495n 3.3v 1599.505n 3.3v 1609.495n 3.3v 1609.505n 3.3v 1619.495n 3.3v 1619.505n 3.3v 1629.495n 3.3v 1629.505n 3.3v 1639.495n 3.3v 1639.505n 3.3v 1649.495n 3.3v 1649.505n 3.3v 1659.495n 3.3v 1659.505n 0.0v 1669.495n 0.0v 1669.505n 0.0v 1679.495n 0.0v 1679.505n 0.0v 1689.495n 0.0v 1689.505n 0.0v 1699.495n 0.0v 1699.505n 0.0v 1709.495n 0.0v 1709.505n 0.0v 1719.495n 0.0v 1719.505n 0.0v 1729.495n 0.0v 1729.505n 0.0v 1739.495n 0.0v 1739.505n 0.0v 1749.495n 0.0v 1749.505n 0.0v 1759.495n 0.0v 1759.505n 0.0v 1769.495n 0.0v 1769.505n 0.0v 1779.495n 0.0v 1779.505n 0.0v 1789.495n 0.0v 1789.505n 0.0v 1799.495n 0.0v 1799.505n 0.0v 1809.495n 0.0v 1809.505n 0.0v 1819.495n 0.0v 1819.505n 3.3v 1829.495n 3.3v 1829.505n 3.3v 1839.495n 3.3v 1839.505n 3.3v 1849.495n 3.3v 1849.505n 0.0v 1859.495n 0.0v 1859.505n 0.0v 1869.495n 0.0v 1869.505n 0.0v 1879.495n 0.0v 1879.505n 3.3v 1889.495n 3.3v 1889.505n 3.3v 1899.495n 3.3v 1899.505n 0.0v 1909.495n 0.0v 1909.505n 0.0v 1919.495n 0.0v 1919.505n 0.0v 1929.495n 0.0v 1929.505n 0.0v 1939.495n 0.0v 1939.505n 0.0v 1949.495n 0.0v 1949.505n 0.0v 1959.495n 0.0v 1959.505n 3.3v 1969.495n 3.3v 1969.505n 3.3v 1979.495n 3.3v 1979.505n 3.3v 1989.495n 3.3v 1989.505n 0.0v 1999.495n 0.0v 1999.505n 0.0v 2009.495n 0.0v 2009.505n 0.0v 2019.495n 0.0v 2019.505n 0.0v 2029.495n 0.0v 2029.505n 0.0v 2039.495n 0.0v 2039.505n 0.0v 2049.495n 0.0v 2049.505n 0.0v )
* (time, data): [(0, 0), (10, 1), (20, 0), (30, 0), (40, 0), (50, 0), (60, 1), (70, 1), (80, 1), (90, 1), (100, 0), (110, 0), (120, 0), (130, 0), (140, 0), (150, 0), (160, 1), (170, 1), (180, 1), (190, 1), (200, 1), (210, 1), (220, 0), (230, 0), (240, 0), (250, 0), (260, 1), (270, 1), (280, 1), (290, 1), (300, 1), (310, 1), (320, 1), (330, 1), (340, 1), (350, 1), (360, 1), (370, 1), (380, 1), (390, 0), (400, 0), (410, 0), (420, 0), (430, 0), (440, 0), (450, 0), (460, 0), (470, 1), (480, 1), (490, 1), (500, 1), (510, 1), (520, 1), (530, 1), (540, 1), (550, 1), (560, 0), (570, 0), (580, 0), (590, 0), (600, 0), (610, 0), (620, 0), (630, 0), (640, 0), (650, 0), (660, 0), (670, 0), (680, 0), (690, 0), (700, 0), (710, 1), (720, 1), (730, 1), (740, 1), (750, 1), (760, 1), (770, 1), (780, 0), (790, 1), (800, 1), (810, 1), (820, 1), (830, 1), (840, 1), (850, 1), (860, 1), (870, 1), (880, 1), (890, 1), (900, 1), (910, 1), (920, 1), (930, 1), (940, 1), (950, 1), (960, 1), (970, 1), (980, 1), (990, 1), (1000, 0), (1010, 1), (1020, 0), (1030, 0), (1040, 0), (1050, 0), (1060, 0), (1070, 0), (1080, 0), (1090, 0), (1100, 0), (1110, 0), (1120, 0), (1130, 0), (1140, 0), (1150, 0), (1160, 0), (1170, 0), (1180, 0), (1190, 0), (1200, 0), (1210, 0), (1220, 0), (1230, 0), (1240, 1), (1250, 1), (1260, 1), (1270, 1), (1280, 1), (1290, 0), (1300, 0), (1310, 0), (1320, 0), (1330, 0), (1340, 0), (1350, 0), (1360, 0), (1370, 0), (1380, 0), (1390, 0), (1400, 0), (1410, 0), (1420, 0), (1430, 0), (1440, 0), (1450, 0), (1460, 0), (1470, 0), (1480, 0), (1490, 0), (1500, 1), (1510, 1), (1520, 1), (1530, 1), (1540, 1), (1550, 1), (1560, 1), (1570, 1), (1580, 1), (1590, 1), (1600, 1), (1610, 1), (1620, 1), (1630, 1), (1640, 1), (1650, 1), (1660, 1), (1670, 1), (1680, 1), (1690, 1), (1700, 1), (1710, 0), (1720, 0), (1730, 0), (1740, 0), (1750, 0), (1760, 0), (1770, 0), (1780, 0), (1790, 1), (1800, 1), (1810, 1), (1820, 0), (1830, 0), (1840, 0), (1850, 0), (1860, 0), (1870, 0), (1880, 0), (1890, 0), (1900, 0), (1910, 0), (1920, 0), (1930, 0), (1940, 0), (1950, 0), (1960, 1), (1970, 1), (1980, 1), (1990, 0), (2000, 0), (2010, 0), (2020, 0), (2030, 0), (2040, 0), (2050, 0)]
Vdin0_9  din0_9  0 PWL (0n 0.0v 9.495n 0.0v 9.505n 3.3v 19.495n 3.3v 19.505n 0.0v 29.495n 0.0v 29.505n 0.0v 39.495n 0.0v 39.505n 0.0v 49.495n 0.0v 49.505n 0.0v 59.495n 0.0v 59.505n 3.3v 69.495n 3.3v 69.505n 3.3v 79.495n 3.3v 79.505n 3.3v 89.495n 3.3v 89.505n 3.3v 99.495n 3.3v 99.505n 0.0v 109.495n 0.0v 109.505n 0.0v 119.495n 0.0v 119.505n 0.0v 129.495n 0.0v 129.505n 0.0v 139.495n 0.0v 139.505n 0.0v 149.495n 0.0v 149.505n 0.0v 159.495n 0.0v 159.505n 3.3v 169.495n 3.3v 169.505n 3.3v 179.495n 3.3v 179.505n 3.3v 189.495n 3.3v 189.505n 3.3v 199.495n 3.3v 199.505n 3.3v 209.495n 3.3v 209.505n 3.3v 219.495n 3.3v 219.505n 0.0v 229.495n 0.0v 229.505n 0.0v 239.495n 0.0v 239.505n 0.0v 249.495n 0.0v 249.505n 0.0v 259.495n 0.0v 259.505n 3.3v 269.495n 3.3v 269.505n 3.3v 279.495n 3.3v 279.505n 3.3v 289.495n 3.3v 289.505n 3.3v 299.495n 3.3v 299.505n 3.3v 309.495n 3.3v 309.505n 3.3v 319.495n 3.3v 319.505n 3.3v 329.495n 3.3v 329.505n 3.3v 339.495n 3.3v 339.505n 3.3v 349.495n 3.3v 349.505n 3.3v 359.495n 3.3v 359.505n 3.3v 369.495n 3.3v 369.505n 3.3v 379.495n 3.3v 379.505n 3.3v 389.495n 3.3v 389.505n 0.0v 399.495n 0.0v 399.505n 0.0v 409.495n 0.0v 409.505n 0.0v 419.495n 0.0v 419.505n 0.0v 429.495n 0.0v 429.505n 0.0v 439.495n 0.0v 439.505n 0.0v 449.495n 0.0v 449.505n 0.0v 459.495n 0.0v 459.505n 0.0v 469.495n 0.0v 469.505n 3.3v 479.495n 3.3v 479.505n 3.3v 489.495n 3.3v 489.505n 3.3v 499.495n 3.3v 499.505n 3.3v 509.495n 3.3v 509.505n 3.3v 519.495n 3.3v 519.505n 3.3v 529.495n 3.3v 529.505n 3.3v 539.495n 3.3v 539.505n 3.3v 549.495n 3.3v 549.505n 3.3v 559.495n 3.3v 559.505n 0.0v 569.495n 0.0v 569.505n 0.0v 579.495n 0.0v 579.505n 0.0v 589.495n 0.0v 589.505n 0.0v 599.495n 0.0v 599.505n 0.0v 609.495n 0.0v 609.505n 0.0v 619.495n 0.0v 619.505n 0.0v 629.495n 0.0v 629.505n 0.0v 639.495n 0.0v 639.505n 0.0v 649.495n 0.0v 649.505n 0.0v 659.495n 0.0v 659.505n 0.0v 669.495n 0.0v 669.505n 0.0v 679.495n 0.0v 679.505n 0.0v 689.495n 0.0v 689.505n 0.0v 699.495n 0.0v 699.505n 0.0v 709.495n 0.0v 709.505n 3.3v 719.495n 3.3v 719.505n 3.3v 729.495n 3.3v 729.505n 3.3v 739.495n 3.3v 739.505n 3.3v 749.495n 3.3v 749.505n 3.3v 759.495n 3.3v 759.505n 3.3v 769.495n 3.3v 769.505n 3.3v 779.495n 3.3v 779.505n 0.0v 789.495n 0.0v 789.505n 3.3v 799.495n 3.3v 799.505n 3.3v 809.495n 3.3v 809.505n 3.3v 819.495n 3.3v 819.505n 3.3v 829.495n 3.3v 829.505n 3.3v 839.495n 3.3v 839.505n 3.3v 849.495n 3.3v 849.505n 3.3v 859.495n 3.3v 859.505n 3.3v 869.495n 3.3v 869.505n 3.3v 879.495n 3.3v 879.505n 3.3v 889.495n 3.3v 889.505n 3.3v 899.495n 3.3v 899.505n 3.3v 909.495n 3.3v 909.505n 3.3v 919.495n 3.3v 919.505n 3.3v 929.495n 3.3v 929.505n 3.3v 939.495n 3.3v 939.505n 3.3v 949.495n 3.3v 949.505n 3.3v 959.495n 3.3v 959.505n 3.3v 969.495n 3.3v 969.505n 3.3v 979.495n 3.3v 979.505n 3.3v 989.495n 3.3v 989.505n 3.3v 999.495n 3.3v 999.505n 0.0v 1009.495n 0.0v 1009.505n 3.3v 1019.495n 3.3v 1019.505n 0.0v 1029.495n 0.0v 1029.505n 0.0v 1039.495n 0.0v 1039.505n 0.0v 1049.495n 0.0v 1049.505n 0.0v 1059.495n 0.0v 1059.505n 0.0v 1069.495n 0.0v 1069.505n 0.0v 1079.495n 0.0v 1079.505n 0.0v 1089.495n 0.0v 1089.505n 0.0v 1099.495n 0.0v 1099.505n 0.0v 1109.495n 0.0v 1109.505n 0.0v 1119.495n 0.0v 1119.505n 0.0v 1129.495n 0.0v 1129.505n 0.0v 1139.495n 0.0v 1139.505n 0.0v 1149.495n 0.0v 1149.505n 0.0v 1159.495n 0.0v 1159.505n 0.0v 1169.495n 0.0v 1169.505n 0.0v 1179.495n 0.0v 1179.505n 0.0v 1189.495n 0.0v 1189.505n 0.0v 1199.495n 0.0v 1199.505n 0.0v 1209.495n 0.0v 1209.505n 0.0v 1219.495n 0.0v 1219.505n 0.0v 1229.495n 0.0v 1229.505n 0.0v 1239.495n 0.0v 1239.505n 3.3v 1249.495n 3.3v 1249.505n 3.3v 1259.495n 3.3v 1259.505n 3.3v 1269.495n 3.3v 1269.505n 3.3v 1279.495n 3.3v 1279.505n 3.3v 1289.495n 3.3v 1289.505n 0.0v 1299.495n 0.0v 1299.505n 0.0v 1309.495n 0.0v 1309.505n 0.0v 1319.495n 0.0v 1319.505n 0.0v 1329.495n 0.0v 1329.505n 0.0v 1339.495n 0.0v 1339.505n 0.0v 1349.495n 0.0v 1349.505n 0.0v 1359.495n 0.0v 1359.505n 0.0v 1369.495n 0.0v 1369.505n 0.0v 1379.495n 0.0v 1379.505n 0.0v 1389.495n 0.0v 1389.505n 0.0v 1399.495n 0.0v 1399.505n 0.0v 1409.495n 0.0v 1409.505n 0.0v 1419.495n 0.0v 1419.505n 0.0v 1429.495n 0.0v 1429.505n 0.0v 1439.495n 0.0v 1439.505n 0.0v 1449.495n 0.0v 1449.505n 0.0v 1459.495n 0.0v 1459.505n 0.0v 1469.495n 0.0v 1469.505n 0.0v 1479.495n 0.0v 1479.505n 0.0v 1489.495n 0.0v 1489.505n 0.0v 1499.495n 0.0v 1499.505n 3.3v 1509.495n 3.3v 1509.505n 3.3v 1519.495n 3.3v 1519.505n 3.3v 1529.495n 3.3v 1529.505n 3.3v 1539.495n 3.3v 1539.505n 3.3v 1549.495n 3.3v 1549.505n 3.3v 1559.495n 3.3v 1559.505n 3.3v 1569.495n 3.3v 1569.505n 3.3v 1579.495n 3.3v 1579.505n 3.3v 1589.495n 3.3v 1589.505n 3.3v 1599.495n 3.3v 1599.505n 3.3v 1609.495n 3.3v 1609.505n 3.3v 1619.495n 3.3v 1619.505n 3.3v 1629.495n 3.3v 1629.505n 3.3v 1639.495n 3.3v 1639.505n 3.3v 1649.495n 3.3v 1649.505n 3.3v 1659.495n 3.3v 1659.505n 3.3v 1669.495n 3.3v 1669.505n 3.3v 1679.495n 3.3v 1679.505n 3.3v 1689.495n 3.3v 1689.505n 3.3v 1699.495n 3.3v 1699.505n 3.3v 1709.495n 3.3v 1709.505n 0.0v 1719.495n 0.0v 1719.505n 0.0v 1729.495n 0.0v 1729.505n 0.0v 1739.495n 0.0v 1739.505n 0.0v 1749.495n 0.0v 1749.505n 0.0v 1759.495n 0.0v 1759.505n 0.0v 1769.495n 0.0v 1769.505n 0.0v 1779.495n 0.0v 1779.505n 0.0v 1789.495n 0.0v 1789.505n 3.3v 1799.495n 3.3v 1799.505n 3.3v 1809.495n 3.3v 1809.505n 3.3v 1819.495n 3.3v 1819.505n 0.0v 1829.495n 0.0v 1829.505n 0.0v 1839.495n 0.0v 1839.505n 0.0v 1849.495n 0.0v 1849.505n 0.0v 1859.495n 0.0v 1859.505n 0.0v 1869.495n 0.0v 1869.505n 0.0v 1879.495n 0.0v 1879.505n 0.0v 1889.495n 0.0v 1889.505n 0.0v 1899.495n 0.0v 1899.505n 0.0v 1909.495n 0.0v 1909.505n 0.0v 1919.495n 0.0v 1919.505n 0.0v 1929.495n 0.0v 1929.505n 0.0v 1939.495n 0.0v 1939.505n 0.0v 1949.495n 0.0v 1949.505n 0.0v 1959.495n 0.0v 1959.505n 3.3v 1969.495n 3.3v 1969.505n 3.3v 1979.495n 3.3v 1979.505n 3.3v 1989.495n 3.3v 1989.505n 0.0v 1999.495n 0.0v 1999.505n 0.0v 2009.495n 0.0v 2009.505n 0.0v 2019.495n 0.0v 2019.505n 0.0v 2029.495n 0.0v 2029.505n 0.0v 2039.495n 0.0v 2039.505n 0.0v 2049.495n 0.0v 2049.505n 0.0v )
* (time, data): [(0, 0), (10, 1), (20, 1), (30, 0), (40, 0), (50, 0), (60, 1), (70, 1), (80, 1), (90, 1), (100, 0), (110, 0), (120, 0), (130, 0), (140, 0), (150, 0), (160, 0), (170, 0), (180, 0), (190, 0), (200, 0), (210, 0), (220, 1), (230, 1), (240, 1), (250, 1), (260, 0), (270, 1), (280, 1), (290, 0), (300, 0), (310, 1), (320, 1), (330, 0), (340, 0), (350, 0), (360, 0), (370, 0), (380, 0), (390, 0), (400, 0), (410, 0), (420, 0), (430, 1), (440, 1), (450, 1), (460, 1), (470, 0), (480, 0), (490, 0), (500, 0), (510, 0), (520, 0), (530, 0), (540, 1), (550, 1), (560, 0), (570, 0), (580, 1), (590, 1), (600, 1), (610, 0), (620, 0), (630, 0), (640, 0), (650, 0), (660, 0), (670, 0), (680, 0), (690, 0), (700, 0), (710, 0), (720, 0), (730, 0), (740, 0), (750, 0), (760, 0), (770, 0), (780, 0), (790, 1), (800, 1), (810, 1), (820, 1), (830, 1), (840, 1), (850, 1), (860, 1), (870, 1), (880, 1), (890, 1), (900, 1), (910, 1), (920, 1), (930, 1), (940, 1), (950, 1), (960, 1), (970, 1), (980, 1), (990, 1), (1000, 1), (1010, 1), (1020, 1), (1030, 1), (1040, 1), (1050, 0), (1060, 0), (1070, 1), (1080, 1), (1090, 1), (1100, 1), (1110, 1), (1120, 1), (1130, 1), (1140, 1), (1150, 0), (1160, 0), (1170, 0), (1180, 0), (1190, 0), (1200, 0), (1210, 0), (1220, 0), (1230, 0), (1240, 0), (1250, 0), (1260, 0), (1270, 0), (1280, 0), (1290, 0), (1300, 0), (1310, 0), (1320, 0), (1330, 0), (1340, 1), (1350, 1), (1360, 1), (1370, 1), (1380, 1), (1390, 1), (1400, 1), (1410, 1), (1420, 1), (1430, 1), (1440, 1), (1450, 1), (1460, 0), (1470, 0), (1480, 0), (1490, 0), (1500, 1), (1510, 1), (1520, 1), (1530, 1), (1540, 1), (1550, 1), (1560, 1), (1570, 1), (1580, 1), (1590, 1), (1600, 1), (1610, 1), (1620, 1), (1630, 1), (1640, 1), (1650, 1), (1660, 0), (1670, 0), (1680, 0), (1690, 0), (1700, 0), (1710, 1), (1720, 1), (1730, 1), (1740, 1), (1750, 1), (1760, 1), (1770, 1), (1780, 0), (1790, 0), (1800, 0), (1810, 0), (1820, 0), (1830, 0), (1840, 0), (1850, 1), (1860, 1), (1870, 1), (1880, 1), (1890, 1), (1900, 1), (1910, 1), (1920, 1), (1930, 1), (1940, 1), (1950, 1), (1960, 0), (1970, 0), (1980, 0), (1990, 0), (2000, 0), (2010, 0), (2020, 0), (2030, 0), (2040, 0), (2050, 0)]
Vdin0_10  din0_10  0 PWL (0n 0.0v 9.495n 0.0v 9.505n 3.3v 19.495n 3.3v 19.505n 3.3v 29.495n 3.3v 29.505n 0.0v 39.495n 0.0v 39.505n 0.0v 49.495n 0.0v 49.505n 0.0v 59.495n 0.0v 59.505n 3.3v 69.495n 3.3v 69.505n 3.3v 79.495n 3.3v 79.505n 3.3v 89.495n 3.3v 89.505n 3.3v 99.495n 3.3v 99.505n 0.0v 109.495n 0.0v 109.505n 0.0v 119.495n 0.0v 119.505n 0.0v 129.495n 0.0v 129.505n 0.0v 139.495n 0.0v 139.505n 0.0v 149.495n 0.0v 149.505n 0.0v 159.495n 0.0v 159.505n 0.0v 169.495n 0.0v 169.505n 0.0v 179.495n 0.0v 179.505n 0.0v 189.495n 0.0v 189.505n 0.0v 199.495n 0.0v 199.505n 0.0v 209.495n 0.0v 209.505n 0.0v 219.495n 0.0v 219.505n 3.3v 229.495n 3.3v 229.505n 3.3v 239.495n 3.3v 239.505n 3.3v 249.495n 3.3v 249.505n 3.3v 259.495n 3.3v 259.505n 0.0v 269.495n 0.0v 269.505n 3.3v 279.495n 3.3v 279.505n 3.3v 289.495n 3.3v 289.505n 0.0v 299.495n 0.0v 299.505n 0.0v 309.495n 0.0v 309.505n 3.3v 319.495n 3.3v 319.505n 3.3v 329.495n 3.3v 329.505n 0.0v 339.495n 0.0v 339.505n 0.0v 349.495n 0.0v 349.505n 0.0v 359.495n 0.0v 359.505n 0.0v 369.495n 0.0v 369.505n 0.0v 379.495n 0.0v 379.505n 0.0v 389.495n 0.0v 389.505n 0.0v 399.495n 0.0v 399.505n 0.0v 409.495n 0.0v 409.505n 0.0v 419.495n 0.0v 419.505n 0.0v 429.495n 0.0v 429.505n 3.3v 439.495n 3.3v 439.505n 3.3v 449.495n 3.3v 449.505n 3.3v 459.495n 3.3v 459.505n 3.3v 469.495n 3.3v 469.505n 0.0v 479.495n 0.0v 479.505n 0.0v 489.495n 0.0v 489.505n 0.0v 499.495n 0.0v 499.505n 0.0v 509.495n 0.0v 509.505n 0.0v 519.495n 0.0v 519.505n 0.0v 529.495n 0.0v 529.505n 0.0v 539.495n 0.0v 539.505n 3.3v 549.495n 3.3v 549.505n 3.3v 559.495n 3.3v 559.505n 0.0v 569.495n 0.0v 569.505n 0.0v 579.495n 0.0v 579.505n 3.3v 589.495n 3.3v 589.505n 3.3v 599.495n 3.3v 599.505n 3.3v 609.495n 3.3v 609.505n 0.0v 619.495n 0.0v 619.505n 0.0v 629.495n 0.0v 629.505n 0.0v 639.495n 0.0v 639.505n 0.0v 649.495n 0.0v 649.505n 0.0v 659.495n 0.0v 659.505n 0.0v 669.495n 0.0v 669.505n 0.0v 679.495n 0.0v 679.505n 0.0v 689.495n 0.0v 689.505n 0.0v 699.495n 0.0v 699.505n 0.0v 709.495n 0.0v 709.505n 0.0v 719.495n 0.0v 719.505n 0.0v 729.495n 0.0v 729.505n 0.0v 739.495n 0.0v 739.505n 0.0v 749.495n 0.0v 749.505n 0.0v 759.495n 0.0v 759.505n 0.0v 769.495n 0.0v 769.505n 0.0v 779.495n 0.0v 779.505n 0.0v 789.495n 0.0v 789.505n 3.3v 799.495n 3.3v 799.505n 3.3v 809.495n 3.3v 809.505n 3.3v 819.495n 3.3v 819.505n 3.3v 829.495n 3.3v 829.505n 3.3v 839.495n 3.3v 839.505n 3.3v 849.495n 3.3v 849.505n 3.3v 859.495n 3.3v 859.505n 3.3v 869.495n 3.3v 869.505n 3.3v 879.495n 3.3v 879.505n 3.3v 889.495n 3.3v 889.505n 3.3v 899.495n 3.3v 899.505n 3.3v 909.495n 3.3v 909.505n 3.3v 919.495n 3.3v 919.505n 3.3v 929.495n 3.3v 929.505n 3.3v 939.495n 3.3v 939.505n 3.3v 949.495n 3.3v 949.505n 3.3v 959.495n 3.3v 959.505n 3.3v 969.495n 3.3v 969.505n 3.3v 979.495n 3.3v 979.505n 3.3v 989.495n 3.3v 989.505n 3.3v 999.495n 3.3v 999.505n 3.3v 1009.495n 3.3v 1009.505n 3.3v 1019.495n 3.3v 1019.505n 3.3v 1029.495n 3.3v 1029.505n 3.3v 1039.495n 3.3v 1039.505n 3.3v 1049.495n 3.3v 1049.505n 0.0v 1059.495n 0.0v 1059.505n 0.0v 1069.495n 0.0v 1069.505n 3.3v 1079.495n 3.3v 1079.505n 3.3v 1089.495n 3.3v 1089.505n 3.3v 1099.495n 3.3v 1099.505n 3.3v 1109.495n 3.3v 1109.505n 3.3v 1119.495n 3.3v 1119.505n 3.3v 1129.495n 3.3v 1129.505n 3.3v 1139.495n 3.3v 1139.505n 3.3v 1149.495n 3.3v 1149.505n 0.0v 1159.495n 0.0v 1159.505n 0.0v 1169.495n 0.0v 1169.505n 0.0v 1179.495n 0.0v 1179.505n 0.0v 1189.495n 0.0v 1189.505n 0.0v 1199.495n 0.0v 1199.505n 0.0v 1209.495n 0.0v 1209.505n 0.0v 1219.495n 0.0v 1219.505n 0.0v 1229.495n 0.0v 1229.505n 0.0v 1239.495n 0.0v 1239.505n 0.0v 1249.495n 0.0v 1249.505n 0.0v 1259.495n 0.0v 1259.505n 0.0v 1269.495n 0.0v 1269.505n 0.0v 1279.495n 0.0v 1279.505n 0.0v 1289.495n 0.0v 1289.505n 0.0v 1299.495n 0.0v 1299.505n 0.0v 1309.495n 0.0v 1309.505n 0.0v 1319.495n 0.0v 1319.505n 0.0v 1329.495n 0.0v 1329.505n 0.0v 1339.495n 0.0v 1339.505n 3.3v 1349.495n 3.3v 1349.505n 3.3v 1359.495n 3.3v 1359.505n 3.3v 1369.495n 3.3v 1369.505n 3.3v 1379.495n 3.3v 1379.505n 3.3v 1389.495n 3.3v 1389.505n 3.3v 1399.495n 3.3v 1399.505n 3.3v 1409.495n 3.3v 1409.505n 3.3v 1419.495n 3.3v 1419.505n 3.3v 1429.495n 3.3v 1429.505n 3.3v 1439.495n 3.3v 1439.505n 3.3v 1449.495n 3.3v 1449.505n 3.3v 1459.495n 3.3v 1459.505n 0.0v 1469.495n 0.0v 1469.505n 0.0v 1479.495n 0.0v 1479.505n 0.0v 1489.495n 0.0v 1489.505n 0.0v 1499.495n 0.0v 1499.505n 3.3v 1509.495n 3.3v 1509.505n 3.3v 1519.495n 3.3v 1519.505n 3.3v 1529.495n 3.3v 1529.505n 3.3v 1539.495n 3.3v 1539.505n 3.3v 1549.495n 3.3v 1549.505n 3.3v 1559.495n 3.3v 1559.505n 3.3v 1569.495n 3.3v 1569.505n 3.3v 1579.495n 3.3v 1579.505n 3.3v 1589.495n 3.3v 1589.505n 3.3v 1599.495n 3.3v 1599.505n 3.3v 1609.495n 3.3v 1609.505n 3.3v 1619.495n 3.3v 1619.505n 3.3v 1629.495n 3.3v 1629.505n 3.3v 1639.495n 3.3v 1639.505n 3.3v 1649.495n 3.3v 1649.505n 3.3v 1659.495n 3.3v 1659.505n 0.0v 1669.495n 0.0v 1669.505n 0.0v 1679.495n 0.0v 1679.505n 0.0v 1689.495n 0.0v 1689.505n 0.0v 1699.495n 0.0v 1699.505n 0.0v 1709.495n 0.0v 1709.505n 3.3v 1719.495n 3.3v 1719.505n 3.3v 1729.495n 3.3v 1729.505n 3.3v 1739.495n 3.3v 1739.505n 3.3v 1749.495n 3.3v 1749.505n 3.3v 1759.495n 3.3v 1759.505n 3.3v 1769.495n 3.3v 1769.505n 3.3v 1779.495n 3.3v 1779.505n 0.0v 1789.495n 0.0v 1789.505n 0.0v 1799.495n 0.0v 1799.505n 0.0v 1809.495n 0.0v 1809.505n 0.0v 1819.495n 0.0v 1819.505n 0.0v 1829.495n 0.0v 1829.505n 0.0v 1839.495n 0.0v 1839.505n 0.0v 1849.495n 0.0v 1849.505n 3.3v 1859.495n 3.3v 1859.505n 3.3v 1869.495n 3.3v 1869.505n 3.3v 1879.495n 3.3v 1879.505n 3.3v 1889.495n 3.3v 1889.505n 3.3v 1899.495n 3.3v 1899.505n 3.3v 1909.495n 3.3v 1909.505n 3.3v 1919.495n 3.3v 1919.505n 3.3v 1929.495n 3.3v 1929.505n 3.3v 1939.495n 3.3v 1939.505n 3.3v 1949.495n 3.3v 1949.505n 3.3v 1959.495n 3.3v 1959.505n 0.0v 1969.495n 0.0v 1969.505n 0.0v 1979.495n 0.0v 1979.505n 0.0v 1989.495n 0.0v 1989.505n 0.0v 1999.495n 0.0v 1999.505n 0.0v 2009.495n 0.0v 2009.505n 0.0v 2019.495n 0.0v 2019.505n 0.0v 2029.495n 0.0v 2029.505n 0.0v 2039.495n 0.0v 2039.505n 0.0v 2049.495n 0.0v 2049.505n 0.0v )
* (time, data): [(0, 0), (10, 0), (20, 1), (30, 1), (40, 1), (50, 1), (60, 1), (70, 1), (80, 1), (90, 1), (100, 0), (110, 0), (120, 0), (130, 0), (140, 0), (150, 0), (160, 1), (170, 1), (180, 1), (190, 1), (200, 1), (210, 1), (220, 1), (230, 1), (240, 1), (250, 1), (260, 0), (270, 1), (280, 1), (290, 1), (300, 1), (310, 1), (320, 1), (330, 1), (340, 0), (350, 0), (360, 0), (370, 0), (380, 0), (390, 1), (400, 1), (410, 1), (420, 1), (430, 1), (440, 1), (450, 1), (460, 0), (470, 0), (480, 0), (490, 0), (500, 0), (510, 0), (520, 0), (530, 1), (540, 0), (550, 0), (560, 1), (570, 1), (580, 0), (590, 0), (600, 0), (610, 1), (620, 1), (630, 1), (640, 1), (650, 1), (660, 1), (670, 1), (680, 1), (690, 1), (700, 1), (710, 0), (720, 0), (730, 0), (740, 0), (750, 0), (760, 0), (770, 0), (780, 1), (790, 1), (800, 1), (810, 1), (820, 1), (830, 1), (840, 1), (850, 0), (860, 0), (870, 0), (880, 0), (890, 0), (900, 0), (910, 0), (920, 0), (930, 0), (940, 0), (950, 0), (960, 0), (970, 0), (980, 0), (990, 1), (1000, 0), (1010, 0), (1020, 1), (1030, 1), (1040, 1), (1050, 1), (1060, 1), (1070, 0), (1080, 0), (1090, 0), (1100, 0), (1110, 0), (1120, 0), (1130, 0), (1140, 0), (1150, 0), (1160, 0), (1170, 0), (1180, 0), (1190, 0), (1200, 0), (1210, 0), (1220, 0), (1230, 0), (1240, 1), (1250, 1), (1260, 1), (1270, 1), (1280, 0), (1290, 0), (1300, 0), (1310, 0), (1320, 0), (1330, 0), (1340, 1), (1350, 1), (1360, 0), (1370, 1), (1380, 1), (1390, 1), (1400, 1), (1410, 1), (1420, 1), (1430, 1), (1440, 1), (1450, 1), (1460, 0), (1470, 0), (1480, 0), (1490, 0), (1500, 1), (1510, 1), (1520, 1), (1530, 0), (1540, 0), (1550, 0), (1560, 0), (1570, 0), (1580, 0), (1590, 0), (1600, 0), (1610, 0), (1620, 0), (1630, 0), (1640, 0), (1650, 0), (1660, 1), (1670, 1), (1680, 1), (1690, 1), (1700, 1), (1710, 1), (1720, 1), (1730, 1), (1740, 1), (1750, 1), (1760, 1), (1770, 1), (1780, 1), (1790, 0), (1800, 0), (1810, 0), (1820, 1), (1830, 1), (1840, 1), (1850, 0), (1860, 0), (1870, 0), (1880, 1), (1890, 1), (1900, 1), (1910, 1), (1920, 1), (1930, 1), (1940, 1), (1950, 1), (1960, 0), (1970, 0), (1980, 0), (1990, 0), (2000, 0), (2010, 0), (2020, 0), (2030, 0), (2040, 0), (2050, 0)]
Vdin0_11  din0_11  0 PWL (0n 0.0v 9.495n 0.0v 9.505n 0.0v 19.495n 0.0v 19.505n 3.3v 29.495n 3.3v 29.505n 3.3v 39.495n 3.3v 39.505n 3.3v 49.495n 3.3v 49.505n 3.3v 59.495n 3.3v 59.505n 3.3v 69.495n 3.3v 69.505n 3.3v 79.495n 3.3v 79.505n 3.3v 89.495n 3.3v 89.505n 3.3v 99.495n 3.3v 99.505n 0.0v 109.495n 0.0v 109.505n 0.0v 119.495n 0.0v 119.505n 0.0v 129.495n 0.0v 129.505n 0.0v 139.495n 0.0v 139.505n 0.0v 149.495n 0.0v 149.505n 0.0v 159.495n 0.0v 159.505n 3.3v 169.495n 3.3v 169.505n 3.3v 179.495n 3.3v 179.505n 3.3v 189.495n 3.3v 189.505n 3.3v 199.495n 3.3v 199.505n 3.3v 209.495n 3.3v 209.505n 3.3v 219.495n 3.3v 219.505n 3.3v 229.495n 3.3v 229.505n 3.3v 239.495n 3.3v 239.505n 3.3v 249.495n 3.3v 249.505n 3.3v 259.495n 3.3v 259.505n 0.0v 269.495n 0.0v 269.505n 3.3v 279.495n 3.3v 279.505n 3.3v 289.495n 3.3v 289.505n 3.3v 299.495n 3.3v 299.505n 3.3v 309.495n 3.3v 309.505n 3.3v 319.495n 3.3v 319.505n 3.3v 329.495n 3.3v 329.505n 3.3v 339.495n 3.3v 339.505n 0.0v 349.495n 0.0v 349.505n 0.0v 359.495n 0.0v 359.505n 0.0v 369.495n 0.0v 369.505n 0.0v 379.495n 0.0v 379.505n 0.0v 389.495n 0.0v 389.505n 3.3v 399.495n 3.3v 399.505n 3.3v 409.495n 3.3v 409.505n 3.3v 419.495n 3.3v 419.505n 3.3v 429.495n 3.3v 429.505n 3.3v 439.495n 3.3v 439.505n 3.3v 449.495n 3.3v 449.505n 3.3v 459.495n 3.3v 459.505n 0.0v 469.495n 0.0v 469.505n 0.0v 479.495n 0.0v 479.505n 0.0v 489.495n 0.0v 489.505n 0.0v 499.495n 0.0v 499.505n 0.0v 509.495n 0.0v 509.505n 0.0v 519.495n 0.0v 519.505n 0.0v 529.495n 0.0v 529.505n 3.3v 539.495n 3.3v 539.505n 0.0v 549.495n 0.0v 549.505n 0.0v 559.495n 0.0v 559.505n 3.3v 569.495n 3.3v 569.505n 3.3v 579.495n 3.3v 579.505n 0.0v 589.495n 0.0v 589.505n 0.0v 599.495n 0.0v 599.505n 0.0v 609.495n 0.0v 609.505n 3.3v 619.495n 3.3v 619.505n 3.3v 629.495n 3.3v 629.505n 3.3v 639.495n 3.3v 639.505n 3.3v 649.495n 3.3v 649.505n 3.3v 659.495n 3.3v 659.505n 3.3v 669.495n 3.3v 669.505n 3.3v 679.495n 3.3v 679.505n 3.3v 689.495n 3.3v 689.505n 3.3v 699.495n 3.3v 699.505n 3.3v 709.495n 3.3v 709.505n 0.0v 719.495n 0.0v 719.505n 0.0v 729.495n 0.0v 729.505n 0.0v 739.495n 0.0v 739.505n 0.0v 749.495n 0.0v 749.505n 0.0v 759.495n 0.0v 759.505n 0.0v 769.495n 0.0v 769.505n 0.0v 779.495n 0.0v 779.505n 3.3v 789.495n 3.3v 789.505n 3.3v 799.495n 3.3v 799.505n 3.3v 809.495n 3.3v 809.505n 3.3v 819.495n 3.3v 819.505n 3.3v 829.495n 3.3v 829.505n 3.3v 839.495n 3.3v 839.505n 3.3v 849.495n 3.3v 849.505n 0.0v 859.495n 0.0v 859.505n 0.0v 869.495n 0.0v 869.505n 0.0v 879.495n 0.0v 879.505n 0.0v 889.495n 0.0v 889.505n 0.0v 899.495n 0.0v 899.505n 0.0v 909.495n 0.0v 909.505n 0.0v 919.495n 0.0v 919.505n 0.0v 929.495n 0.0v 929.505n 0.0v 939.495n 0.0v 939.505n 0.0v 949.495n 0.0v 949.505n 0.0v 959.495n 0.0v 959.505n 0.0v 969.495n 0.0v 969.505n 0.0v 979.495n 0.0v 979.505n 0.0v 989.495n 0.0v 989.505n 3.3v 999.495n 3.3v 999.505n 0.0v 1009.495n 0.0v 1009.505n 0.0v 1019.495n 0.0v 1019.505n 3.3v 1029.495n 3.3v 1029.505n 3.3v 1039.495n 3.3v 1039.505n 3.3v 1049.495n 3.3v 1049.505n 3.3v 1059.495n 3.3v 1059.505n 3.3v 1069.495n 3.3v 1069.505n 0.0v 1079.495n 0.0v 1079.505n 0.0v 1089.495n 0.0v 1089.505n 0.0v 1099.495n 0.0v 1099.505n 0.0v 1109.495n 0.0v 1109.505n 0.0v 1119.495n 0.0v 1119.505n 0.0v 1129.495n 0.0v 1129.505n 0.0v 1139.495n 0.0v 1139.505n 0.0v 1149.495n 0.0v 1149.505n 0.0v 1159.495n 0.0v 1159.505n 0.0v 1169.495n 0.0v 1169.505n 0.0v 1179.495n 0.0v 1179.505n 0.0v 1189.495n 0.0v 1189.505n 0.0v 1199.495n 0.0v 1199.505n 0.0v 1209.495n 0.0v 1209.505n 0.0v 1219.495n 0.0v 1219.505n 0.0v 1229.495n 0.0v 1229.505n 0.0v 1239.495n 0.0v 1239.505n 3.3v 1249.495n 3.3v 1249.505n 3.3v 1259.495n 3.3v 1259.505n 3.3v 1269.495n 3.3v 1269.505n 3.3v 1279.495n 3.3v 1279.505n 0.0v 1289.495n 0.0v 1289.505n 0.0v 1299.495n 0.0v 1299.505n 0.0v 1309.495n 0.0v 1309.505n 0.0v 1319.495n 0.0v 1319.505n 0.0v 1329.495n 0.0v 1329.505n 0.0v 1339.495n 0.0v 1339.505n 3.3v 1349.495n 3.3v 1349.505n 3.3v 1359.495n 3.3v 1359.505n 0.0v 1369.495n 0.0v 1369.505n 3.3v 1379.495n 3.3v 1379.505n 3.3v 1389.495n 3.3v 1389.505n 3.3v 1399.495n 3.3v 1399.505n 3.3v 1409.495n 3.3v 1409.505n 3.3v 1419.495n 3.3v 1419.505n 3.3v 1429.495n 3.3v 1429.505n 3.3v 1439.495n 3.3v 1439.505n 3.3v 1449.495n 3.3v 1449.505n 3.3v 1459.495n 3.3v 1459.505n 0.0v 1469.495n 0.0v 1469.505n 0.0v 1479.495n 0.0v 1479.505n 0.0v 1489.495n 0.0v 1489.505n 0.0v 1499.495n 0.0v 1499.505n 3.3v 1509.495n 3.3v 1509.505n 3.3v 1519.495n 3.3v 1519.505n 3.3v 1529.495n 3.3v 1529.505n 0.0v 1539.495n 0.0v 1539.505n 0.0v 1549.495n 0.0v 1549.505n 0.0v 1559.495n 0.0v 1559.505n 0.0v 1569.495n 0.0v 1569.505n 0.0v 1579.495n 0.0v 1579.505n 0.0v 1589.495n 0.0v 1589.505n 0.0v 1599.495n 0.0v 1599.505n 0.0v 1609.495n 0.0v 1609.505n 0.0v 1619.495n 0.0v 1619.505n 0.0v 1629.495n 0.0v 1629.505n 0.0v 1639.495n 0.0v 1639.505n 0.0v 1649.495n 0.0v 1649.505n 0.0v 1659.495n 0.0v 1659.505n 3.3v 1669.495n 3.3v 1669.505n 3.3v 1679.495n 3.3v 1679.505n 3.3v 1689.495n 3.3v 1689.505n 3.3v 1699.495n 3.3v 1699.505n 3.3v 1709.495n 3.3v 1709.505n 3.3v 1719.495n 3.3v 1719.505n 3.3v 1729.495n 3.3v 1729.505n 3.3v 1739.495n 3.3v 1739.505n 3.3v 1749.495n 3.3v 1749.505n 3.3v 1759.495n 3.3v 1759.505n 3.3v 1769.495n 3.3v 1769.505n 3.3v 1779.495n 3.3v 1779.505n 3.3v 1789.495n 3.3v 1789.505n 0.0v 1799.495n 0.0v 1799.505n 0.0v 1809.495n 0.0v 1809.505n 0.0v 1819.495n 0.0v 1819.505n 3.3v 1829.495n 3.3v 1829.505n 3.3v 1839.495n 3.3v 1839.505n 3.3v 1849.495n 3.3v 1849.505n 0.0v 1859.495n 0.0v 1859.505n 0.0v 1869.495n 0.0v 1869.505n 0.0v 1879.495n 0.0v 1879.505n 3.3v 1889.495n 3.3v 1889.505n 3.3v 1899.495n 3.3v 1899.505n 3.3v 1909.495n 3.3v 1909.505n 3.3v 1919.495n 3.3v 1919.505n 3.3v 1929.495n 3.3v 1929.505n 3.3v 1939.495n 3.3v 1939.505n 3.3v 1949.495n 3.3v 1949.505n 3.3v 1959.495n 3.3v 1959.505n 0.0v 1969.495n 0.0v 1969.505n 0.0v 1979.495n 0.0v 1979.505n 0.0v 1989.495n 0.0v 1989.505n 0.0v 1999.495n 0.0v 1999.505n 0.0v 2009.495n 0.0v 2009.505n 0.0v 2019.495n 0.0v 2019.505n 0.0v 2029.495n 0.0v 2029.505n 0.0v 2039.495n 0.0v 2039.505n 0.0v 2049.495n 0.0v 2049.505n 0.0v )
* (time, data): [(0, 0), (10, 1), (20, 1), (30, 1), (40, 1), (50, 1), (60, 1), (70, 1), (80, 1), (90, 1), (100, 1), (110, 1), (120, 1), (130, 1), (140, 1), (150, 1), (160, 1), (170, 1), (180, 1), (190, 1), (200, 1), (210, 1), (220, 1), (230, 1), (240, 1), (250, 1), (260, 0), (270, 1), (280, 1), (290, 0), (300, 0), (310, 0), (320, 0), (330, 1), (340, 1), (350, 1), (360, 1), (370, 1), (380, 1), (390, 1), (400, 1), (410, 1), (420, 1), (430, 0), (440, 0), (450, 0), (460, 1), (470, 1), (480, 1), (490, 1), (500, 1), (510, 1), (520, 1), (530, 1), (540, 1), (550, 1), (560, 1), (570, 1), (580, 1), (590, 1), (600, 1), (610, 1), (620, 1), (630, 1), (640, 1), (650, 1), (660, 1), (670, 1), (680, 1), (690, 1), (700, 1), (710, 0), (720, 0), (730, 0), (740, 0), (750, 0), (760, 0), (770, 0), (780, 1), (790, 1), (800, 1), (810, 1), (820, 1), (830, 1), (840, 1), (850, 0), (860, 0), (870, 0), (880, 0), (890, 0), (900, 0), (910, 0), (920, 0), (930, 0), (940, 0), (950, 0), (960, 0), (970, 0), (980, 0), (990, 1), (1000, 0), (1010, 0), (1020, 1), (1030, 1), (1040, 1), (1050, 0), (1060, 0), (1070, 0), (1080, 0), (1090, 0), (1100, 0), (1110, 0), (1120, 0), (1130, 0), (1140, 0), (1150, 1), (1160, 1), (1170, 1), (1180, 1), (1190, 1), (1200, 1), (1210, 1), (1220, 1), (1230, 1), (1240, 1), (1250, 1), (1260, 0), (1270, 0), (1280, 0), (1290, 1), (1300, 1), (1310, 1), (1320, 1), (1330, 1), (1340, 0), (1350, 0), (1360, 1), (1370, 0), (1380, 0), (1390, 0), (1400, 0), (1410, 0), (1420, 0), (1430, 0), (1440, 0), (1450, 0), (1460, 1), (1470, 1), (1480, 1), (1490, 1), (1500, 0), (1510, 0), (1520, 0), (1530, 1), (1540, 1), (1550, 1), (1560, 1), (1570, 1), (1580, 1), (1590, 1), (1600, 1), (1610, 1), (1620, 1), (1630, 1), (1640, 1), (1650, 1), (1660, 0), (1670, 0), (1680, 0), (1690, 0), (1700, 0), (1710, 1), (1720, 1), (1730, 1), (1740, 1), (1750, 1), (1760, 1), (1770, 1), (1780, 0), (1790, 0), (1800, 0), (1810, 0), (1820, 0), (1830, 0), (1840, 0), (1850, 0), (1860, 0), (1870, 0), (1880, 1), (1890, 1), (1900, 1), (1910, 1), (1920, 1), (1930, 1), (1940, 1), (1950, 1), (1960, 0), (1970, 0), (1980, 0), (1990, 1), (2000, 1), (2010, 1), (2020, 1), (2030, 1), (2040, 1), (2050, 1)]
Vdin0_12  din0_12  0 PWL (0n 0.0v 9.495n 0.0v 9.505n 3.3v 19.495n 3.3v 19.505n 3.3v 29.495n 3.3v 29.505n 3.3v 39.495n 3.3v 39.505n 3.3v 49.495n 3.3v 49.505n 3.3v 59.495n 3.3v 59.505n 3.3v 69.495n 3.3v 69.505n 3.3v 79.495n 3.3v 79.505n 3.3v 89.495n 3.3v 89.505n 3.3v 99.495n 3.3v 99.505n 3.3v 109.495n 3.3v 109.505n 3.3v 119.495n 3.3v 119.505n 3.3v 129.495n 3.3v 129.505n 3.3v 139.495n 3.3v 139.505n 3.3v 149.495n 3.3v 149.505n 3.3v 159.495n 3.3v 159.505n 3.3v 169.495n 3.3v 169.505n 3.3v 179.495n 3.3v 179.505n 3.3v 189.495n 3.3v 189.505n 3.3v 199.495n 3.3v 199.505n 3.3v 209.495n 3.3v 209.505n 3.3v 219.495n 3.3v 219.505n 3.3v 229.495n 3.3v 229.505n 3.3v 239.495n 3.3v 239.505n 3.3v 249.495n 3.3v 249.505n 3.3v 259.495n 3.3v 259.505n 0.0v 269.495n 0.0v 269.505n 3.3v 279.495n 3.3v 279.505n 3.3v 289.495n 3.3v 289.505n 0.0v 299.495n 0.0v 299.505n 0.0v 309.495n 0.0v 309.505n 0.0v 319.495n 0.0v 319.505n 0.0v 329.495n 0.0v 329.505n 3.3v 339.495n 3.3v 339.505n 3.3v 349.495n 3.3v 349.505n 3.3v 359.495n 3.3v 359.505n 3.3v 369.495n 3.3v 369.505n 3.3v 379.495n 3.3v 379.505n 3.3v 389.495n 3.3v 389.505n 3.3v 399.495n 3.3v 399.505n 3.3v 409.495n 3.3v 409.505n 3.3v 419.495n 3.3v 419.505n 3.3v 429.495n 3.3v 429.505n 0.0v 439.495n 0.0v 439.505n 0.0v 449.495n 0.0v 449.505n 0.0v 459.495n 0.0v 459.505n 3.3v 469.495n 3.3v 469.505n 3.3v 479.495n 3.3v 479.505n 3.3v 489.495n 3.3v 489.505n 3.3v 499.495n 3.3v 499.505n 3.3v 509.495n 3.3v 509.505n 3.3v 519.495n 3.3v 519.505n 3.3v 529.495n 3.3v 529.505n 3.3v 539.495n 3.3v 539.505n 3.3v 549.495n 3.3v 549.505n 3.3v 559.495n 3.3v 559.505n 3.3v 569.495n 3.3v 569.505n 3.3v 579.495n 3.3v 579.505n 3.3v 589.495n 3.3v 589.505n 3.3v 599.495n 3.3v 599.505n 3.3v 609.495n 3.3v 609.505n 3.3v 619.495n 3.3v 619.505n 3.3v 629.495n 3.3v 629.505n 3.3v 639.495n 3.3v 639.505n 3.3v 649.495n 3.3v 649.505n 3.3v 659.495n 3.3v 659.505n 3.3v 669.495n 3.3v 669.505n 3.3v 679.495n 3.3v 679.505n 3.3v 689.495n 3.3v 689.505n 3.3v 699.495n 3.3v 699.505n 3.3v 709.495n 3.3v 709.505n 0.0v 719.495n 0.0v 719.505n 0.0v 729.495n 0.0v 729.505n 0.0v 739.495n 0.0v 739.505n 0.0v 749.495n 0.0v 749.505n 0.0v 759.495n 0.0v 759.505n 0.0v 769.495n 0.0v 769.505n 0.0v 779.495n 0.0v 779.505n 3.3v 789.495n 3.3v 789.505n 3.3v 799.495n 3.3v 799.505n 3.3v 809.495n 3.3v 809.505n 3.3v 819.495n 3.3v 819.505n 3.3v 829.495n 3.3v 829.505n 3.3v 839.495n 3.3v 839.505n 3.3v 849.495n 3.3v 849.505n 0.0v 859.495n 0.0v 859.505n 0.0v 869.495n 0.0v 869.505n 0.0v 879.495n 0.0v 879.505n 0.0v 889.495n 0.0v 889.505n 0.0v 899.495n 0.0v 899.505n 0.0v 909.495n 0.0v 909.505n 0.0v 919.495n 0.0v 919.505n 0.0v 929.495n 0.0v 929.505n 0.0v 939.495n 0.0v 939.505n 0.0v 949.495n 0.0v 949.505n 0.0v 959.495n 0.0v 959.505n 0.0v 969.495n 0.0v 969.505n 0.0v 979.495n 0.0v 979.505n 0.0v 989.495n 0.0v 989.505n 3.3v 999.495n 3.3v 999.505n 0.0v 1009.495n 0.0v 1009.505n 0.0v 1019.495n 0.0v 1019.505n 3.3v 1029.495n 3.3v 1029.505n 3.3v 1039.495n 3.3v 1039.505n 3.3v 1049.495n 3.3v 1049.505n 0.0v 1059.495n 0.0v 1059.505n 0.0v 1069.495n 0.0v 1069.505n 0.0v 1079.495n 0.0v 1079.505n 0.0v 1089.495n 0.0v 1089.505n 0.0v 1099.495n 0.0v 1099.505n 0.0v 1109.495n 0.0v 1109.505n 0.0v 1119.495n 0.0v 1119.505n 0.0v 1129.495n 0.0v 1129.505n 0.0v 1139.495n 0.0v 1139.505n 0.0v 1149.495n 0.0v 1149.505n 3.3v 1159.495n 3.3v 1159.505n 3.3v 1169.495n 3.3v 1169.505n 3.3v 1179.495n 3.3v 1179.505n 3.3v 1189.495n 3.3v 1189.505n 3.3v 1199.495n 3.3v 1199.505n 3.3v 1209.495n 3.3v 1209.505n 3.3v 1219.495n 3.3v 1219.505n 3.3v 1229.495n 3.3v 1229.505n 3.3v 1239.495n 3.3v 1239.505n 3.3v 1249.495n 3.3v 1249.505n 3.3v 1259.495n 3.3v 1259.505n 0.0v 1269.495n 0.0v 1269.505n 0.0v 1279.495n 0.0v 1279.505n 0.0v 1289.495n 0.0v 1289.505n 3.3v 1299.495n 3.3v 1299.505n 3.3v 1309.495n 3.3v 1309.505n 3.3v 1319.495n 3.3v 1319.505n 3.3v 1329.495n 3.3v 1329.505n 3.3v 1339.495n 3.3v 1339.505n 0.0v 1349.495n 0.0v 1349.505n 0.0v 1359.495n 0.0v 1359.505n 3.3v 1369.495n 3.3v 1369.505n 0.0v 1379.495n 0.0v 1379.505n 0.0v 1389.495n 0.0v 1389.505n 0.0v 1399.495n 0.0v 1399.505n 0.0v 1409.495n 0.0v 1409.505n 0.0v 1419.495n 0.0v 1419.505n 0.0v 1429.495n 0.0v 1429.505n 0.0v 1439.495n 0.0v 1439.505n 0.0v 1449.495n 0.0v 1449.505n 0.0v 1459.495n 0.0v 1459.505n 3.3v 1469.495n 3.3v 1469.505n 3.3v 1479.495n 3.3v 1479.505n 3.3v 1489.495n 3.3v 1489.505n 3.3v 1499.495n 3.3v 1499.505n 0.0v 1509.495n 0.0v 1509.505n 0.0v 1519.495n 0.0v 1519.505n 0.0v 1529.495n 0.0v 1529.505n 3.3v 1539.495n 3.3v 1539.505n 3.3v 1549.495n 3.3v 1549.505n 3.3v 1559.495n 3.3v 1559.505n 3.3v 1569.495n 3.3v 1569.505n 3.3v 1579.495n 3.3v 1579.505n 3.3v 1589.495n 3.3v 1589.505n 3.3v 1599.495n 3.3v 1599.505n 3.3v 1609.495n 3.3v 1609.505n 3.3v 1619.495n 3.3v 1619.505n 3.3v 1629.495n 3.3v 1629.505n 3.3v 1639.495n 3.3v 1639.505n 3.3v 1649.495n 3.3v 1649.505n 3.3v 1659.495n 3.3v 1659.505n 0.0v 1669.495n 0.0v 1669.505n 0.0v 1679.495n 0.0v 1679.505n 0.0v 1689.495n 0.0v 1689.505n 0.0v 1699.495n 0.0v 1699.505n 0.0v 1709.495n 0.0v 1709.505n 3.3v 1719.495n 3.3v 1719.505n 3.3v 1729.495n 3.3v 1729.505n 3.3v 1739.495n 3.3v 1739.505n 3.3v 1749.495n 3.3v 1749.505n 3.3v 1759.495n 3.3v 1759.505n 3.3v 1769.495n 3.3v 1769.505n 3.3v 1779.495n 3.3v 1779.505n 0.0v 1789.495n 0.0v 1789.505n 0.0v 1799.495n 0.0v 1799.505n 0.0v 1809.495n 0.0v 1809.505n 0.0v 1819.495n 0.0v 1819.505n 0.0v 1829.495n 0.0v 1829.505n 0.0v 1839.495n 0.0v 1839.505n 0.0v 1849.495n 0.0v 1849.505n 0.0v 1859.495n 0.0v 1859.505n 0.0v 1869.495n 0.0v 1869.505n 0.0v 1879.495n 0.0v 1879.505n 3.3v 1889.495n 3.3v 1889.505n 3.3v 1899.495n 3.3v 1899.505n 3.3v 1909.495n 3.3v 1909.505n 3.3v 1919.495n 3.3v 1919.505n 3.3v 1929.495n 3.3v 1929.505n 3.3v 1939.495n 3.3v 1939.505n 3.3v 1949.495n 3.3v 1949.505n 3.3v 1959.495n 3.3v 1959.505n 0.0v 1969.495n 0.0v 1969.505n 0.0v 1979.495n 0.0v 1979.505n 0.0v 1989.495n 0.0v 1989.505n 3.3v 1999.495n 3.3v 1999.505n 3.3v 2009.495n 3.3v 2009.505n 3.3v 2019.495n 3.3v 2019.505n 3.3v 2029.495n 3.3v 2029.505n 3.3v 2039.495n 3.3v 2039.505n 3.3v 2049.495n 3.3v 2049.505n 3.3v )
* (time, data): [(0, 0), (10, 0), (20, 0), (30, 1), (40, 1), (50, 1), (60, 0), (70, 0), (80, 0), (90, 0), (100, 0), (110, 0), (120, 0), (130, 0), (140, 0), (150, 0), (160, 0), (170, 0), (180, 0), (190, 0), (200, 0), (210, 0), (220, 1), (230, 1), (240, 1), (250, 1), (260, 0), (270, 0), (280, 1), (290, 1), (300, 1), (310, 1), (320, 1), (330, 1), (340, 0), (350, 0), (360, 0), (370, 0), (380, 0), (390, 1), (400, 1), (410, 1), (420, 0), (430, 1), (440, 1), (450, 1), (460, 1), (470, 1), (480, 1), (490, 1), (500, 1), (510, 1), (520, 1), (530, 1), (540, 0), (550, 0), (560, 0), (570, 0), (580, 0), (590, 0), (600, 0), (610, 1), (620, 1), (630, 1), (640, 1), (650, 1), (660, 1), (670, 1), (680, 1), (690, 1), (700, 1), (710, 0), (720, 0), (730, 0), (740, 0), (750, 0), (760, 0), (770, 0), (780, 1), (790, 1), (800, 1), (810, 1), (820, 1), (830, 1), (840, 1), (850, 0), (860, 0), (870, 0), (880, 0), (890, 0), (900, 0), (910, 0), (920, 0), (930, 0), (940, 0), (950, 0), (960, 0), (970, 0), (980, 0), (990, 1), (1000, 1), (1010, 0), (1020, 1), (1030, 1), (1040, 1), (1050, 1), (1060, 1), (1070, 1), (1080, 1), (1090, 1), (1100, 1), (1110, 1), (1120, 1), (1130, 1), (1140, 1), (1150, 1), (1160, 1), (1170, 1), (1180, 1), (1190, 1), (1200, 1), (1210, 1), (1220, 1), (1230, 1), (1240, 0), (1250, 0), (1260, 0), (1270, 0), (1280, 1), (1290, 0), (1300, 0), (1310, 0), (1320, 0), (1330, 0), (1340, 1), (1350, 1), (1360, 1), (1370, 0), (1380, 0), (1390, 0), (1400, 0), (1410, 0), (1420, 0), (1430, 0), (1440, 0), (1450, 0), (1460, 1), (1470, 1), (1480, 1), (1490, 1), (1500, 0), (1510, 0), (1520, 0), (1530, 1), (1540, 1), (1550, 1), (1560, 1), (1570, 1), (1580, 1), (1590, 1), (1600, 1), (1610, 1), (1620, 1), (1630, 1), (1640, 1), (1650, 1), (1660, 1), (1670, 1), (1680, 1), (1690, 1), (1700, 1), (1710, 0), (1720, 0), (1730, 0), (1740, 0), (1750, 0), (1760, 0), (1770, 0), (1780, 0), (1790, 0), (1800, 0), (1810, 0), (1820, 0), (1830, 0), (1840, 0), (1850, 0), (1860, 0), (1870, 0), (1880, 1), (1890, 1), (1900, 0), (1910, 0), (1920, 0), (1930, 0), (1940, 0), (1950, 0), (1960, 1), (1970, 1), (1980, 1), (1990, 1), (2000, 1), (2010, 1), (2020, 1), (2030, 1), (2040, 1), (2050, 1)]
Vdin0_13  din0_13  0 PWL (0n 0.0v 9.495n 0.0v 9.505n 0.0v 19.495n 0.0v 19.505n 0.0v 29.495n 0.0v 29.505n 3.3v 39.495n 3.3v 39.505n 3.3v 49.495n 3.3v 49.505n 3.3v 59.495n 3.3v 59.505n 0.0v 69.495n 0.0v 69.505n 0.0v 79.495n 0.0v 79.505n 0.0v 89.495n 0.0v 89.505n 0.0v 99.495n 0.0v 99.505n 0.0v 109.495n 0.0v 109.505n 0.0v 119.495n 0.0v 119.505n 0.0v 129.495n 0.0v 129.505n 0.0v 139.495n 0.0v 139.505n 0.0v 149.495n 0.0v 149.505n 0.0v 159.495n 0.0v 159.505n 0.0v 169.495n 0.0v 169.505n 0.0v 179.495n 0.0v 179.505n 0.0v 189.495n 0.0v 189.505n 0.0v 199.495n 0.0v 199.505n 0.0v 209.495n 0.0v 209.505n 0.0v 219.495n 0.0v 219.505n 3.3v 229.495n 3.3v 229.505n 3.3v 239.495n 3.3v 239.505n 3.3v 249.495n 3.3v 249.505n 3.3v 259.495n 3.3v 259.505n 0.0v 269.495n 0.0v 269.505n 0.0v 279.495n 0.0v 279.505n 3.3v 289.495n 3.3v 289.505n 3.3v 299.495n 3.3v 299.505n 3.3v 309.495n 3.3v 309.505n 3.3v 319.495n 3.3v 319.505n 3.3v 329.495n 3.3v 329.505n 3.3v 339.495n 3.3v 339.505n 0.0v 349.495n 0.0v 349.505n 0.0v 359.495n 0.0v 359.505n 0.0v 369.495n 0.0v 369.505n 0.0v 379.495n 0.0v 379.505n 0.0v 389.495n 0.0v 389.505n 3.3v 399.495n 3.3v 399.505n 3.3v 409.495n 3.3v 409.505n 3.3v 419.495n 3.3v 419.505n 0.0v 429.495n 0.0v 429.505n 3.3v 439.495n 3.3v 439.505n 3.3v 449.495n 3.3v 449.505n 3.3v 459.495n 3.3v 459.505n 3.3v 469.495n 3.3v 469.505n 3.3v 479.495n 3.3v 479.505n 3.3v 489.495n 3.3v 489.505n 3.3v 499.495n 3.3v 499.505n 3.3v 509.495n 3.3v 509.505n 3.3v 519.495n 3.3v 519.505n 3.3v 529.495n 3.3v 529.505n 3.3v 539.495n 3.3v 539.505n 0.0v 549.495n 0.0v 549.505n 0.0v 559.495n 0.0v 559.505n 0.0v 569.495n 0.0v 569.505n 0.0v 579.495n 0.0v 579.505n 0.0v 589.495n 0.0v 589.505n 0.0v 599.495n 0.0v 599.505n 0.0v 609.495n 0.0v 609.505n 3.3v 619.495n 3.3v 619.505n 3.3v 629.495n 3.3v 629.505n 3.3v 639.495n 3.3v 639.505n 3.3v 649.495n 3.3v 649.505n 3.3v 659.495n 3.3v 659.505n 3.3v 669.495n 3.3v 669.505n 3.3v 679.495n 3.3v 679.505n 3.3v 689.495n 3.3v 689.505n 3.3v 699.495n 3.3v 699.505n 3.3v 709.495n 3.3v 709.505n 0.0v 719.495n 0.0v 719.505n 0.0v 729.495n 0.0v 729.505n 0.0v 739.495n 0.0v 739.505n 0.0v 749.495n 0.0v 749.505n 0.0v 759.495n 0.0v 759.505n 0.0v 769.495n 0.0v 769.505n 0.0v 779.495n 0.0v 779.505n 3.3v 789.495n 3.3v 789.505n 3.3v 799.495n 3.3v 799.505n 3.3v 809.495n 3.3v 809.505n 3.3v 819.495n 3.3v 819.505n 3.3v 829.495n 3.3v 829.505n 3.3v 839.495n 3.3v 839.505n 3.3v 849.495n 3.3v 849.505n 0.0v 859.495n 0.0v 859.505n 0.0v 869.495n 0.0v 869.505n 0.0v 879.495n 0.0v 879.505n 0.0v 889.495n 0.0v 889.505n 0.0v 899.495n 0.0v 899.505n 0.0v 909.495n 0.0v 909.505n 0.0v 919.495n 0.0v 919.505n 0.0v 929.495n 0.0v 929.505n 0.0v 939.495n 0.0v 939.505n 0.0v 949.495n 0.0v 949.505n 0.0v 959.495n 0.0v 959.505n 0.0v 969.495n 0.0v 969.505n 0.0v 979.495n 0.0v 979.505n 0.0v 989.495n 0.0v 989.505n 3.3v 999.495n 3.3v 999.505n 3.3v 1009.495n 3.3v 1009.505n 0.0v 1019.495n 0.0v 1019.505n 3.3v 1029.495n 3.3v 1029.505n 3.3v 1039.495n 3.3v 1039.505n 3.3v 1049.495n 3.3v 1049.505n 3.3v 1059.495n 3.3v 1059.505n 3.3v 1069.495n 3.3v 1069.505n 3.3v 1079.495n 3.3v 1079.505n 3.3v 1089.495n 3.3v 1089.505n 3.3v 1099.495n 3.3v 1099.505n 3.3v 1109.495n 3.3v 1109.505n 3.3v 1119.495n 3.3v 1119.505n 3.3v 1129.495n 3.3v 1129.505n 3.3v 1139.495n 3.3v 1139.505n 3.3v 1149.495n 3.3v 1149.505n 3.3v 1159.495n 3.3v 1159.505n 3.3v 1169.495n 3.3v 1169.505n 3.3v 1179.495n 3.3v 1179.505n 3.3v 1189.495n 3.3v 1189.505n 3.3v 1199.495n 3.3v 1199.505n 3.3v 1209.495n 3.3v 1209.505n 3.3v 1219.495n 3.3v 1219.505n 3.3v 1229.495n 3.3v 1229.505n 3.3v 1239.495n 3.3v 1239.505n 0.0v 1249.495n 0.0v 1249.505n 0.0v 1259.495n 0.0v 1259.505n 0.0v 1269.495n 0.0v 1269.505n 0.0v 1279.495n 0.0v 1279.505n 3.3v 1289.495n 3.3v 1289.505n 0.0v 1299.495n 0.0v 1299.505n 0.0v 1309.495n 0.0v 1309.505n 0.0v 1319.495n 0.0v 1319.505n 0.0v 1329.495n 0.0v 1329.505n 0.0v 1339.495n 0.0v 1339.505n 3.3v 1349.495n 3.3v 1349.505n 3.3v 1359.495n 3.3v 1359.505n 3.3v 1369.495n 3.3v 1369.505n 0.0v 1379.495n 0.0v 1379.505n 0.0v 1389.495n 0.0v 1389.505n 0.0v 1399.495n 0.0v 1399.505n 0.0v 1409.495n 0.0v 1409.505n 0.0v 1419.495n 0.0v 1419.505n 0.0v 1429.495n 0.0v 1429.505n 0.0v 1439.495n 0.0v 1439.505n 0.0v 1449.495n 0.0v 1449.505n 0.0v 1459.495n 0.0v 1459.505n 3.3v 1469.495n 3.3v 1469.505n 3.3v 1479.495n 3.3v 1479.505n 3.3v 1489.495n 3.3v 1489.505n 3.3v 1499.495n 3.3v 1499.505n 0.0v 1509.495n 0.0v 1509.505n 0.0v 1519.495n 0.0v 1519.505n 0.0v 1529.495n 0.0v 1529.505n 3.3v 1539.495n 3.3v 1539.505n 3.3v 1549.495n 3.3v 1549.505n 3.3v 1559.495n 3.3v 1559.505n 3.3v 1569.495n 3.3v 1569.505n 3.3v 1579.495n 3.3v 1579.505n 3.3v 1589.495n 3.3v 1589.505n 3.3v 1599.495n 3.3v 1599.505n 3.3v 1609.495n 3.3v 1609.505n 3.3v 1619.495n 3.3v 1619.505n 3.3v 1629.495n 3.3v 1629.505n 3.3v 1639.495n 3.3v 1639.505n 3.3v 1649.495n 3.3v 1649.505n 3.3v 1659.495n 3.3v 1659.505n 3.3v 1669.495n 3.3v 1669.505n 3.3v 1679.495n 3.3v 1679.505n 3.3v 1689.495n 3.3v 1689.505n 3.3v 1699.495n 3.3v 1699.505n 3.3v 1709.495n 3.3v 1709.505n 0.0v 1719.495n 0.0v 1719.505n 0.0v 1729.495n 0.0v 1729.505n 0.0v 1739.495n 0.0v 1739.505n 0.0v 1749.495n 0.0v 1749.505n 0.0v 1759.495n 0.0v 1759.505n 0.0v 1769.495n 0.0v 1769.505n 0.0v 1779.495n 0.0v 1779.505n 0.0v 1789.495n 0.0v 1789.505n 0.0v 1799.495n 0.0v 1799.505n 0.0v 1809.495n 0.0v 1809.505n 0.0v 1819.495n 0.0v 1819.505n 0.0v 1829.495n 0.0v 1829.505n 0.0v 1839.495n 0.0v 1839.505n 0.0v 1849.495n 0.0v 1849.505n 0.0v 1859.495n 0.0v 1859.505n 0.0v 1869.495n 0.0v 1869.505n 0.0v 1879.495n 0.0v 1879.505n 3.3v 1889.495n 3.3v 1889.505n 3.3v 1899.495n 3.3v 1899.505n 0.0v 1909.495n 0.0v 1909.505n 0.0v 1919.495n 0.0v 1919.505n 0.0v 1929.495n 0.0v 1929.505n 0.0v 1939.495n 0.0v 1939.505n 0.0v 1949.495n 0.0v 1949.505n 0.0v 1959.495n 0.0v 1959.505n 3.3v 1969.495n 3.3v 1969.505n 3.3v 1979.495n 3.3v 1979.505n 3.3v 1989.495n 3.3v 1989.505n 3.3v 1999.495n 3.3v 1999.505n 3.3v 2009.495n 3.3v 2009.505n 3.3v 2019.495n 3.3v 2019.505n 3.3v 2029.495n 3.3v 2029.505n 3.3v 2039.495n 3.3v 2039.505n 3.3v 2049.495n 3.3v 2049.505n 3.3v )
* (time, data): [(0, 0), (10, 0), (20, 1), (30, 1), (40, 1), (50, 1), (60, 1), (70, 1), (80, 1), (90, 1), (100, 1), (110, 1), (120, 1), (130, 1), (140, 1), (150, 1), (160, 0), (170, 0), (180, 0), (190, 0), (200, 0), (210, 0), (220, 0), (230, 0), (240, 0), (250, 0), (260, 1), (270, 0), (280, 1), (290, 1), (300, 1), (310, 1), (320, 1), (330, 1), (340, 1), (350, 1), (360, 1), (370, 1), (380, 1), (390, 0), (400, 0), (410, 0), (420, 0), (430, 0), (440, 0), (450, 0), (460, 1), (470, 0), (480, 0), (490, 0), (500, 0), (510, 0), (520, 0), (530, 1), (540, 1), (550, 1), (560, 1), (570, 1), (580, 1), (590, 1), (600, 1), (610, 0), (620, 0), (630, 0), (640, 0), (650, 0), (660, 0), (670, 0), (680, 0), (690, 0), (700, 0), (710, 1), (720, 1), (730, 1), (740, 1), (750, 1), (760, 1), (770, 1), (780, 0), (790, 1), (800, 1), (810, 1), (820, 1), (830, 1), (840, 1), (850, 0), (860, 0), (870, 0), (880, 0), (890, 0), (900, 0), (910, 0), (920, 0), (930, 0), (940, 0), (950, 0), (960, 0), (970, 0), (980, 0), (990, 1), (1000, 0), (1010, 0), (1020, 0), (1030, 0), (1040, 0), (1050, 0), (1060, 0), (1070, 1), (1080, 1), (1090, 1), (1100, 1), (1110, 1), (1120, 1), (1130, 1), (1140, 1), (1150, 0), (1160, 0), (1170, 0), (1180, 0), (1190, 0), (1200, 0), (1210, 0), (1220, 0), (1230, 0), (1240, 0), (1250, 0), (1260, 1), (1270, 1), (1280, 0), (1290, 1), (1300, 1), (1310, 1), (1320, 1), (1330, 1), (1340, 0), (1350, 0), (1360, 0), (1370, 0), (1380, 0), (1390, 0), (1400, 0), (1410, 0), (1420, 0), (1430, 0), (1440, 0), (1450, 0), (1460, 0), (1470, 0), (1480, 0), (1490, 0), (1500, 1), (1510, 1), (1520, 1), (1530, 1), (1540, 1), (1550, 1), (1560, 1), (1570, 1), (1580, 1), (1590, 1), (1600, 1), (1610, 1), (1620, 1), (1630, 1), (1640, 1), (1650, 1), (1660, 0), (1670, 0), (1680, 0), (1690, 0), (1700, 0), (1710, 1), (1720, 1), (1730, 1), (1740, 1), (1750, 1), (1760, 1), (1770, 1), (1780, 0), (1790, 0), (1800, 0), (1810, 0), (1820, 0), (1830, 0), (1840, 0), (1850, 0), (1860, 0), (1870, 0), (1880, 1), (1890, 1), (1900, 0), (1910, 0), (1920, 0), (1930, 0), (1940, 0), (1950, 0), (1960, 0), (1970, 0), (1980, 0), (1990, 1), (2000, 1), (2010, 1), (2020, 1), (2030, 1), (2040, 1), (2050, 1)]
Vdin0_14  din0_14  0 PWL (0n 0.0v 9.495n 0.0v 9.505n 0.0v 19.495n 0.0v 19.505n 3.3v 29.495n 3.3v 29.505n 3.3v 39.495n 3.3v 39.505n 3.3v 49.495n 3.3v 49.505n 3.3v 59.495n 3.3v 59.505n 3.3v 69.495n 3.3v 69.505n 3.3v 79.495n 3.3v 79.505n 3.3v 89.495n 3.3v 89.505n 3.3v 99.495n 3.3v 99.505n 3.3v 109.495n 3.3v 109.505n 3.3v 119.495n 3.3v 119.505n 3.3v 129.495n 3.3v 129.505n 3.3v 139.495n 3.3v 139.505n 3.3v 149.495n 3.3v 149.505n 3.3v 159.495n 3.3v 159.505n 0.0v 169.495n 0.0v 169.505n 0.0v 179.495n 0.0v 179.505n 0.0v 189.495n 0.0v 189.505n 0.0v 199.495n 0.0v 199.505n 0.0v 209.495n 0.0v 209.505n 0.0v 219.495n 0.0v 219.505n 0.0v 229.495n 0.0v 229.505n 0.0v 239.495n 0.0v 239.505n 0.0v 249.495n 0.0v 249.505n 0.0v 259.495n 0.0v 259.505n 3.3v 269.495n 3.3v 269.505n 0.0v 279.495n 0.0v 279.505n 3.3v 289.495n 3.3v 289.505n 3.3v 299.495n 3.3v 299.505n 3.3v 309.495n 3.3v 309.505n 3.3v 319.495n 3.3v 319.505n 3.3v 329.495n 3.3v 329.505n 3.3v 339.495n 3.3v 339.505n 3.3v 349.495n 3.3v 349.505n 3.3v 359.495n 3.3v 359.505n 3.3v 369.495n 3.3v 369.505n 3.3v 379.495n 3.3v 379.505n 3.3v 389.495n 3.3v 389.505n 0.0v 399.495n 0.0v 399.505n 0.0v 409.495n 0.0v 409.505n 0.0v 419.495n 0.0v 419.505n 0.0v 429.495n 0.0v 429.505n 0.0v 439.495n 0.0v 439.505n 0.0v 449.495n 0.0v 449.505n 0.0v 459.495n 0.0v 459.505n 3.3v 469.495n 3.3v 469.505n 0.0v 479.495n 0.0v 479.505n 0.0v 489.495n 0.0v 489.505n 0.0v 499.495n 0.0v 499.505n 0.0v 509.495n 0.0v 509.505n 0.0v 519.495n 0.0v 519.505n 0.0v 529.495n 0.0v 529.505n 3.3v 539.495n 3.3v 539.505n 3.3v 549.495n 3.3v 549.505n 3.3v 559.495n 3.3v 559.505n 3.3v 569.495n 3.3v 569.505n 3.3v 579.495n 3.3v 579.505n 3.3v 589.495n 3.3v 589.505n 3.3v 599.495n 3.3v 599.505n 3.3v 609.495n 3.3v 609.505n 0.0v 619.495n 0.0v 619.505n 0.0v 629.495n 0.0v 629.505n 0.0v 639.495n 0.0v 639.505n 0.0v 649.495n 0.0v 649.505n 0.0v 659.495n 0.0v 659.505n 0.0v 669.495n 0.0v 669.505n 0.0v 679.495n 0.0v 679.505n 0.0v 689.495n 0.0v 689.505n 0.0v 699.495n 0.0v 699.505n 0.0v 709.495n 0.0v 709.505n 3.3v 719.495n 3.3v 719.505n 3.3v 729.495n 3.3v 729.505n 3.3v 739.495n 3.3v 739.505n 3.3v 749.495n 3.3v 749.505n 3.3v 759.495n 3.3v 759.505n 3.3v 769.495n 3.3v 769.505n 3.3v 779.495n 3.3v 779.505n 0.0v 789.495n 0.0v 789.505n 3.3v 799.495n 3.3v 799.505n 3.3v 809.495n 3.3v 809.505n 3.3v 819.495n 3.3v 819.505n 3.3v 829.495n 3.3v 829.505n 3.3v 839.495n 3.3v 839.505n 3.3v 849.495n 3.3v 849.505n 0.0v 859.495n 0.0v 859.505n 0.0v 869.495n 0.0v 869.505n 0.0v 879.495n 0.0v 879.505n 0.0v 889.495n 0.0v 889.505n 0.0v 899.495n 0.0v 899.505n 0.0v 909.495n 0.0v 909.505n 0.0v 919.495n 0.0v 919.505n 0.0v 929.495n 0.0v 929.505n 0.0v 939.495n 0.0v 939.505n 0.0v 949.495n 0.0v 949.505n 0.0v 959.495n 0.0v 959.505n 0.0v 969.495n 0.0v 969.505n 0.0v 979.495n 0.0v 979.505n 0.0v 989.495n 0.0v 989.505n 3.3v 999.495n 3.3v 999.505n 0.0v 1009.495n 0.0v 1009.505n 0.0v 1019.495n 0.0v 1019.505n 0.0v 1029.495n 0.0v 1029.505n 0.0v 1039.495n 0.0v 1039.505n 0.0v 1049.495n 0.0v 1049.505n 0.0v 1059.495n 0.0v 1059.505n 0.0v 1069.495n 0.0v 1069.505n 3.3v 1079.495n 3.3v 1079.505n 3.3v 1089.495n 3.3v 1089.505n 3.3v 1099.495n 3.3v 1099.505n 3.3v 1109.495n 3.3v 1109.505n 3.3v 1119.495n 3.3v 1119.505n 3.3v 1129.495n 3.3v 1129.505n 3.3v 1139.495n 3.3v 1139.505n 3.3v 1149.495n 3.3v 1149.505n 0.0v 1159.495n 0.0v 1159.505n 0.0v 1169.495n 0.0v 1169.505n 0.0v 1179.495n 0.0v 1179.505n 0.0v 1189.495n 0.0v 1189.505n 0.0v 1199.495n 0.0v 1199.505n 0.0v 1209.495n 0.0v 1209.505n 0.0v 1219.495n 0.0v 1219.505n 0.0v 1229.495n 0.0v 1229.505n 0.0v 1239.495n 0.0v 1239.505n 0.0v 1249.495n 0.0v 1249.505n 0.0v 1259.495n 0.0v 1259.505n 3.3v 1269.495n 3.3v 1269.505n 3.3v 1279.495n 3.3v 1279.505n 0.0v 1289.495n 0.0v 1289.505n 3.3v 1299.495n 3.3v 1299.505n 3.3v 1309.495n 3.3v 1309.505n 3.3v 1319.495n 3.3v 1319.505n 3.3v 1329.495n 3.3v 1329.505n 3.3v 1339.495n 3.3v 1339.505n 0.0v 1349.495n 0.0v 1349.505n 0.0v 1359.495n 0.0v 1359.505n 0.0v 1369.495n 0.0v 1369.505n 0.0v 1379.495n 0.0v 1379.505n 0.0v 1389.495n 0.0v 1389.505n 0.0v 1399.495n 0.0v 1399.505n 0.0v 1409.495n 0.0v 1409.505n 0.0v 1419.495n 0.0v 1419.505n 0.0v 1429.495n 0.0v 1429.505n 0.0v 1439.495n 0.0v 1439.505n 0.0v 1449.495n 0.0v 1449.505n 0.0v 1459.495n 0.0v 1459.505n 0.0v 1469.495n 0.0v 1469.505n 0.0v 1479.495n 0.0v 1479.505n 0.0v 1489.495n 0.0v 1489.505n 0.0v 1499.495n 0.0v 1499.505n 3.3v 1509.495n 3.3v 1509.505n 3.3v 1519.495n 3.3v 1519.505n 3.3v 1529.495n 3.3v 1529.505n 3.3v 1539.495n 3.3v 1539.505n 3.3v 1549.495n 3.3v 1549.505n 3.3v 1559.495n 3.3v 1559.505n 3.3v 1569.495n 3.3v 1569.505n 3.3v 1579.495n 3.3v 1579.505n 3.3v 1589.495n 3.3v 1589.505n 3.3v 1599.495n 3.3v 1599.505n 3.3v 1609.495n 3.3v 1609.505n 3.3v 1619.495n 3.3v 1619.505n 3.3v 1629.495n 3.3v 1629.505n 3.3v 1639.495n 3.3v 1639.505n 3.3v 1649.495n 3.3v 1649.505n 3.3v 1659.495n 3.3v 1659.505n 0.0v 1669.495n 0.0v 1669.505n 0.0v 1679.495n 0.0v 1679.505n 0.0v 1689.495n 0.0v 1689.505n 0.0v 1699.495n 0.0v 1699.505n 0.0v 1709.495n 0.0v 1709.505n 3.3v 1719.495n 3.3v 1719.505n 3.3v 1729.495n 3.3v 1729.505n 3.3v 1739.495n 3.3v 1739.505n 3.3v 1749.495n 3.3v 1749.505n 3.3v 1759.495n 3.3v 1759.505n 3.3v 1769.495n 3.3v 1769.505n 3.3v 1779.495n 3.3v 1779.505n 0.0v 1789.495n 0.0v 1789.505n 0.0v 1799.495n 0.0v 1799.505n 0.0v 1809.495n 0.0v 1809.505n 0.0v 1819.495n 0.0v 1819.505n 0.0v 1829.495n 0.0v 1829.505n 0.0v 1839.495n 0.0v 1839.505n 0.0v 1849.495n 0.0v 1849.505n 0.0v 1859.495n 0.0v 1859.505n 0.0v 1869.495n 0.0v 1869.505n 0.0v 1879.495n 0.0v 1879.505n 3.3v 1889.495n 3.3v 1889.505n 3.3v 1899.495n 3.3v 1899.505n 0.0v 1909.495n 0.0v 1909.505n 0.0v 1919.495n 0.0v 1919.505n 0.0v 1929.495n 0.0v 1929.505n 0.0v 1939.495n 0.0v 1939.505n 0.0v 1949.495n 0.0v 1949.505n 0.0v 1959.495n 0.0v 1959.505n 0.0v 1969.495n 0.0v 1969.505n 0.0v 1979.495n 0.0v 1979.505n 0.0v 1989.495n 0.0v 1989.505n 3.3v 1999.495n 3.3v 1999.505n 3.3v 2009.495n 3.3v 2009.505n 3.3v 2019.495n 3.3v 2019.505n 3.3v 2029.495n 3.3v 2029.505n 3.3v 2039.495n 3.3v 2039.505n 3.3v 2049.495n 3.3v 2049.505n 3.3v )
* (time, data): [(0, 0), (10, 1), (20, 0), (30, 0), (40, 0), (50, 0), (60, 0), (70, 0), (80, 0), (90, 0), (100, 1), (110, 1), (120, 1), (130, 1), (140, 1), (150, 1), (160, 1), (170, 1), (180, 1), (190, 1), (200, 1), (210, 1), (220, 0), (230, 0), (240, 0), (250, 0), (260, 1), (270, 1), (280, 1), (290, 0), (300, 0), (310, 1), (320, 1), (330, 0), (340, 0), (350, 0), (360, 0), (370, 0), (380, 0), (390, 1), (400, 1), (410, 1), (420, 1), (430, 1), (440, 1), (450, 1), (460, 1), (470, 1), (480, 1), (490, 1), (500, 1), (510, 1), (520, 1), (530, 1), (540, 0), (550, 0), (560, 0), (570, 0), (580, 1), (590, 1), (600, 1), (610, 0), (620, 0), (630, 0), (640, 0), (650, 0), (660, 0), (670, 0), (680, 0), (690, 0), (700, 0), (710, 0), (720, 0), (730, 0), (740, 0), (750, 0), (760, 0), (770, 0), (780, 0), (790, 0), (800, 0), (810, 0), (820, 0), (830, 0), (840, 0), (850, 1), (860, 1), (870, 1), (880, 1), (890, 1), (900, 1), (910, 1), (920, 1), (930, 1), (940, 1), (950, 1), (960, 1), (970, 1), (980, 1), (990, 0), (1000, 1), (1010, 1), (1020, 0), (1030, 0), (1040, 0), (1050, 0), (1060, 0), (1070, 0), (1080, 0), (1090, 0), (1100, 0), (1110, 0), (1120, 0), (1130, 0), (1140, 0), (1150, 1), (1160, 1), (1170, 1), (1180, 1), (1190, 1), (1200, 1), (1210, 1), (1220, 1), (1230, 1), (1240, 1), (1250, 1), (1260, 1), (1270, 1), (1280, 0), (1290, 0), (1300, 0), (1310, 0), (1320, 0), (1330, 0), (1340, 1), (1350, 1), (1360, 1), (1370, 0), (1380, 0), (1390, 0), (1400, 0), (1410, 0), (1420, 0), (1430, 0), (1440, 0), (1450, 0), (1460, 0), (1470, 0), (1480, 0), (1490, 0), (1500, 0), (1510, 0), (1520, 0), (1530, 1), (1540, 1), (1550, 1), (1560, 1), (1570, 1), (1580, 1), (1590, 1), (1600, 1), (1610, 1), (1620, 1), (1630, 1), (1640, 1), (1650, 1), (1660, 1), (1670, 1), (1680, 1), (1690, 1), (1700, 1), (1710, 0), (1720, 0), (1730, 0), (1740, 0), (1750, 0), (1760, 0), (1770, 0), (1780, 1), (1790, 0), (1800, 0), (1810, 0), (1820, 0), (1830, 0), (1840, 0), (1850, 1), (1860, 1), (1870, 1), (1880, 1), (1890, 1), (1900, 1), (1910, 1), (1920, 1), (1930, 1), (1940, 1), (1950, 1), (1960, 1), (1970, 1), (1980, 1), (1990, 0), (2000, 0), (2010, 0), (2020, 0), (2030, 0), (2040, 0), (2050, 0)]
Vdin0_15  din0_15  0 PWL (0n 0.0v 9.495n 0.0v 9.505n 3.3v 19.495n 3.3v 19.505n 0.0v 29.495n 0.0v 29.505n 0.0v 39.495n 0.0v 39.505n 0.0v 49.495n 0.0v 49.505n 0.0v 59.495n 0.0v 59.505n 0.0v 69.495n 0.0v 69.505n 0.0v 79.495n 0.0v 79.505n 0.0v 89.495n 0.0v 89.505n 0.0v 99.495n 0.0v 99.505n 3.3v 109.495n 3.3v 109.505n 3.3v 119.495n 3.3v 119.505n 3.3v 129.495n 3.3v 129.505n 3.3v 139.495n 3.3v 139.505n 3.3v 149.495n 3.3v 149.505n 3.3v 159.495n 3.3v 159.505n 3.3v 169.495n 3.3v 169.505n 3.3v 179.495n 3.3v 179.505n 3.3v 189.495n 3.3v 189.505n 3.3v 199.495n 3.3v 199.505n 3.3v 209.495n 3.3v 209.505n 3.3v 219.495n 3.3v 219.505n 0.0v 229.495n 0.0v 229.505n 0.0v 239.495n 0.0v 239.505n 0.0v 249.495n 0.0v 249.505n 0.0v 259.495n 0.0v 259.505n 3.3v 269.495n 3.3v 269.505n 3.3v 279.495n 3.3v 279.505n 3.3v 289.495n 3.3v 289.505n 0.0v 299.495n 0.0v 299.505n 0.0v 309.495n 0.0v 309.505n 3.3v 319.495n 3.3v 319.505n 3.3v 329.495n 3.3v 329.505n 0.0v 339.495n 0.0v 339.505n 0.0v 349.495n 0.0v 349.505n 0.0v 359.495n 0.0v 359.505n 0.0v 369.495n 0.0v 369.505n 0.0v 379.495n 0.0v 379.505n 0.0v 389.495n 0.0v 389.505n 3.3v 399.495n 3.3v 399.505n 3.3v 409.495n 3.3v 409.505n 3.3v 419.495n 3.3v 419.505n 3.3v 429.495n 3.3v 429.505n 3.3v 439.495n 3.3v 439.505n 3.3v 449.495n 3.3v 449.505n 3.3v 459.495n 3.3v 459.505n 3.3v 469.495n 3.3v 469.505n 3.3v 479.495n 3.3v 479.505n 3.3v 489.495n 3.3v 489.505n 3.3v 499.495n 3.3v 499.505n 3.3v 509.495n 3.3v 509.505n 3.3v 519.495n 3.3v 519.505n 3.3v 529.495n 3.3v 529.505n 3.3v 539.495n 3.3v 539.505n 0.0v 549.495n 0.0v 549.505n 0.0v 559.495n 0.0v 559.505n 0.0v 569.495n 0.0v 569.505n 0.0v 579.495n 0.0v 579.505n 3.3v 589.495n 3.3v 589.505n 3.3v 599.495n 3.3v 599.505n 3.3v 609.495n 3.3v 609.505n 0.0v 619.495n 0.0v 619.505n 0.0v 629.495n 0.0v 629.505n 0.0v 639.495n 0.0v 639.505n 0.0v 649.495n 0.0v 649.505n 0.0v 659.495n 0.0v 659.505n 0.0v 669.495n 0.0v 669.505n 0.0v 679.495n 0.0v 679.505n 0.0v 689.495n 0.0v 689.505n 0.0v 699.495n 0.0v 699.505n 0.0v 709.495n 0.0v 709.505n 0.0v 719.495n 0.0v 719.505n 0.0v 729.495n 0.0v 729.505n 0.0v 739.495n 0.0v 739.505n 0.0v 749.495n 0.0v 749.505n 0.0v 759.495n 0.0v 759.505n 0.0v 769.495n 0.0v 769.505n 0.0v 779.495n 0.0v 779.505n 0.0v 789.495n 0.0v 789.505n 0.0v 799.495n 0.0v 799.505n 0.0v 809.495n 0.0v 809.505n 0.0v 819.495n 0.0v 819.505n 0.0v 829.495n 0.0v 829.505n 0.0v 839.495n 0.0v 839.505n 0.0v 849.495n 0.0v 849.505n 3.3v 859.495n 3.3v 859.505n 3.3v 869.495n 3.3v 869.505n 3.3v 879.495n 3.3v 879.505n 3.3v 889.495n 3.3v 889.505n 3.3v 899.495n 3.3v 899.505n 3.3v 909.495n 3.3v 909.505n 3.3v 919.495n 3.3v 919.505n 3.3v 929.495n 3.3v 929.505n 3.3v 939.495n 3.3v 939.505n 3.3v 949.495n 3.3v 949.505n 3.3v 959.495n 3.3v 959.505n 3.3v 969.495n 3.3v 969.505n 3.3v 979.495n 3.3v 979.505n 3.3v 989.495n 3.3v 989.505n 0.0v 999.495n 0.0v 999.505n 3.3v 1009.495n 3.3v 1009.505n 3.3v 1019.495n 3.3v 1019.505n 0.0v 1029.495n 0.0v 1029.505n 0.0v 1039.495n 0.0v 1039.505n 0.0v 1049.495n 0.0v 1049.505n 0.0v 1059.495n 0.0v 1059.505n 0.0v 1069.495n 0.0v 1069.505n 0.0v 1079.495n 0.0v 1079.505n 0.0v 1089.495n 0.0v 1089.505n 0.0v 1099.495n 0.0v 1099.505n 0.0v 1109.495n 0.0v 1109.505n 0.0v 1119.495n 0.0v 1119.505n 0.0v 1129.495n 0.0v 1129.505n 0.0v 1139.495n 0.0v 1139.505n 0.0v 1149.495n 0.0v 1149.505n 3.3v 1159.495n 3.3v 1159.505n 3.3v 1169.495n 3.3v 1169.505n 3.3v 1179.495n 3.3v 1179.505n 3.3v 1189.495n 3.3v 1189.505n 3.3v 1199.495n 3.3v 1199.505n 3.3v 1209.495n 3.3v 1209.505n 3.3v 1219.495n 3.3v 1219.505n 3.3v 1229.495n 3.3v 1229.505n 3.3v 1239.495n 3.3v 1239.505n 3.3v 1249.495n 3.3v 1249.505n 3.3v 1259.495n 3.3v 1259.505n 3.3v 1269.495n 3.3v 1269.505n 3.3v 1279.495n 3.3v 1279.505n 0.0v 1289.495n 0.0v 1289.505n 0.0v 1299.495n 0.0v 1299.505n 0.0v 1309.495n 0.0v 1309.505n 0.0v 1319.495n 0.0v 1319.505n 0.0v 1329.495n 0.0v 1329.505n 0.0v 1339.495n 0.0v 1339.505n 3.3v 1349.495n 3.3v 1349.505n 3.3v 1359.495n 3.3v 1359.505n 3.3v 1369.495n 3.3v 1369.505n 0.0v 1379.495n 0.0v 1379.505n 0.0v 1389.495n 0.0v 1389.505n 0.0v 1399.495n 0.0v 1399.505n 0.0v 1409.495n 0.0v 1409.505n 0.0v 1419.495n 0.0v 1419.505n 0.0v 1429.495n 0.0v 1429.505n 0.0v 1439.495n 0.0v 1439.505n 0.0v 1449.495n 0.0v 1449.505n 0.0v 1459.495n 0.0v 1459.505n 0.0v 1469.495n 0.0v 1469.505n 0.0v 1479.495n 0.0v 1479.505n 0.0v 1489.495n 0.0v 1489.505n 0.0v 1499.495n 0.0v 1499.505n 0.0v 1509.495n 0.0v 1509.505n 0.0v 1519.495n 0.0v 1519.505n 0.0v 1529.495n 0.0v 1529.505n 3.3v 1539.495n 3.3v 1539.505n 3.3v 1549.495n 3.3v 1549.505n 3.3v 1559.495n 3.3v 1559.505n 3.3v 1569.495n 3.3v 1569.505n 3.3v 1579.495n 3.3v 1579.505n 3.3v 1589.495n 3.3v 1589.505n 3.3v 1599.495n 3.3v 1599.505n 3.3v 1609.495n 3.3v 1609.505n 3.3v 1619.495n 3.3v 1619.505n 3.3v 1629.495n 3.3v 1629.505n 3.3v 1639.495n 3.3v 1639.505n 3.3v 1649.495n 3.3v 1649.505n 3.3v 1659.495n 3.3v 1659.505n 3.3v 1669.495n 3.3v 1669.505n 3.3v 1679.495n 3.3v 1679.505n 3.3v 1689.495n 3.3v 1689.505n 3.3v 1699.495n 3.3v 1699.505n 3.3v 1709.495n 3.3v 1709.505n 0.0v 1719.495n 0.0v 1719.505n 0.0v 1729.495n 0.0v 1729.505n 0.0v 1739.495n 0.0v 1739.505n 0.0v 1749.495n 0.0v 1749.505n 0.0v 1759.495n 0.0v 1759.505n 0.0v 1769.495n 0.0v 1769.505n 0.0v 1779.495n 0.0v 1779.505n 3.3v 1789.495n 3.3v 1789.505n 0.0v 1799.495n 0.0v 1799.505n 0.0v 1809.495n 0.0v 1809.505n 0.0v 1819.495n 0.0v 1819.505n 0.0v 1829.495n 0.0v 1829.505n 0.0v 1839.495n 0.0v 1839.505n 0.0v 1849.495n 0.0v 1849.505n 3.3v 1859.495n 3.3v 1859.505n 3.3v 1869.495n 3.3v 1869.505n 3.3v 1879.495n 3.3v 1879.505n 3.3v 1889.495n 3.3v 1889.505n 3.3v 1899.495n 3.3v 1899.505n 3.3v 1909.495n 3.3v 1909.505n 3.3v 1919.495n 3.3v 1919.505n 3.3v 1929.495n 3.3v 1929.505n 3.3v 1939.495n 3.3v 1939.505n 3.3v 1949.495n 3.3v 1949.505n 3.3v 1959.495n 3.3v 1959.505n 3.3v 1969.495n 3.3v 1969.505n 3.3v 1979.495n 3.3v 1979.505n 3.3v 1989.495n 3.3v 1989.505n 0.0v 1999.495n 0.0v 1999.505n 0.0v 2009.495n 0.0v 2009.505n 0.0v 2019.495n 0.0v 2019.505n 0.0v 2029.495n 0.0v 2029.505n 0.0v 2039.495n 0.0v 2039.505n 0.0v 2049.495n 0.0v 2049.505n 0.0v )
* (time, data): [(0, 0), (10, 0), (20, 0), (30, 1), (40, 1), (50, 1), (60, 1), (70, 1), (80, 1), (90, 1), (100, 1), (110, 1), (120, 1), (130, 1), (140, 1), (150, 1), (160, 0), (170, 0), (180, 0), (190, 0), (200, 0), (210, 0), (220, 1), (230, 1), (240, 1), (250, 1), (260, 1), (270, 0), (280, 0), (290, 1), (300, 1), (310, 1), (320, 1), (330, 1), (340, 1), (350, 1), (360, 1), (370, 1), (380, 1), (390, 0), (400, 0), (410, 0), (420, 1), (430, 1), (440, 1), (450, 1), (460, 1), (470, 0), (480, 0), (490, 0), (500, 0), (510, 0), (520, 0), (530, 0), (540, 0), (550, 0), (560, 0), (570, 0), (580, 0), (590, 0), (600, 0), (610, 0), (620, 0), (630, 0), (640, 0), (650, 0), (660, 0), (670, 0), (680, 0), (690, 0), (700, 0), (710, 1), (720, 1), (730, 1), (740, 1), (750, 1), (760, 1), (770, 1), (780, 0), (790, 1), (800, 1), (810, 1), (820, 1), (830, 1), (840, 1), (850, 0), (860, 0), (870, 0), (880, 0), (890, 0), (900, 0), (910, 0), (920, 0), (930, 0), (940, 0), (950, 0), (960, 0), (970, 0), (980, 0), (990, 0), (1000, 1), (1010, 1), (1020, 1), (1030, 1), (1040, 1), (1050, 1), (1060, 1), (1070, 1), (1080, 1), (1090, 1), (1100, 1), (1110, 1), (1120, 1), (1130, 1), (1140, 1), (1150, 0), (1160, 0), (1170, 0), (1180, 0), (1190, 0), (1200, 0), (1210, 0), (1220, 0), (1230, 0), (1240, 0), (1250, 0), (1260, 1), (1270, 1), (1280, 0), (1290, 0), (1300, 0), (1310, 0), (1320, 0), (1330, 0), (1340, 1), (1350, 1), (1360, 1), (1370, 0), (1380, 0), (1390, 0), (1400, 0), (1410, 0), (1420, 0), (1430, 0), (1440, 0), (1450, 0), (1460, 0), (1470, 0), (1480, 0), (1490, 0), (1500, 0), (1510, 0), (1520, 0), (1530, 0), (1540, 0), (1550, 0), (1560, 0), (1570, 0), (1580, 0), (1590, 0), (1600, 0), (1610, 0), (1620, 0), (1630, 0), (1640, 0), (1650, 0), (1660, 1), (1670, 1), (1680, 1), (1690, 1), (1700, 1), (1710, 0), (1720, 0), (1730, 0), (1740, 0), (1750, 0), (1760, 0), (1770, 0), (1780, 0), (1790, 1), (1800, 1), (1810, 1), (1820, 1), (1830, 1), (1840, 1), (1850, 0), (1860, 0), (1870, 0), (1880, 1), (1890, 1), (1900, 1), (1910, 1), (1920, 1), (1930, 1), (1940, 1), (1950, 1), (1960, 1), (1970, 1), (1980, 1), (1990, 1), (2000, 1), (2010, 1), (2020, 1), (2030, 1), (2040, 1), (2050, 1)]
Vdin0_16  din0_16  0 PWL (0n 0.0v 9.495n 0.0v 9.505n 0.0v 19.495n 0.0v 19.505n 0.0v 29.495n 0.0v 29.505n 3.3v 39.495n 3.3v 39.505n 3.3v 49.495n 3.3v 49.505n 3.3v 59.495n 3.3v 59.505n 3.3v 69.495n 3.3v 69.505n 3.3v 79.495n 3.3v 79.505n 3.3v 89.495n 3.3v 89.505n 3.3v 99.495n 3.3v 99.505n 3.3v 109.495n 3.3v 109.505n 3.3v 119.495n 3.3v 119.505n 3.3v 129.495n 3.3v 129.505n 3.3v 139.495n 3.3v 139.505n 3.3v 149.495n 3.3v 149.505n 3.3v 159.495n 3.3v 159.505n 0.0v 169.495n 0.0v 169.505n 0.0v 179.495n 0.0v 179.505n 0.0v 189.495n 0.0v 189.505n 0.0v 199.495n 0.0v 199.505n 0.0v 209.495n 0.0v 209.505n 0.0v 219.495n 0.0v 219.505n 3.3v 229.495n 3.3v 229.505n 3.3v 239.495n 3.3v 239.505n 3.3v 249.495n 3.3v 249.505n 3.3v 259.495n 3.3v 259.505n 3.3v 269.495n 3.3v 269.505n 0.0v 279.495n 0.0v 279.505n 0.0v 289.495n 0.0v 289.505n 3.3v 299.495n 3.3v 299.505n 3.3v 309.495n 3.3v 309.505n 3.3v 319.495n 3.3v 319.505n 3.3v 329.495n 3.3v 329.505n 3.3v 339.495n 3.3v 339.505n 3.3v 349.495n 3.3v 349.505n 3.3v 359.495n 3.3v 359.505n 3.3v 369.495n 3.3v 369.505n 3.3v 379.495n 3.3v 379.505n 3.3v 389.495n 3.3v 389.505n 0.0v 399.495n 0.0v 399.505n 0.0v 409.495n 0.0v 409.505n 0.0v 419.495n 0.0v 419.505n 3.3v 429.495n 3.3v 429.505n 3.3v 439.495n 3.3v 439.505n 3.3v 449.495n 3.3v 449.505n 3.3v 459.495n 3.3v 459.505n 3.3v 469.495n 3.3v 469.505n 0.0v 479.495n 0.0v 479.505n 0.0v 489.495n 0.0v 489.505n 0.0v 499.495n 0.0v 499.505n 0.0v 509.495n 0.0v 509.505n 0.0v 519.495n 0.0v 519.505n 0.0v 529.495n 0.0v 529.505n 0.0v 539.495n 0.0v 539.505n 0.0v 549.495n 0.0v 549.505n 0.0v 559.495n 0.0v 559.505n 0.0v 569.495n 0.0v 569.505n 0.0v 579.495n 0.0v 579.505n 0.0v 589.495n 0.0v 589.505n 0.0v 599.495n 0.0v 599.505n 0.0v 609.495n 0.0v 609.505n 0.0v 619.495n 0.0v 619.505n 0.0v 629.495n 0.0v 629.505n 0.0v 639.495n 0.0v 639.505n 0.0v 649.495n 0.0v 649.505n 0.0v 659.495n 0.0v 659.505n 0.0v 669.495n 0.0v 669.505n 0.0v 679.495n 0.0v 679.505n 0.0v 689.495n 0.0v 689.505n 0.0v 699.495n 0.0v 699.505n 0.0v 709.495n 0.0v 709.505n 3.3v 719.495n 3.3v 719.505n 3.3v 729.495n 3.3v 729.505n 3.3v 739.495n 3.3v 739.505n 3.3v 749.495n 3.3v 749.505n 3.3v 759.495n 3.3v 759.505n 3.3v 769.495n 3.3v 769.505n 3.3v 779.495n 3.3v 779.505n 0.0v 789.495n 0.0v 789.505n 3.3v 799.495n 3.3v 799.505n 3.3v 809.495n 3.3v 809.505n 3.3v 819.495n 3.3v 819.505n 3.3v 829.495n 3.3v 829.505n 3.3v 839.495n 3.3v 839.505n 3.3v 849.495n 3.3v 849.505n 0.0v 859.495n 0.0v 859.505n 0.0v 869.495n 0.0v 869.505n 0.0v 879.495n 0.0v 879.505n 0.0v 889.495n 0.0v 889.505n 0.0v 899.495n 0.0v 899.505n 0.0v 909.495n 0.0v 909.505n 0.0v 919.495n 0.0v 919.505n 0.0v 929.495n 0.0v 929.505n 0.0v 939.495n 0.0v 939.505n 0.0v 949.495n 0.0v 949.505n 0.0v 959.495n 0.0v 959.505n 0.0v 969.495n 0.0v 969.505n 0.0v 979.495n 0.0v 979.505n 0.0v 989.495n 0.0v 989.505n 0.0v 999.495n 0.0v 999.505n 3.3v 1009.495n 3.3v 1009.505n 3.3v 1019.495n 3.3v 1019.505n 3.3v 1029.495n 3.3v 1029.505n 3.3v 1039.495n 3.3v 1039.505n 3.3v 1049.495n 3.3v 1049.505n 3.3v 1059.495n 3.3v 1059.505n 3.3v 1069.495n 3.3v 1069.505n 3.3v 1079.495n 3.3v 1079.505n 3.3v 1089.495n 3.3v 1089.505n 3.3v 1099.495n 3.3v 1099.505n 3.3v 1109.495n 3.3v 1109.505n 3.3v 1119.495n 3.3v 1119.505n 3.3v 1129.495n 3.3v 1129.505n 3.3v 1139.495n 3.3v 1139.505n 3.3v 1149.495n 3.3v 1149.505n 0.0v 1159.495n 0.0v 1159.505n 0.0v 1169.495n 0.0v 1169.505n 0.0v 1179.495n 0.0v 1179.505n 0.0v 1189.495n 0.0v 1189.505n 0.0v 1199.495n 0.0v 1199.505n 0.0v 1209.495n 0.0v 1209.505n 0.0v 1219.495n 0.0v 1219.505n 0.0v 1229.495n 0.0v 1229.505n 0.0v 1239.495n 0.0v 1239.505n 0.0v 1249.495n 0.0v 1249.505n 0.0v 1259.495n 0.0v 1259.505n 3.3v 1269.495n 3.3v 1269.505n 3.3v 1279.495n 3.3v 1279.505n 0.0v 1289.495n 0.0v 1289.505n 0.0v 1299.495n 0.0v 1299.505n 0.0v 1309.495n 0.0v 1309.505n 0.0v 1319.495n 0.0v 1319.505n 0.0v 1329.495n 0.0v 1329.505n 0.0v 1339.495n 0.0v 1339.505n 3.3v 1349.495n 3.3v 1349.505n 3.3v 1359.495n 3.3v 1359.505n 3.3v 1369.495n 3.3v 1369.505n 0.0v 1379.495n 0.0v 1379.505n 0.0v 1389.495n 0.0v 1389.505n 0.0v 1399.495n 0.0v 1399.505n 0.0v 1409.495n 0.0v 1409.505n 0.0v 1419.495n 0.0v 1419.505n 0.0v 1429.495n 0.0v 1429.505n 0.0v 1439.495n 0.0v 1439.505n 0.0v 1449.495n 0.0v 1449.505n 0.0v 1459.495n 0.0v 1459.505n 0.0v 1469.495n 0.0v 1469.505n 0.0v 1479.495n 0.0v 1479.505n 0.0v 1489.495n 0.0v 1489.505n 0.0v 1499.495n 0.0v 1499.505n 0.0v 1509.495n 0.0v 1509.505n 0.0v 1519.495n 0.0v 1519.505n 0.0v 1529.495n 0.0v 1529.505n 0.0v 1539.495n 0.0v 1539.505n 0.0v 1549.495n 0.0v 1549.505n 0.0v 1559.495n 0.0v 1559.505n 0.0v 1569.495n 0.0v 1569.505n 0.0v 1579.495n 0.0v 1579.505n 0.0v 1589.495n 0.0v 1589.505n 0.0v 1599.495n 0.0v 1599.505n 0.0v 1609.495n 0.0v 1609.505n 0.0v 1619.495n 0.0v 1619.505n 0.0v 1629.495n 0.0v 1629.505n 0.0v 1639.495n 0.0v 1639.505n 0.0v 1649.495n 0.0v 1649.505n 0.0v 1659.495n 0.0v 1659.505n 3.3v 1669.495n 3.3v 1669.505n 3.3v 1679.495n 3.3v 1679.505n 3.3v 1689.495n 3.3v 1689.505n 3.3v 1699.495n 3.3v 1699.505n 3.3v 1709.495n 3.3v 1709.505n 0.0v 1719.495n 0.0v 1719.505n 0.0v 1729.495n 0.0v 1729.505n 0.0v 1739.495n 0.0v 1739.505n 0.0v 1749.495n 0.0v 1749.505n 0.0v 1759.495n 0.0v 1759.505n 0.0v 1769.495n 0.0v 1769.505n 0.0v 1779.495n 0.0v 1779.505n 0.0v 1789.495n 0.0v 1789.505n 3.3v 1799.495n 3.3v 1799.505n 3.3v 1809.495n 3.3v 1809.505n 3.3v 1819.495n 3.3v 1819.505n 3.3v 1829.495n 3.3v 1829.505n 3.3v 1839.495n 3.3v 1839.505n 3.3v 1849.495n 3.3v 1849.505n 0.0v 1859.495n 0.0v 1859.505n 0.0v 1869.495n 0.0v 1869.505n 0.0v 1879.495n 0.0v 1879.505n 3.3v 1889.495n 3.3v 1889.505n 3.3v 1899.495n 3.3v 1899.505n 3.3v 1909.495n 3.3v 1909.505n 3.3v 1919.495n 3.3v 1919.505n 3.3v 1929.495n 3.3v 1929.505n 3.3v 1939.495n 3.3v 1939.505n 3.3v 1949.495n 3.3v 1949.505n 3.3v 1959.495n 3.3v 1959.505n 3.3v 1969.495n 3.3v 1969.505n 3.3v 1979.495n 3.3v 1979.505n 3.3v 1989.495n 3.3v 1989.505n 3.3v 1999.495n 3.3v 1999.505n 3.3v 2009.495n 3.3v 2009.505n 3.3v 2019.495n 3.3v 2019.505n 3.3v 2029.495n 3.3v 2029.505n 3.3v 2039.495n 3.3v 2039.505n 3.3v 2049.495n 3.3v 2049.505n 3.3v )
* (time, data): [(0, 0), (10, 1), (20, 0), (30, 0), (40, 0), (50, 0), (60, 0), (70, 0), (80, 0), (90, 0), (100, 1), (110, 1), (120, 1), (130, 1), (140, 1), (150, 1), (160, 1), (170, 1), (180, 1), (190, 1), (200, 1), (210, 1), (220, 0), (230, 0), (240, 0), (250, 0), (260, 0), (270, 0), (280, 0), (290, 0), (300, 0), (310, 1), (320, 1), (330, 0), (340, 0), (350, 0), (360, 0), (370, 0), (380, 0), (390, 0), (400, 0), (410, 0), (420, 1), (430, 1), (440, 1), (450, 1), (460, 0), (470, 1), (480, 1), (490, 1), (500, 1), (510, 1), (520, 1), (530, 0), (540, 1), (550, 1), (560, 1), (570, 1), (580, 0), (590, 0), (600, 0), (610, 1), (620, 1), (630, 1), (640, 1), (650, 1), (660, 1), (670, 1), (680, 1), (690, 1), (700, 1), (710, 0), (720, 0), (730, 0), (740, 0), (750, 0), (760, 0), (770, 0), (780, 0), (790, 1), (800, 1), (810, 1), (820, 1), (830, 1), (840, 1), (850, 1), (860, 1), (870, 1), (880, 1), (890, 1), (900, 1), (910, 1), (920, 1), (930, 1), (940, 1), (950, 1), (960, 1), (970, 1), (980, 1), (990, 1), (1000, 1), (1010, 1), (1020, 1), (1030, 1), (1040, 1), (1050, 0), (1060, 0), (1070, 1), (1080, 1), (1090, 1), (1100, 1), (1110, 1), (1120, 1), (1130, 1), (1140, 1), (1150, 0), (1160, 0), (1170, 0), (1180, 0), (1190, 0), (1200, 0), (1210, 0), (1220, 0), (1230, 0), (1240, 1), (1250, 1), (1260, 0), (1270, 0), (1280, 0), (1290, 1), (1300, 1), (1310, 1), (1320, 1), (1330, 1), (1340, 0), (1350, 0), (1360, 0), (1370, 1), (1380, 1), (1390, 1), (1400, 1), (1410, 1), (1420, 1), (1430, 1), (1440, 1), (1450, 1), (1460, 1), (1470, 1), (1480, 1), (1490, 1), (1500, 1), (1510, 1), (1520, 1), (1530, 0), (1540, 0), (1550, 0), (1560, 0), (1570, 0), (1580, 0), (1590, 0), (1600, 0), (1610, 0), (1620, 0), (1630, 0), (1640, 0), (1650, 0), (1660, 1), (1670, 1), (1680, 1), (1690, 1), (1700, 1), (1710, 1), (1720, 1), (1730, 1), (1740, 1), (1750, 1), (1760, 1), (1770, 1), (1780, 1), (1790, 1), (1800, 1), (1810, 1), (1820, 1), (1830, 1), (1840, 1), (1850, 1), (1860, 1), (1870, 1), (1880, 0), (1890, 0), (1900, 0), (1910, 0), (1920, 0), (1930, 0), (1940, 0), (1950, 0), (1960, 0), (1970, 0), (1980, 0), (1990, 0), (2000, 0), (2010, 0), (2020, 0), (2030, 0), (2040, 0), (2050, 0)]
Vdin0_17  din0_17  0 PWL (0n 0.0v 9.495n 0.0v 9.505n 3.3v 19.495n 3.3v 19.505n 0.0v 29.495n 0.0v 29.505n 0.0v 39.495n 0.0v 39.505n 0.0v 49.495n 0.0v 49.505n 0.0v 59.495n 0.0v 59.505n 0.0v 69.495n 0.0v 69.505n 0.0v 79.495n 0.0v 79.505n 0.0v 89.495n 0.0v 89.505n 0.0v 99.495n 0.0v 99.505n 3.3v 109.495n 3.3v 109.505n 3.3v 119.495n 3.3v 119.505n 3.3v 129.495n 3.3v 129.505n 3.3v 139.495n 3.3v 139.505n 3.3v 149.495n 3.3v 149.505n 3.3v 159.495n 3.3v 159.505n 3.3v 169.495n 3.3v 169.505n 3.3v 179.495n 3.3v 179.505n 3.3v 189.495n 3.3v 189.505n 3.3v 199.495n 3.3v 199.505n 3.3v 209.495n 3.3v 209.505n 3.3v 219.495n 3.3v 219.505n 0.0v 229.495n 0.0v 229.505n 0.0v 239.495n 0.0v 239.505n 0.0v 249.495n 0.0v 249.505n 0.0v 259.495n 0.0v 259.505n 0.0v 269.495n 0.0v 269.505n 0.0v 279.495n 0.0v 279.505n 0.0v 289.495n 0.0v 289.505n 0.0v 299.495n 0.0v 299.505n 0.0v 309.495n 0.0v 309.505n 3.3v 319.495n 3.3v 319.505n 3.3v 329.495n 3.3v 329.505n 0.0v 339.495n 0.0v 339.505n 0.0v 349.495n 0.0v 349.505n 0.0v 359.495n 0.0v 359.505n 0.0v 369.495n 0.0v 369.505n 0.0v 379.495n 0.0v 379.505n 0.0v 389.495n 0.0v 389.505n 0.0v 399.495n 0.0v 399.505n 0.0v 409.495n 0.0v 409.505n 0.0v 419.495n 0.0v 419.505n 3.3v 429.495n 3.3v 429.505n 3.3v 439.495n 3.3v 439.505n 3.3v 449.495n 3.3v 449.505n 3.3v 459.495n 3.3v 459.505n 0.0v 469.495n 0.0v 469.505n 3.3v 479.495n 3.3v 479.505n 3.3v 489.495n 3.3v 489.505n 3.3v 499.495n 3.3v 499.505n 3.3v 509.495n 3.3v 509.505n 3.3v 519.495n 3.3v 519.505n 3.3v 529.495n 3.3v 529.505n 0.0v 539.495n 0.0v 539.505n 3.3v 549.495n 3.3v 549.505n 3.3v 559.495n 3.3v 559.505n 3.3v 569.495n 3.3v 569.505n 3.3v 579.495n 3.3v 579.505n 0.0v 589.495n 0.0v 589.505n 0.0v 599.495n 0.0v 599.505n 0.0v 609.495n 0.0v 609.505n 3.3v 619.495n 3.3v 619.505n 3.3v 629.495n 3.3v 629.505n 3.3v 639.495n 3.3v 639.505n 3.3v 649.495n 3.3v 649.505n 3.3v 659.495n 3.3v 659.505n 3.3v 669.495n 3.3v 669.505n 3.3v 679.495n 3.3v 679.505n 3.3v 689.495n 3.3v 689.505n 3.3v 699.495n 3.3v 699.505n 3.3v 709.495n 3.3v 709.505n 0.0v 719.495n 0.0v 719.505n 0.0v 729.495n 0.0v 729.505n 0.0v 739.495n 0.0v 739.505n 0.0v 749.495n 0.0v 749.505n 0.0v 759.495n 0.0v 759.505n 0.0v 769.495n 0.0v 769.505n 0.0v 779.495n 0.0v 779.505n 0.0v 789.495n 0.0v 789.505n 3.3v 799.495n 3.3v 799.505n 3.3v 809.495n 3.3v 809.505n 3.3v 819.495n 3.3v 819.505n 3.3v 829.495n 3.3v 829.505n 3.3v 839.495n 3.3v 839.505n 3.3v 849.495n 3.3v 849.505n 3.3v 859.495n 3.3v 859.505n 3.3v 869.495n 3.3v 869.505n 3.3v 879.495n 3.3v 879.505n 3.3v 889.495n 3.3v 889.505n 3.3v 899.495n 3.3v 899.505n 3.3v 909.495n 3.3v 909.505n 3.3v 919.495n 3.3v 919.505n 3.3v 929.495n 3.3v 929.505n 3.3v 939.495n 3.3v 939.505n 3.3v 949.495n 3.3v 949.505n 3.3v 959.495n 3.3v 959.505n 3.3v 969.495n 3.3v 969.505n 3.3v 979.495n 3.3v 979.505n 3.3v 989.495n 3.3v 989.505n 3.3v 999.495n 3.3v 999.505n 3.3v 1009.495n 3.3v 1009.505n 3.3v 1019.495n 3.3v 1019.505n 3.3v 1029.495n 3.3v 1029.505n 3.3v 1039.495n 3.3v 1039.505n 3.3v 1049.495n 3.3v 1049.505n 0.0v 1059.495n 0.0v 1059.505n 0.0v 1069.495n 0.0v 1069.505n 3.3v 1079.495n 3.3v 1079.505n 3.3v 1089.495n 3.3v 1089.505n 3.3v 1099.495n 3.3v 1099.505n 3.3v 1109.495n 3.3v 1109.505n 3.3v 1119.495n 3.3v 1119.505n 3.3v 1129.495n 3.3v 1129.505n 3.3v 1139.495n 3.3v 1139.505n 3.3v 1149.495n 3.3v 1149.505n 0.0v 1159.495n 0.0v 1159.505n 0.0v 1169.495n 0.0v 1169.505n 0.0v 1179.495n 0.0v 1179.505n 0.0v 1189.495n 0.0v 1189.505n 0.0v 1199.495n 0.0v 1199.505n 0.0v 1209.495n 0.0v 1209.505n 0.0v 1219.495n 0.0v 1219.505n 0.0v 1229.495n 0.0v 1229.505n 0.0v 1239.495n 0.0v 1239.505n 3.3v 1249.495n 3.3v 1249.505n 3.3v 1259.495n 3.3v 1259.505n 0.0v 1269.495n 0.0v 1269.505n 0.0v 1279.495n 0.0v 1279.505n 0.0v 1289.495n 0.0v 1289.505n 3.3v 1299.495n 3.3v 1299.505n 3.3v 1309.495n 3.3v 1309.505n 3.3v 1319.495n 3.3v 1319.505n 3.3v 1329.495n 3.3v 1329.505n 3.3v 1339.495n 3.3v 1339.505n 0.0v 1349.495n 0.0v 1349.505n 0.0v 1359.495n 0.0v 1359.505n 0.0v 1369.495n 0.0v 1369.505n 3.3v 1379.495n 3.3v 1379.505n 3.3v 1389.495n 3.3v 1389.505n 3.3v 1399.495n 3.3v 1399.505n 3.3v 1409.495n 3.3v 1409.505n 3.3v 1419.495n 3.3v 1419.505n 3.3v 1429.495n 3.3v 1429.505n 3.3v 1439.495n 3.3v 1439.505n 3.3v 1449.495n 3.3v 1449.505n 3.3v 1459.495n 3.3v 1459.505n 3.3v 1469.495n 3.3v 1469.505n 3.3v 1479.495n 3.3v 1479.505n 3.3v 1489.495n 3.3v 1489.505n 3.3v 1499.495n 3.3v 1499.505n 3.3v 1509.495n 3.3v 1509.505n 3.3v 1519.495n 3.3v 1519.505n 3.3v 1529.495n 3.3v 1529.505n 0.0v 1539.495n 0.0v 1539.505n 0.0v 1549.495n 0.0v 1549.505n 0.0v 1559.495n 0.0v 1559.505n 0.0v 1569.495n 0.0v 1569.505n 0.0v 1579.495n 0.0v 1579.505n 0.0v 1589.495n 0.0v 1589.505n 0.0v 1599.495n 0.0v 1599.505n 0.0v 1609.495n 0.0v 1609.505n 0.0v 1619.495n 0.0v 1619.505n 0.0v 1629.495n 0.0v 1629.505n 0.0v 1639.495n 0.0v 1639.505n 0.0v 1649.495n 0.0v 1649.505n 0.0v 1659.495n 0.0v 1659.505n 3.3v 1669.495n 3.3v 1669.505n 3.3v 1679.495n 3.3v 1679.505n 3.3v 1689.495n 3.3v 1689.505n 3.3v 1699.495n 3.3v 1699.505n 3.3v 1709.495n 3.3v 1709.505n 3.3v 1719.495n 3.3v 1719.505n 3.3v 1729.495n 3.3v 1729.505n 3.3v 1739.495n 3.3v 1739.505n 3.3v 1749.495n 3.3v 1749.505n 3.3v 1759.495n 3.3v 1759.505n 3.3v 1769.495n 3.3v 1769.505n 3.3v 1779.495n 3.3v 1779.505n 3.3v 1789.495n 3.3v 1789.505n 3.3v 1799.495n 3.3v 1799.505n 3.3v 1809.495n 3.3v 1809.505n 3.3v 1819.495n 3.3v 1819.505n 3.3v 1829.495n 3.3v 1829.505n 3.3v 1839.495n 3.3v 1839.505n 3.3v 1849.495n 3.3v 1849.505n 3.3v 1859.495n 3.3v 1859.505n 3.3v 1869.495n 3.3v 1869.505n 3.3v 1879.495n 3.3v 1879.505n 0.0v 1889.495n 0.0v 1889.505n 0.0v 1899.495n 0.0v 1899.505n 0.0v 1909.495n 0.0v 1909.505n 0.0v 1919.495n 0.0v 1919.505n 0.0v 1929.495n 0.0v 1929.505n 0.0v 1939.495n 0.0v 1939.505n 0.0v 1949.495n 0.0v 1949.505n 0.0v 1959.495n 0.0v 1959.505n 0.0v 1969.495n 0.0v 1969.505n 0.0v 1979.495n 0.0v 1979.505n 0.0v 1989.495n 0.0v 1989.505n 0.0v 1999.495n 0.0v 1999.505n 0.0v 2009.495n 0.0v 2009.505n 0.0v 2019.495n 0.0v 2019.505n 0.0v 2029.495n 0.0v 2029.505n 0.0v 2039.495n 0.0v 2039.505n 0.0v 2049.495n 0.0v 2049.505n 0.0v )
* (time, data): [(0, 0), (10, 0), (20, 0), (30, 0), (40, 0), (50, 0), (60, 0), (70, 0), (80, 0), (90, 0), (100, 0), (110, 0), (120, 0), (130, 0), (140, 0), (150, 0), (160, 1), (170, 1), (180, 1), (190, 1), (200, 1), (210, 1), (220, 0), (230, 0), (240, 0), (250, 0), (260, 1), (270, 1), (280, 0), (290, 1), (300, 1), (310, 1), (320, 1), (330, 0), (340, 0), (350, 0), (360, 0), (370, 0), (380, 0), (390, 1), (400, 1), (410, 1), (420, 1), (430, 1), (440, 1), (450, 1), (460, 1), (470, 1), (480, 1), (490, 1), (500, 1), (510, 1), (520, 1), (530, 1), (540, 1), (550, 1), (560, 0), (570, 0), (580, 1), (590, 1), (600, 1), (610, 1), (620, 1), (630, 1), (640, 1), (650, 1), (660, 1), (670, 1), (680, 1), (690, 1), (700, 1), (710, 1), (720, 1), (730, 1), (740, 1), (750, 1), (760, 1), (770, 1), (780, 0), (790, 1), (800, 1), (810, 1), (820, 1), (830, 1), (840, 1), (850, 0), (860, 0), (870, 0), (880, 0), (890, 0), (900, 0), (910, 0), (920, 0), (930, 0), (940, 0), (950, 0), (960, 0), (970, 0), (980, 0), (990, 1), (1000, 0), (1010, 1), (1020, 1), (1030, 1), (1040, 1), (1050, 1), (1060, 1), (1070, 0), (1080, 0), (1090, 0), (1100, 0), (1110, 0), (1120, 0), (1130, 0), (1140, 0), (1150, 0), (1160, 0), (1170, 0), (1180, 0), (1190, 0), (1200, 0), (1210, 0), (1220, 0), (1230, 0), (1240, 0), (1250, 0), (1260, 0), (1270, 0), (1280, 0), (1290, 0), (1300, 0), (1310, 0), (1320, 0), (1330, 0), (1340, 1), (1350, 1), (1360, 1), (1370, 0), (1380, 0), (1390, 0), (1400, 0), (1410, 0), (1420, 0), (1430, 0), (1440, 0), (1450, 0), (1460, 1), (1470, 1), (1480, 1), (1490, 1), (1500, 0), (1510, 0), (1520, 0), (1530, 1), (1540, 1), (1550, 1), (1560, 1), (1570, 1), (1580, 1), (1590, 1), (1600, 1), (1610, 1), (1620, 1), (1630, 1), (1640, 1), (1650, 1), (1660, 1), (1670, 1), (1680, 1), (1690, 1), (1700, 1), (1710, 1), (1720, 1), (1730, 1), (1740, 1), (1750, 1), (1760, 1), (1770, 1), (1780, 0), (1790, 0), (1800, 0), (1810, 0), (1820, 0), (1830, 0), (1840, 0), (1850, 1), (1860, 1), (1870, 1), (1880, 0), (1890, 0), (1900, 0), (1910, 0), (1920, 0), (1930, 0), (1940, 0), (1950, 0), (1960, 0), (1970, 0), (1980, 0), (1990, 0), (2000, 0), (2010, 0), (2020, 0), (2030, 0), (2040, 0), (2050, 0)]
Vdin0_18  din0_18  0 PWL (0n 0.0v 9.495n 0.0v 9.505n 0.0v 19.495n 0.0v 19.505n 0.0v 29.495n 0.0v 29.505n 0.0v 39.495n 0.0v 39.505n 0.0v 49.495n 0.0v 49.505n 0.0v 59.495n 0.0v 59.505n 0.0v 69.495n 0.0v 69.505n 0.0v 79.495n 0.0v 79.505n 0.0v 89.495n 0.0v 89.505n 0.0v 99.495n 0.0v 99.505n 0.0v 109.495n 0.0v 109.505n 0.0v 119.495n 0.0v 119.505n 0.0v 129.495n 0.0v 129.505n 0.0v 139.495n 0.0v 139.505n 0.0v 149.495n 0.0v 149.505n 0.0v 159.495n 0.0v 159.505n 3.3v 169.495n 3.3v 169.505n 3.3v 179.495n 3.3v 179.505n 3.3v 189.495n 3.3v 189.505n 3.3v 199.495n 3.3v 199.505n 3.3v 209.495n 3.3v 209.505n 3.3v 219.495n 3.3v 219.505n 0.0v 229.495n 0.0v 229.505n 0.0v 239.495n 0.0v 239.505n 0.0v 249.495n 0.0v 249.505n 0.0v 259.495n 0.0v 259.505n 3.3v 269.495n 3.3v 269.505n 3.3v 279.495n 3.3v 279.505n 0.0v 289.495n 0.0v 289.505n 3.3v 299.495n 3.3v 299.505n 3.3v 309.495n 3.3v 309.505n 3.3v 319.495n 3.3v 319.505n 3.3v 329.495n 3.3v 329.505n 0.0v 339.495n 0.0v 339.505n 0.0v 349.495n 0.0v 349.505n 0.0v 359.495n 0.0v 359.505n 0.0v 369.495n 0.0v 369.505n 0.0v 379.495n 0.0v 379.505n 0.0v 389.495n 0.0v 389.505n 3.3v 399.495n 3.3v 399.505n 3.3v 409.495n 3.3v 409.505n 3.3v 419.495n 3.3v 419.505n 3.3v 429.495n 3.3v 429.505n 3.3v 439.495n 3.3v 439.505n 3.3v 449.495n 3.3v 449.505n 3.3v 459.495n 3.3v 459.505n 3.3v 469.495n 3.3v 469.505n 3.3v 479.495n 3.3v 479.505n 3.3v 489.495n 3.3v 489.505n 3.3v 499.495n 3.3v 499.505n 3.3v 509.495n 3.3v 509.505n 3.3v 519.495n 3.3v 519.505n 3.3v 529.495n 3.3v 529.505n 3.3v 539.495n 3.3v 539.505n 3.3v 549.495n 3.3v 549.505n 3.3v 559.495n 3.3v 559.505n 0.0v 569.495n 0.0v 569.505n 0.0v 579.495n 0.0v 579.505n 3.3v 589.495n 3.3v 589.505n 3.3v 599.495n 3.3v 599.505n 3.3v 609.495n 3.3v 609.505n 3.3v 619.495n 3.3v 619.505n 3.3v 629.495n 3.3v 629.505n 3.3v 639.495n 3.3v 639.505n 3.3v 649.495n 3.3v 649.505n 3.3v 659.495n 3.3v 659.505n 3.3v 669.495n 3.3v 669.505n 3.3v 679.495n 3.3v 679.505n 3.3v 689.495n 3.3v 689.505n 3.3v 699.495n 3.3v 699.505n 3.3v 709.495n 3.3v 709.505n 3.3v 719.495n 3.3v 719.505n 3.3v 729.495n 3.3v 729.505n 3.3v 739.495n 3.3v 739.505n 3.3v 749.495n 3.3v 749.505n 3.3v 759.495n 3.3v 759.505n 3.3v 769.495n 3.3v 769.505n 3.3v 779.495n 3.3v 779.505n 0.0v 789.495n 0.0v 789.505n 3.3v 799.495n 3.3v 799.505n 3.3v 809.495n 3.3v 809.505n 3.3v 819.495n 3.3v 819.505n 3.3v 829.495n 3.3v 829.505n 3.3v 839.495n 3.3v 839.505n 3.3v 849.495n 3.3v 849.505n 0.0v 859.495n 0.0v 859.505n 0.0v 869.495n 0.0v 869.505n 0.0v 879.495n 0.0v 879.505n 0.0v 889.495n 0.0v 889.505n 0.0v 899.495n 0.0v 899.505n 0.0v 909.495n 0.0v 909.505n 0.0v 919.495n 0.0v 919.505n 0.0v 929.495n 0.0v 929.505n 0.0v 939.495n 0.0v 939.505n 0.0v 949.495n 0.0v 949.505n 0.0v 959.495n 0.0v 959.505n 0.0v 969.495n 0.0v 969.505n 0.0v 979.495n 0.0v 979.505n 0.0v 989.495n 0.0v 989.505n 3.3v 999.495n 3.3v 999.505n 0.0v 1009.495n 0.0v 1009.505n 3.3v 1019.495n 3.3v 1019.505n 3.3v 1029.495n 3.3v 1029.505n 3.3v 1039.495n 3.3v 1039.505n 3.3v 1049.495n 3.3v 1049.505n 3.3v 1059.495n 3.3v 1059.505n 3.3v 1069.495n 3.3v 1069.505n 0.0v 1079.495n 0.0v 1079.505n 0.0v 1089.495n 0.0v 1089.505n 0.0v 1099.495n 0.0v 1099.505n 0.0v 1109.495n 0.0v 1109.505n 0.0v 1119.495n 0.0v 1119.505n 0.0v 1129.495n 0.0v 1129.505n 0.0v 1139.495n 0.0v 1139.505n 0.0v 1149.495n 0.0v 1149.505n 0.0v 1159.495n 0.0v 1159.505n 0.0v 1169.495n 0.0v 1169.505n 0.0v 1179.495n 0.0v 1179.505n 0.0v 1189.495n 0.0v 1189.505n 0.0v 1199.495n 0.0v 1199.505n 0.0v 1209.495n 0.0v 1209.505n 0.0v 1219.495n 0.0v 1219.505n 0.0v 1229.495n 0.0v 1229.505n 0.0v 1239.495n 0.0v 1239.505n 0.0v 1249.495n 0.0v 1249.505n 0.0v 1259.495n 0.0v 1259.505n 0.0v 1269.495n 0.0v 1269.505n 0.0v 1279.495n 0.0v 1279.505n 0.0v 1289.495n 0.0v 1289.505n 0.0v 1299.495n 0.0v 1299.505n 0.0v 1309.495n 0.0v 1309.505n 0.0v 1319.495n 0.0v 1319.505n 0.0v 1329.495n 0.0v 1329.505n 0.0v 1339.495n 0.0v 1339.505n 3.3v 1349.495n 3.3v 1349.505n 3.3v 1359.495n 3.3v 1359.505n 3.3v 1369.495n 3.3v 1369.505n 0.0v 1379.495n 0.0v 1379.505n 0.0v 1389.495n 0.0v 1389.505n 0.0v 1399.495n 0.0v 1399.505n 0.0v 1409.495n 0.0v 1409.505n 0.0v 1419.495n 0.0v 1419.505n 0.0v 1429.495n 0.0v 1429.505n 0.0v 1439.495n 0.0v 1439.505n 0.0v 1449.495n 0.0v 1449.505n 0.0v 1459.495n 0.0v 1459.505n 3.3v 1469.495n 3.3v 1469.505n 3.3v 1479.495n 3.3v 1479.505n 3.3v 1489.495n 3.3v 1489.505n 3.3v 1499.495n 3.3v 1499.505n 0.0v 1509.495n 0.0v 1509.505n 0.0v 1519.495n 0.0v 1519.505n 0.0v 1529.495n 0.0v 1529.505n 3.3v 1539.495n 3.3v 1539.505n 3.3v 1549.495n 3.3v 1549.505n 3.3v 1559.495n 3.3v 1559.505n 3.3v 1569.495n 3.3v 1569.505n 3.3v 1579.495n 3.3v 1579.505n 3.3v 1589.495n 3.3v 1589.505n 3.3v 1599.495n 3.3v 1599.505n 3.3v 1609.495n 3.3v 1609.505n 3.3v 1619.495n 3.3v 1619.505n 3.3v 1629.495n 3.3v 1629.505n 3.3v 1639.495n 3.3v 1639.505n 3.3v 1649.495n 3.3v 1649.505n 3.3v 1659.495n 3.3v 1659.505n 3.3v 1669.495n 3.3v 1669.505n 3.3v 1679.495n 3.3v 1679.505n 3.3v 1689.495n 3.3v 1689.505n 3.3v 1699.495n 3.3v 1699.505n 3.3v 1709.495n 3.3v 1709.505n 3.3v 1719.495n 3.3v 1719.505n 3.3v 1729.495n 3.3v 1729.505n 3.3v 1739.495n 3.3v 1739.505n 3.3v 1749.495n 3.3v 1749.505n 3.3v 1759.495n 3.3v 1759.505n 3.3v 1769.495n 3.3v 1769.505n 3.3v 1779.495n 3.3v 1779.505n 0.0v 1789.495n 0.0v 1789.505n 0.0v 1799.495n 0.0v 1799.505n 0.0v 1809.495n 0.0v 1809.505n 0.0v 1819.495n 0.0v 1819.505n 0.0v 1829.495n 0.0v 1829.505n 0.0v 1839.495n 0.0v 1839.505n 0.0v 1849.495n 0.0v 1849.505n 3.3v 1859.495n 3.3v 1859.505n 3.3v 1869.495n 3.3v 1869.505n 3.3v 1879.495n 3.3v 1879.505n 0.0v 1889.495n 0.0v 1889.505n 0.0v 1899.495n 0.0v 1899.505n 0.0v 1909.495n 0.0v 1909.505n 0.0v 1919.495n 0.0v 1919.505n 0.0v 1929.495n 0.0v 1929.505n 0.0v 1939.495n 0.0v 1939.505n 0.0v 1949.495n 0.0v 1949.505n 0.0v 1959.495n 0.0v 1959.505n 0.0v 1969.495n 0.0v 1969.505n 0.0v 1979.495n 0.0v 1979.505n 0.0v 1989.495n 0.0v 1989.505n 0.0v 1999.495n 0.0v 1999.505n 0.0v 2009.495n 0.0v 2009.505n 0.0v 2019.495n 0.0v 2019.505n 0.0v 2029.495n 0.0v 2029.505n 0.0v 2039.495n 0.0v 2039.505n 0.0v 2049.495n 0.0v 2049.505n 0.0v )
* (time, data): [(0, 0), (10, 1), (20, 0), (30, 1), (40, 1), (50, 1), (60, 0), (70, 0), (80, 0), (90, 0), (100, 0), (110, 0), (120, 0), (130, 0), (140, 0), (150, 0), (160, 0), (170, 0), (180, 0), (190, 0), (200, 0), (210, 0), (220, 1), (230, 1), (240, 1), (250, 1), (260, 1), (270, 1), (280, 1), (290, 0), (300, 0), (310, 0), (320, 0), (330, 0), (340, 0), (350, 0), (360, 0), (370, 0), (380, 0), (390, 1), (400, 1), (410, 1), (420, 1), (430, 0), (440, 0), (450, 0), (460, 1), (470, 1), (480, 1), (490, 1), (500, 1), (510, 1), (520, 1), (530, 1), (540, 1), (550, 1), (560, 0), (570, 0), (580, 0), (590, 0), (600, 0), (610, 1), (620, 1), (630, 1), (640, 1), (650, 1), (660, 1), (670, 1), (680, 1), (690, 1), (700, 1), (710, 1), (720, 1), (730, 1), (740, 1), (750, 1), (760, 1), (770, 1), (780, 0), (790, 0), (800, 0), (810, 0), (820, 0), (830, 0), (840, 0), (850, 1), (860, 1), (870, 1), (880, 1), (890, 1), (900, 1), (910, 1), (920, 1), (930, 1), (940, 1), (950, 1), (960, 1), (970, 1), (980, 1), (990, 0), (1000, 0), (1010, 1), (1020, 1), (1030, 1), (1040, 1), (1050, 1), (1060, 1), (1070, 0), (1080, 0), (1090, 0), (1100, 0), (1110, 0), (1120, 0), (1130, 0), (1140, 0), (1150, 0), (1160, 0), (1170, 0), (1180, 0), (1190, 0), (1200, 0), (1210, 0), (1220, 0), (1230, 0), (1240, 0), (1250, 0), (1260, 1), (1270, 1), (1280, 1), (1290, 1), (1300, 1), (1310, 1), (1320, 1), (1330, 1), (1340, 0), (1350, 0), (1360, 0), (1370, 0), (1380, 0), (1390, 0), (1400, 0), (1410, 0), (1420, 0), (1430, 0), (1440, 0), (1450, 0), (1460, 1), (1470, 1), (1480, 1), (1490, 1), (1500, 0), (1510, 0), (1520, 0), (1530, 0), (1540, 0), (1550, 0), (1560, 0), (1570, 0), (1580, 0), (1590, 0), (1600, 0), (1610, 0), (1620, 0), (1630, 0), (1640, 0), (1650, 0), (1660, 0), (1670, 0), (1680, 0), (1690, 0), (1700, 0), (1710, 0), (1720, 0), (1730, 0), (1740, 0), (1750, 0), (1760, 0), (1770, 0), (1780, 1), (1790, 0), (1800, 0), (1810, 0), (1820, 0), (1830, 0), (1840, 0), (1850, 1), (1860, 1), (1870, 1), (1880, 0), (1890, 0), (1900, 1), (1910, 1), (1920, 1), (1930, 1), (1940, 1), (1950, 1), (1960, 0), (1970, 0), (1980, 0), (1990, 0), (2000, 0), (2010, 0), (2020, 0), (2030, 0), (2040, 0), (2050, 0)]
Vdin0_19  din0_19  0 PWL (0n 0.0v 9.495n 0.0v 9.505n 3.3v 19.495n 3.3v 19.505n 0.0v 29.495n 0.0v 29.505n 3.3v 39.495n 3.3v 39.505n 3.3v 49.495n 3.3v 49.505n 3.3v 59.495n 3.3v 59.505n 0.0v 69.495n 0.0v 69.505n 0.0v 79.495n 0.0v 79.505n 0.0v 89.495n 0.0v 89.505n 0.0v 99.495n 0.0v 99.505n 0.0v 109.495n 0.0v 109.505n 0.0v 119.495n 0.0v 119.505n 0.0v 129.495n 0.0v 129.505n 0.0v 139.495n 0.0v 139.505n 0.0v 149.495n 0.0v 149.505n 0.0v 159.495n 0.0v 159.505n 0.0v 169.495n 0.0v 169.505n 0.0v 179.495n 0.0v 179.505n 0.0v 189.495n 0.0v 189.505n 0.0v 199.495n 0.0v 199.505n 0.0v 209.495n 0.0v 209.505n 0.0v 219.495n 0.0v 219.505n 3.3v 229.495n 3.3v 229.505n 3.3v 239.495n 3.3v 239.505n 3.3v 249.495n 3.3v 249.505n 3.3v 259.495n 3.3v 259.505n 3.3v 269.495n 3.3v 269.505n 3.3v 279.495n 3.3v 279.505n 3.3v 289.495n 3.3v 289.505n 0.0v 299.495n 0.0v 299.505n 0.0v 309.495n 0.0v 309.505n 0.0v 319.495n 0.0v 319.505n 0.0v 329.495n 0.0v 329.505n 0.0v 339.495n 0.0v 339.505n 0.0v 349.495n 0.0v 349.505n 0.0v 359.495n 0.0v 359.505n 0.0v 369.495n 0.0v 369.505n 0.0v 379.495n 0.0v 379.505n 0.0v 389.495n 0.0v 389.505n 3.3v 399.495n 3.3v 399.505n 3.3v 409.495n 3.3v 409.505n 3.3v 419.495n 3.3v 419.505n 3.3v 429.495n 3.3v 429.505n 0.0v 439.495n 0.0v 439.505n 0.0v 449.495n 0.0v 449.505n 0.0v 459.495n 0.0v 459.505n 3.3v 469.495n 3.3v 469.505n 3.3v 479.495n 3.3v 479.505n 3.3v 489.495n 3.3v 489.505n 3.3v 499.495n 3.3v 499.505n 3.3v 509.495n 3.3v 509.505n 3.3v 519.495n 3.3v 519.505n 3.3v 529.495n 3.3v 529.505n 3.3v 539.495n 3.3v 539.505n 3.3v 549.495n 3.3v 549.505n 3.3v 559.495n 3.3v 559.505n 0.0v 569.495n 0.0v 569.505n 0.0v 579.495n 0.0v 579.505n 0.0v 589.495n 0.0v 589.505n 0.0v 599.495n 0.0v 599.505n 0.0v 609.495n 0.0v 609.505n 3.3v 619.495n 3.3v 619.505n 3.3v 629.495n 3.3v 629.505n 3.3v 639.495n 3.3v 639.505n 3.3v 649.495n 3.3v 649.505n 3.3v 659.495n 3.3v 659.505n 3.3v 669.495n 3.3v 669.505n 3.3v 679.495n 3.3v 679.505n 3.3v 689.495n 3.3v 689.505n 3.3v 699.495n 3.3v 699.505n 3.3v 709.495n 3.3v 709.505n 3.3v 719.495n 3.3v 719.505n 3.3v 729.495n 3.3v 729.505n 3.3v 739.495n 3.3v 739.505n 3.3v 749.495n 3.3v 749.505n 3.3v 759.495n 3.3v 759.505n 3.3v 769.495n 3.3v 769.505n 3.3v 779.495n 3.3v 779.505n 0.0v 789.495n 0.0v 789.505n 0.0v 799.495n 0.0v 799.505n 0.0v 809.495n 0.0v 809.505n 0.0v 819.495n 0.0v 819.505n 0.0v 829.495n 0.0v 829.505n 0.0v 839.495n 0.0v 839.505n 0.0v 849.495n 0.0v 849.505n 3.3v 859.495n 3.3v 859.505n 3.3v 869.495n 3.3v 869.505n 3.3v 879.495n 3.3v 879.505n 3.3v 889.495n 3.3v 889.505n 3.3v 899.495n 3.3v 899.505n 3.3v 909.495n 3.3v 909.505n 3.3v 919.495n 3.3v 919.505n 3.3v 929.495n 3.3v 929.505n 3.3v 939.495n 3.3v 939.505n 3.3v 949.495n 3.3v 949.505n 3.3v 959.495n 3.3v 959.505n 3.3v 969.495n 3.3v 969.505n 3.3v 979.495n 3.3v 979.505n 3.3v 989.495n 3.3v 989.505n 0.0v 999.495n 0.0v 999.505n 0.0v 1009.495n 0.0v 1009.505n 3.3v 1019.495n 3.3v 1019.505n 3.3v 1029.495n 3.3v 1029.505n 3.3v 1039.495n 3.3v 1039.505n 3.3v 1049.495n 3.3v 1049.505n 3.3v 1059.495n 3.3v 1059.505n 3.3v 1069.495n 3.3v 1069.505n 0.0v 1079.495n 0.0v 1079.505n 0.0v 1089.495n 0.0v 1089.505n 0.0v 1099.495n 0.0v 1099.505n 0.0v 1109.495n 0.0v 1109.505n 0.0v 1119.495n 0.0v 1119.505n 0.0v 1129.495n 0.0v 1129.505n 0.0v 1139.495n 0.0v 1139.505n 0.0v 1149.495n 0.0v 1149.505n 0.0v 1159.495n 0.0v 1159.505n 0.0v 1169.495n 0.0v 1169.505n 0.0v 1179.495n 0.0v 1179.505n 0.0v 1189.495n 0.0v 1189.505n 0.0v 1199.495n 0.0v 1199.505n 0.0v 1209.495n 0.0v 1209.505n 0.0v 1219.495n 0.0v 1219.505n 0.0v 1229.495n 0.0v 1229.505n 0.0v 1239.495n 0.0v 1239.505n 0.0v 1249.495n 0.0v 1249.505n 0.0v 1259.495n 0.0v 1259.505n 3.3v 1269.495n 3.3v 1269.505n 3.3v 1279.495n 3.3v 1279.505n 3.3v 1289.495n 3.3v 1289.505n 3.3v 1299.495n 3.3v 1299.505n 3.3v 1309.495n 3.3v 1309.505n 3.3v 1319.495n 3.3v 1319.505n 3.3v 1329.495n 3.3v 1329.505n 3.3v 1339.495n 3.3v 1339.505n 0.0v 1349.495n 0.0v 1349.505n 0.0v 1359.495n 0.0v 1359.505n 0.0v 1369.495n 0.0v 1369.505n 0.0v 1379.495n 0.0v 1379.505n 0.0v 1389.495n 0.0v 1389.505n 0.0v 1399.495n 0.0v 1399.505n 0.0v 1409.495n 0.0v 1409.505n 0.0v 1419.495n 0.0v 1419.505n 0.0v 1429.495n 0.0v 1429.505n 0.0v 1439.495n 0.0v 1439.505n 0.0v 1449.495n 0.0v 1449.505n 0.0v 1459.495n 0.0v 1459.505n 3.3v 1469.495n 3.3v 1469.505n 3.3v 1479.495n 3.3v 1479.505n 3.3v 1489.495n 3.3v 1489.505n 3.3v 1499.495n 3.3v 1499.505n 0.0v 1509.495n 0.0v 1509.505n 0.0v 1519.495n 0.0v 1519.505n 0.0v 1529.495n 0.0v 1529.505n 0.0v 1539.495n 0.0v 1539.505n 0.0v 1549.495n 0.0v 1549.505n 0.0v 1559.495n 0.0v 1559.505n 0.0v 1569.495n 0.0v 1569.505n 0.0v 1579.495n 0.0v 1579.505n 0.0v 1589.495n 0.0v 1589.505n 0.0v 1599.495n 0.0v 1599.505n 0.0v 1609.495n 0.0v 1609.505n 0.0v 1619.495n 0.0v 1619.505n 0.0v 1629.495n 0.0v 1629.505n 0.0v 1639.495n 0.0v 1639.505n 0.0v 1649.495n 0.0v 1649.505n 0.0v 1659.495n 0.0v 1659.505n 0.0v 1669.495n 0.0v 1669.505n 0.0v 1679.495n 0.0v 1679.505n 0.0v 1689.495n 0.0v 1689.505n 0.0v 1699.495n 0.0v 1699.505n 0.0v 1709.495n 0.0v 1709.505n 0.0v 1719.495n 0.0v 1719.505n 0.0v 1729.495n 0.0v 1729.505n 0.0v 1739.495n 0.0v 1739.505n 0.0v 1749.495n 0.0v 1749.505n 0.0v 1759.495n 0.0v 1759.505n 0.0v 1769.495n 0.0v 1769.505n 0.0v 1779.495n 0.0v 1779.505n 3.3v 1789.495n 3.3v 1789.505n 0.0v 1799.495n 0.0v 1799.505n 0.0v 1809.495n 0.0v 1809.505n 0.0v 1819.495n 0.0v 1819.505n 0.0v 1829.495n 0.0v 1829.505n 0.0v 1839.495n 0.0v 1839.505n 0.0v 1849.495n 0.0v 1849.505n 3.3v 1859.495n 3.3v 1859.505n 3.3v 1869.495n 3.3v 1869.505n 3.3v 1879.495n 3.3v 1879.505n 0.0v 1889.495n 0.0v 1889.505n 0.0v 1899.495n 0.0v 1899.505n 3.3v 1909.495n 3.3v 1909.505n 3.3v 1919.495n 3.3v 1919.505n 3.3v 1929.495n 3.3v 1929.505n 3.3v 1939.495n 3.3v 1939.505n 3.3v 1949.495n 3.3v 1949.505n 3.3v 1959.495n 3.3v 1959.505n 0.0v 1969.495n 0.0v 1969.505n 0.0v 1979.495n 0.0v 1979.505n 0.0v 1989.495n 0.0v 1989.505n 0.0v 1999.495n 0.0v 1999.505n 0.0v 2009.495n 0.0v 2009.505n 0.0v 2019.495n 0.0v 2019.505n 0.0v 2029.495n 0.0v 2029.505n 0.0v 2039.495n 0.0v 2039.505n 0.0v 2049.495n 0.0v 2049.505n 0.0v )
* (time, data): [(0, 0), (10, 1), (20, 1), (30, 1), (40, 1), (50, 1), (60, 1), (70, 1), (80, 1), (90, 1), (100, 0), (110, 0), (120, 0), (130, 0), (140, 0), (150, 0), (160, 0), (170, 0), (180, 0), (190, 0), (200, 0), (210, 0), (220, 1), (230, 1), (240, 1), (250, 1), (260, 1), (270, 1), (280, 0), (290, 0), (300, 0), (310, 1), (320, 1), (330, 1), (340, 0), (350, 0), (360, 0), (370, 0), (380, 0), (390, 1), (400, 1), (410, 1), (420, 0), (430, 0), (440, 0), (450, 0), (460, 1), (470, 0), (480, 0), (490, 0), (500, 0), (510, 0), (520, 0), (530, 0), (540, 1), (550, 1), (560, 1), (570, 1), (580, 0), (590, 0), (600, 0), (610, 0), (620, 0), (630, 0), (640, 0), (650, 0), (660, 0), (670, 0), (680, 0), (690, 0), (700, 0), (710, 1), (720, 1), (730, 1), (740, 1), (750, 1), (760, 1), (770, 1), (780, 0), (790, 1), (800, 1), (810, 1), (820, 1), (830, 1), (840, 1), (850, 1), (860, 1), (870, 1), (880, 1), (890, 1), (900, 1), (910, 1), (920, 1), (930, 1), (940, 1), (950, 1), (960, 1), (970, 1), (980, 1), (990, 1), (1000, 1), (1010, 0), (1020, 0), (1030, 0), (1040, 0), (1050, 0), (1060, 0), (1070, 0), (1080, 0), (1090, 0), (1100, 0), (1110, 0), (1120, 0), (1130, 0), (1140, 0), (1150, 0), (1160, 0), (1170, 0), (1180, 0), (1190, 0), (1200, 0), (1210, 0), (1220, 0), (1230, 0), (1240, 0), (1250, 0), (1260, 0), (1270, 0), (1280, 1), (1290, 0), (1300, 0), (1310, 0), (1320, 0), (1330, 0), (1340, 0), (1350, 0), (1360, 0), (1370, 1), (1380, 1), (1390, 1), (1400, 1), (1410, 1), (1420, 1), (1430, 1), (1440, 1), (1450, 1), (1460, 0), (1470, 0), (1480, 0), (1490, 0), (1500, 0), (1510, 0), (1520, 0), (1530, 0), (1540, 0), (1550, 0), (1560, 0), (1570, 0), (1580, 0), (1590, 0), (1600, 0), (1610, 0), (1620, 0), (1630, 0), (1640, 0), (1650, 0), (1660, 1), (1670, 1), (1680, 1), (1690, 1), (1700, 1), (1710, 0), (1720, 0), (1730, 0), (1740, 0), (1750, 0), (1760, 0), (1770, 0), (1780, 0), (1790, 0), (1800, 0), (1810, 0), (1820, 1), (1830, 1), (1840, 1), (1850, 1), (1860, 1), (1870, 1), (1880, 1), (1890, 1), (1900, 1), (1910, 1), (1920, 1), (1930, 1), (1940, 1), (1950, 1), (1960, 0), (1970, 0), (1980, 0), (1990, 0), (2000, 0), (2010, 0), (2020, 0), (2030, 0), (2040, 0), (2050, 0)]
Vdin0_20  din0_20  0 PWL (0n 0.0v 9.495n 0.0v 9.505n 3.3v 19.495n 3.3v 19.505n 3.3v 29.495n 3.3v 29.505n 3.3v 39.495n 3.3v 39.505n 3.3v 49.495n 3.3v 49.505n 3.3v 59.495n 3.3v 59.505n 3.3v 69.495n 3.3v 69.505n 3.3v 79.495n 3.3v 79.505n 3.3v 89.495n 3.3v 89.505n 3.3v 99.495n 3.3v 99.505n 0.0v 109.495n 0.0v 109.505n 0.0v 119.495n 0.0v 119.505n 0.0v 129.495n 0.0v 129.505n 0.0v 139.495n 0.0v 139.505n 0.0v 149.495n 0.0v 149.505n 0.0v 159.495n 0.0v 159.505n 0.0v 169.495n 0.0v 169.505n 0.0v 179.495n 0.0v 179.505n 0.0v 189.495n 0.0v 189.505n 0.0v 199.495n 0.0v 199.505n 0.0v 209.495n 0.0v 209.505n 0.0v 219.495n 0.0v 219.505n 3.3v 229.495n 3.3v 229.505n 3.3v 239.495n 3.3v 239.505n 3.3v 249.495n 3.3v 249.505n 3.3v 259.495n 3.3v 259.505n 3.3v 269.495n 3.3v 269.505n 3.3v 279.495n 3.3v 279.505n 0.0v 289.495n 0.0v 289.505n 0.0v 299.495n 0.0v 299.505n 0.0v 309.495n 0.0v 309.505n 3.3v 319.495n 3.3v 319.505n 3.3v 329.495n 3.3v 329.505n 3.3v 339.495n 3.3v 339.505n 0.0v 349.495n 0.0v 349.505n 0.0v 359.495n 0.0v 359.505n 0.0v 369.495n 0.0v 369.505n 0.0v 379.495n 0.0v 379.505n 0.0v 389.495n 0.0v 389.505n 3.3v 399.495n 3.3v 399.505n 3.3v 409.495n 3.3v 409.505n 3.3v 419.495n 3.3v 419.505n 0.0v 429.495n 0.0v 429.505n 0.0v 439.495n 0.0v 439.505n 0.0v 449.495n 0.0v 449.505n 0.0v 459.495n 0.0v 459.505n 3.3v 469.495n 3.3v 469.505n 0.0v 479.495n 0.0v 479.505n 0.0v 489.495n 0.0v 489.505n 0.0v 499.495n 0.0v 499.505n 0.0v 509.495n 0.0v 509.505n 0.0v 519.495n 0.0v 519.505n 0.0v 529.495n 0.0v 529.505n 0.0v 539.495n 0.0v 539.505n 3.3v 549.495n 3.3v 549.505n 3.3v 559.495n 3.3v 559.505n 3.3v 569.495n 3.3v 569.505n 3.3v 579.495n 3.3v 579.505n 0.0v 589.495n 0.0v 589.505n 0.0v 599.495n 0.0v 599.505n 0.0v 609.495n 0.0v 609.505n 0.0v 619.495n 0.0v 619.505n 0.0v 629.495n 0.0v 629.505n 0.0v 639.495n 0.0v 639.505n 0.0v 649.495n 0.0v 649.505n 0.0v 659.495n 0.0v 659.505n 0.0v 669.495n 0.0v 669.505n 0.0v 679.495n 0.0v 679.505n 0.0v 689.495n 0.0v 689.505n 0.0v 699.495n 0.0v 699.505n 0.0v 709.495n 0.0v 709.505n 3.3v 719.495n 3.3v 719.505n 3.3v 729.495n 3.3v 729.505n 3.3v 739.495n 3.3v 739.505n 3.3v 749.495n 3.3v 749.505n 3.3v 759.495n 3.3v 759.505n 3.3v 769.495n 3.3v 769.505n 3.3v 779.495n 3.3v 779.505n 0.0v 789.495n 0.0v 789.505n 3.3v 799.495n 3.3v 799.505n 3.3v 809.495n 3.3v 809.505n 3.3v 819.495n 3.3v 819.505n 3.3v 829.495n 3.3v 829.505n 3.3v 839.495n 3.3v 839.505n 3.3v 849.495n 3.3v 849.505n 3.3v 859.495n 3.3v 859.505n 3.3v 869.495n 3.3v 869.505n 3.3v 879.495n 3.3v 879.505n 3.3v 889.495n 3.3v 889.505n 3.3v 899.495n 3.3v 899.505n 3.3v 909.495n 3.3v 909.505n 3.3v 919.495n 3.3v 919.505n 3.3v 929.495n 3.3v 929.505n 3.3v 939.495n 3.3v 939.505n 3.3v 949.495n 3.3v 949.505n 3.3v 959.495n 3.3v 959.505n 3.3v 969.495n 3.3v 969.505n 3.3v 979.495n 3.3v 979.505n 3.3v 989.495n 3.3v 989.505n 3.3v 999.495n 3.3v 999.505n 3.3v 1009.495n 3.3v 1009.505n 0.0v 1019.495n 0.0v 1019.505n 0.0v 1029.495n 0.0v 1029.505n 0.0v 1039.495n 0.0v 1039.505n 0.0v 1049.495n 0.0v 1049.505n 0.0v 1059.495n 0.0v 1059.505n 0.0v 1069.495n 0.0v 1069.505n 0.0v 1079.495n 0.0v 1079.505n 0.0v 1089.495n 0.0v 1089.505n 0.0v 1099.495n 0.0v 1099.505n 0.0v 1109.495n 0.0v 1109.505n 0.0v 1119.495n 0.0v 1119.505n 0.0v 1129.495n 0.0v 1129.505n 0.0v 1139.495n 0.0v 1139.505n 0.0v 1149.495n 0.0v 1149.505n 0.0v 1159.495n 0.0v 1159.505n 0.0v 1169.495n 0.0v 1169.505n 0.0v 1179.495n 0.0v 1179.505n 0.0v 1189.495n 0.0v 1189.505n 0.0v 1199.495n 0.0v 1199.505n 0.0v 1209.495n 0.0v 1209.505n 0.0v 1219.495n 0.0v 1219.505n 0.0v 1229.495n 0.0v 1229.505n 0.0v 1239.495n 0.0v 1239.505n 0.0v 1249.495n 0.0v 1249.505n 0.0v 1259.495n 0.0v 1259.505n 0.0v 1269.495n 0.0v 1269.505n 0.0v 1279.495n 0.0v 1279.505n 3.3v 1289.495n 3.3v 1289.505n 0.0v 1299.495n 0.0v 1299.505n 0.0v 1309.495n 0.0v 1309.505n 0.0v 1319.495n 0.0v 1319.505n 0.0v 1329.495n 0.0v 1329.505n 0.0v 1339.495n 0.0v 1339.505n 0.0v 1349.495n 0.0v 1349.505n 0.0v 1359.495n 0.0v 1359.505n 0.0v 1369.495n 0.0v 1369.505n 3.3v 1379.495n 3.3v 1379.505n 3.3v 1389.495n 3.3v 1389.505n 3.3v 1399.495n 3.3v 1399.505n 3.3v 1409.495n 3.3v 1409.505n 3.3v 1419.495n 3.3v 1419.505n 3.3v 1429.495n 3.3v 1429.505n 3.3v 1439.495n 3.3v 1439.505n 3.3v 1449.495n 3.3v 1449.505n 3.3v 1459.495n 3.3v 1459.505n 0.0v 1469.495n 0.0v 1469.505n 0.0v 1479.495n 0.0v 1479.505n 0.0v 1489.495n 0.0v 1489.505n 0.0v 1499.495n 0.0v 1499.505n 0.0v 1509.495n 0.0v 1509.505n 0.0v 1519.495n 0.0v 1519.505n 0.0v 1529.495n 0.0v 1529.505n 0.0v 1539.495n 0.0v 1539.505n 0.0v 1549.495n 0.0v 1549.505n 0.0v 1559.495n 0.0v 1559.505n 0.0v 1569.495n 0.0v 1569.505n 0.0v 1579.495n 0.0v 1579.505n 0.0v 1589.495n 0.0v 1589.505n 0.0v 1599.495n 0.0v 1599.505n 0.0v 1609.495n 0.0v 1609.505n 0.0v 1619.495n 0.0v 1619.505n 0.0v 1629.495n 0.0v 1629.505n 0.0v 1639.495n 0.0v 1639.505n 0.0v 1649.495n 0.0v 1649.505n 0.0v 1659.495n 0.0v 1659.505n 3.3v 1669.495n 3.3v 1669.505n 3.3v 1679.495n 3.3v 1679.505n 3.3v 1689.495n 3.3v 1689.505n 3.3v 1699.495n 3.3v 1699.505n 3.3v 1709.495n 3.3v 1709.505n 0.0v 1719.495n 0.0v 1719.505n 0.0v 1729.495n 0.0v 1729.505n 0.0v 1739.495n 0.0v 1739.505n 0.0v 1749.495n 0.0v 1749.505n 0.0v 1759.495n 0.0v 1759.505n 0.0v 1769.495n 0.0v 1769.505n 0.0v 1779.495n 0.0v 1779.505n 0.0v 1789.495n 0.0v 1789.505n 0.0v 1799.495n 0.0v 1799.505n 0.0v 1809.495n 0.0v 1809.505n 0.0v 1819.495n 0.0v 1819.505n 3.3v 1829.495n 3.3v 1829.505n 3.3v 1839.495n 3.3v 1839.505n 3.3v 1849.495n 3.3v 1849.505n 3.3v 1859.495n 3.3v 1859.505n 3.3v 1869.495n 3.3v 1869.505n 3.3v 1879.495n 3.3v 1879.505n 3.3v 1889.495n 3.3v 1889.505n 3.3v 1899.495n 3.3v 1899.505n 3.3v 1909.495n 3.3v 1909.505n 3.3v 1919.495n 3.3v 1919.505n 3.3v 1929.495n 3.3v 1929.505n 3.3v 1939.495n 3.3v 1939.505n 3.3v 1949.495n 3.3v 1949.505n 3.3v 1959.495n 3.3v 1959.505n 0.0v 1969.495n 0.0v 1969.505n 0.0v 1979.495n 0.0v 1979.505n 0.0v 1989.495n 0.0v 1989.505n 0.0v 1999.495n 0.0v 1999.505n 0.0v 2009.495n 0.0v 2009.505n 0.0v 2019.495n 0.0v 2019.505n 0.0v 2029.495n 0.0v 2029.505n 0.0v 2039.495n 0.0v 2039.505n 0.0v 2049.495n 0.0v 2049.505n 0.0v )
* (time, data): [(0, 0), (10, 0), (20, 1), (30, 1), (40, 1), (50, 1), (60, 0), (70, 0), (80, 0), (90, 0), (100, 0), (110, 0), (120, 0), (130, 0), (140, 0), (150, 0), (160, 0), (170, 0), (180, 0), (190, 0), (200, 0), (210, 0), (220, 1), (230, 1), (240, 1), (250, 1), (260, 1), (270, 1), (280, 1), (290, 1), (300, 1), (310, 0), (320, 0), (330, 1), (340, 0), (350, 0), (360, 0), (370, 0), (380, 0), (390, 0), (400, 0), (410, 0), (420, 1), (430, 0), (440, 0), (450, 0), (460, 0), (470, 0), (480, 0), (490, 0), (500, 0), (510, 0), (520, 0), (530, 0), (540, 0), (550, 0), (560, 0), (570, 0), (580, 1), (590, 1), (600, 1), (610, 0), (620, 0), (630, 0), (640, 0), (650, 0), (660, 0), (670, 0), (680, 0), (690, 0), (700, 0), (710, 1), (720, 1), (730, 1), (740, 1), (750, 1), (760, 1), (770, 1), (780, 1), (790, 0), (800, 0), (810, 0), (820, 0), (830, 0), (840, 0), (850, 0), (860, 0), (870, 0), (880, 0), (890, 0), (900, 0), (910, 0), (920, 0), (930, 0), (940, 0), (950, 0), (960, 0), (970, 0), (980, 0), (990, 1), (1000, 0), (1010, 1), (1020, 0), (1030, 0), (1040, 0), (1050, 0), (1060, 0), (1070, 0), (1080, 0), (1090, 0), (1100, 0), (1110, 0), (1120, 0), (1130, 0), (1140, 0), (1150, 0), (1160, 0), (1170, 0), (1180, 0), (1190, 0), (1200, 0), (1210, 0), (1220, 0), (1230, 0), (1240, 0), (1250, 0), (1260, 1), (1270, 1), (1280, 1), (1290, 0), (1300, 0), (1310, 0), (1320, 0), (1330, 0), (1340, 1), (1350, 1), (1360, 1), (1370, 1), (1380, 1), (1390, 1), (1400, 1), (1410, 1), (1420, 1), (1430, 1), (1440, 1), (1450, 1), (1460, 1), (1470, 1), (1480, 1), (1490, 1), (1500, 0), (1510, 0), (1520, 0), (1530, 0), (1540, 0), (1550, 0), (1560, 0), (1570, 0), (1580, 0), (1590, 0), (1600, 0), (1610, 0), (1620, 0), (1630, 0), (1640, 0), (1650, 0), (1660, 1), (1670, 1), (1680, 1), (1690, 1), (1700, 1), (1710, 1), (1720, 1), (1730, 1), (1740, 1), (1750, 1), (1760, 1), (1770, 1), (1780, 0), (1790, 1), (1800, 1), (1810, 1), (1820, 0), (1830, 0), (1840, 0), (1850, 0), (1860, 0), (1870, 0), (1880, 0), (1890, 0), (1900, 1), (1910, 1), (1920, 1), (1930, 1), (1940, 1), (1950, 1), (1960, 0), (1970, 0), (1980, 0), (1990, 1), (2000, 1), (2010, 1), (2020, 1), (2030, 1), (2040, 1), (2050, 1)]
Vdin0_21  din0_21  0 PWL (0n 0.0v 9.495n 0.0v 9.505n 0.0v 19.495n 0.0v 19.505n 3.3v 29.495n 3.3v 29.505n 3.3v 39.495n 3.3v 39.505n 3.3v 49.495n 3.3v 49.505n 3.3v 59.495n 3.3v 59.505n 0.0v 69.495n 0.0v 69.505n 0.0v 79.495n 0.0v 79.505n 0.0v 89.495n 0.0v 89.505n 0.0v 99.495n 0.0v 99.505n 0.0v 109.495n 0.0v 109.505n 0.0v 119.495n 0.0v 119.505n 0.0v 129.495n 0.0v 129.505n 0.0v 139.495n 0.0v 139.505n 0.0v 149.495n 0.0v 149.505n 0.0v 159.495n 0.0v 159.505n 0.0v 169.495n 0.0v 169.505n 0.0v 179.495n 0.0v 179.505n 0.0v 189.495n 0.0v 189.505n 0.0v 199.495n 0.0v 199.505n 0.0v 209.495n 0.0v 209.505n 0.0v 219.495n 0.0v 219.505n 3.3v 229.495n 3.3v 229.505n 3.3v 239.495n 3.3v 239.505n 3.3v 249.495n 3.3v 249.505n 3.3v 259.495n 3.3v 259.505n 3.3v 269.495n 3.3v 269.505n 3.3v 279.495n 3.3v 279.505n 3.3v 289.495n 3.3v 289.505n 3.3v 299.495n 3.3v 299.505n 3.3v 309.495n 3.3v 309.505n 0.0v 319.495n 0.0v 319.505n 0.0v 329.495n 0.0v 329.505n 3.3v 339.495n 3.3v 339.505n 0.0v 349.495n 0.0v 349.505n 0.0v 359.495n 0.0v 359.505n 0.0v 369.495n 0.0v 369.505n 0.0v 379.495n 0.0v 379.505n 0.0v 389.495n 0.0v 389.505n 0.0v 399.495n 0.0v 399.505n 0.0v 409.495n 0.0v 409.505n 0.0v 419.495n 0.0v 419.505n 3.3v 429.495n 3.3v 429.505n 0.0v 439.495n 0.0v 439.505n 0.0v 449.495n 0.0v 449.505n 0.0v 459.495n 0.0v 459.505n 0.0v 469.495n 0.0v 469.505n 0.0v 479.495n 0.0v 479.505n 0.0v 489.495n 0.0v 489.505n 0.0v 499.495n 0.0v 499.505n 0.0v 509.495n 0.0v 509.505n 0.0v 519.495n 0.0v 519.505n 0.0v 529.495n 0.0v 529.505n 0.0v 539.495n 0.0v 539.505n 0.0v 549.495n 0.0v 549.505n 0.0v 559.495n 0.0v 559.505n 0.0v 569.495n 0.0v 569.505n 0.0v 579.495n 0.0v 579.505n 3.3v 589.495n 3.3v 589.505n 3.3v 599.495n 3.3v 599.505n 3.3v 609.495n 3.3v 609.505n 0.0v 619.495n 0.0v 619.505n 0.0v 629.495n 0.0v 629.505n 0.0v 639.495n 0.0v 639.505n 0.0v 649.495n 0.0v 649.505n 0.0v 659.495n 0.0v 659.505n 0.0v 669.495n 0.0v 669.505n 0.0v 679.495n 0.0v 679.505n 0.0v 689.495n 0.0v 689.505n 0.0v 699.495n 0.0v 699.505n 0.0v 709.495n 0.0v 709.505n 3.3v 719.495n 3.3v 719.505n 3.3v 729.495n 3.3v 729.505n 3.3v 739.495n 3.3v 739.505n 3.3v 749.495n 3.3v 749.505n 3.3v 759.495n 3.3v 759.505n 3.3v 769.495n 3.3v 769.505n 3.3v 779.495n 3.3v 779.505n 3.3v 789.495n 3.3v 789.505n 0.0v 799.495n 0.0v 799.505n 0.0v 809.495n 0.0v 809.505n 0.0v 819.495n 0.0v 819.505n 0.0v 829.495n 0.0v 829.505n 0.0v 839.495n 0.0v 839.505n 0.0v 849.495n 0.0v 849.505n 0.0v 859.495n 0.0v 859.505n 0.0v 869.495n 0.0v 869.505n 0.0v 879.495n 0.0v 879.505n 0.0v 889.495n 0.0v 889.505n 0.0v 899.495n 0.0v 899.505n 0.0v 909.495n 0.0v 909.505n 0.0v 919.495n 0.0v 919.505n 0.0v 929.495n 0.0v 929.505n 0.0v 939.495n 0.0v 939.505n 0.0v 949.495n 0.0v 949.505n 0.0v 959.495n 0.0v 959.505n 0.0v 969.495n 0.0v 969.505n 0.0v 979.495n 0.0v 979.505n 0.0v 989.495n 0.0v 989.505n 3.3v 999.495n 3.3v 999.505n 0.0v 1009.495n 0.0v 1009.505n 3.3v 1019.495n 3.3v 1019.505n 0.0v 1029.495n 0.0v 1029.505n 0.0v 1039.495n 0.0v 1039.505n 0.0v 1049.495n 0.0v 1049.505n 0.0v 1059.495n 0.0v 1059.505n 0.0v 1069.495n 0.0v 1069.505n 0.0v 1079.495n 0.0v 1079.505n 0.0v 1089.495n 0.0v 1089.505n 0.0v 1099.495n 0.0v 1099.505n 0.0v 1109.495n 0.0v 1109.505n 0.0v 1119.495n 0.0v 1119.505n 0.0v 1129.495n 0.0v 1129.505n 0.0v 1139.495n 0.0v 1139.505n 0.0v 1149.495n 0.0v 1149.505n 0.0v 1159.495n 0.0v 1159.505n 0.0v 1169.495n 0.0v 1169.505n 0.0v 1179.495n 0.0v 1179.505n 0.0v 1189.495n 0.0v 1189.505n 0.0v 1199.495n 0.0v 1199.505n 0.0v 1209.495n 0.0v 1209.505n 0.0v 1219.495n 0.0v 1219.505n 0.0v 1229.495n 0.0v 1229.505n 0.0v 1239.495n 0.0v 1239.505n 0.0v 1249.495n 0.0v 1249.505n 0.0v 1259.495n 0.0v 1259.505n 3.3v 1269.495n 3.3v 1269.505n 3.3v 1279.495n 3.3v 1279.505n 3.3v 1289.495n 3.3v 1289.505n 0.0v 1299.495n 0.0v 1299.505n 0.0v 1309.495n 0.0v 1309.505n 0.0v 1319.495n 0.0v 1319.505n 0.0v 1329.495n 0.0v 1329.505n 0.0v 1339.495n 0.0v 1339.505n 3.3v 1349.495n 3.3v 1349.505n 3.3v 1359.495n 3.3v 1359.505n 3.3v 1369.495n 3.3v 1369.505n 3.3v 1379.495n 3.3v 1379.505n 3.3v 1389.495n 3.3v 1389.505n 3.3v 1399.495n 3.3v 1399.505n 3.3v 1409.495n 3.3v 1409.505n 3.3v 1419.495n 3.3v 1419.505n 3.3v 1429.495n 3.3v 1429.505n 3.3v 1439.495n 3.3v 1439.505n 3.3v 1449.495n 3.3v 1449.505n 3.3v 1459.495n 3.3v 1459.505n 3.3v 1469.495n 3.3v 1469.505n 3.3v 1479.495n 3.3v 1479.505n 3.3v 1489.495n 3.3v 1489.505n 3.3v 1499.495n 3.3v 1499.505n 0.0v 1509.495n 0.0v 1509.505n 0.0v 1519.495n 0.0v 1519.505n 0.0v 1529.495n 0.0v 1529.505n 0.0v 1539.495n 0.0v 1539.505n 0.0v 1549.495n 0.0v 1549.505n 0.0v 1559.495n 0.0v 1559.505n 0.0v 1569.495n 0.0v 1569.505n 0.0v 1579.495n 0.0v 1579.505n 0.0v 1589.495n 0.0v 1589.505n 0.0v 1599.495n 0.0v 1599.505n 0.0v 1609.495n 0.0v 1609.505n 0.0v 1619.495n 0.0v 1619.505n 0.0v 1629.495n 0.0v 1629.505n 0.0v 1639.495n 0.0v 1639.505n 0.0v 1649.495n 0.0v 1649.505n 0.0v 1659.495n 0.0v 1659.505n 3.3v 1669.495n 3.3v 1669.505n 3.3v 1679.495n 3.3v 1679.505n 3.3v 1689.495n 3.3v 1689.505n 3.3v 1699.495n 3.3v 1699.505n 3.3v 1709.495n 3.3v 1709.505n 3.3v 1719.495n 3.3v 1719.505n 3.3v 1729.495n 3.3v 1729.505n 3.3v 1739.495n 3.3v 1739.505n 3.3v 1749.495n 3.3v 1749.505n 3.3v 1759.495n 3.3v 1759.505n 3.3v 1769.495n 3.3v 1769.505n 3.3v 1779.495n 3.3v 1779.505n 0.0v 1789.495n 0.0v 1789.505n 3.3v 1799.495n 3.3v 1799.505n 3.3v 1809.495n 3.3v 1809.505n 3.3v 1819.495n 3.3v 1819.505n 0.0v 1829.495n 0.0v 1829.505n 0.0v 1839.495n 0.0v 1839.505n 0.0v 1849.495n 0.0v 1849.505n 0.0v 1859.495n 0.0v 1859.505n 0.0v 1869.495n 0.0v 1869.505n 0.0v 1879.495n 0.0v 1879.505n 0.0v 1889.495n 0.0v 1889.505n 0.0v 1899.495n 0.0v 1899.505n 3.3v 1909.495n 3.3v 1909.505n 3.3v 1919.495n 3.3v 1919.505n 3.3v 1929.495n 3.3v 1929.505n 3.3v 1939.495n 3.3v 1939.505n 3.3v 1949.495n 3.3v 1949.505n 3.3v 1959.495n 3.3v 1959.505n 0.0v 1969.495n 0.0v 1969.505n 0.0v 1979.495n 0.0v 1979.505n 0.0v 1989.495n 0.0v 1989.505n 3.3v 1999.495n 3.3v 1999.505n 3.3v 2009.495n 3.3v 2009.505n 3.3v 2019.495n 3.3v 2019.505n 3.3v 2029.495n 3.3v 2029.505n 3.3v 2039.495n 3.3v 2039.505n 3.3v 2049.495n 3.3v 2049.505n 3.3v )
* (time, data): [(0, 0), (10, 1), (20, 0), (30, 0), (40, 0), (50, 0), (60, 0), (70, 0), (80, 0), (90, 0), (100, 0), (110, 0), (120, 0), (130, 0), (140, 0), (150, 0), (160, 0), (170, 0), (180, 0), (190, 0), (200, 0), (210, 0), (220, 0), (230, 0), (240, 0), (250, 0), (260, 0), (270, 1), (280, 0), (290, 1), (300, 1), (310, 0), (320, 0), (330, 1), (340, 0), (350, 0), (360, 0), (370, 0), (380, 0), (390, 1), (400, 1), (410, 1), (420, 0), (430, 1), (440, 1), (450, 1), (460, 0), (470, 1), (480, 1), (490, 1), (500, 1), (510, 1), (520, 1), (530, 0), (540, 1), (550, 1), (560, 0), (570, 0), (580, 1), (590, 1), (600, 1), (610, 1), (620, 1), (630, 1), (640, 1), (650, 1), (660, 1), (670, 1), (680, 1), (690, 1), (700, 1), (710, 1), (720, 1), (730, 1), (740, 1), (750, 1), (760, 1), (770, 1), (780, 1), (790, 0), (800, 0), (810, 0), (820, 0), (830, 0), (840, 0), (850, 0), (860, 0), (870, 0), (880, 0), (890, 0), (900, 0), (910, 0), (920, 0), (930, 0), (940, 0), (950, 0), (960, 0), (970, 0), (980, 0), (990, 0), (1000, 0), (1010, 0), (1020, 0), (1030, 0), (1040, 0), (1050, 1), (1060, 1), (1070, 0), (1080, 0), (1090, 0), (1100, 0), (1110, 0), (1120, 0), (1130, 0), (1140, 0), (1150, 1), (1160, 1), (1170, 1), (1180, 1), (1190, 1), (1200, 1), (1210, 1), (1220, 1), (1230, 1), (1240, 1), (1250, 1), (1260, 1), (1270, 1), (1280, 0), (1290, 0), (1300, 0), (1310, 0), (1320, 0), (1330, 0), (1340, 0), (1350, 0), (1360, 1), (1370, 0), (1380, 0), (1390, 0), (1400, 0), (1410, 0), (1420, 0), (1430, 0), (1440, 0), (1450, 0), (1460, 1), (1470, 1), (1480, 1), (1490, 1), (1500, 0), (1510, 0), (1520, 0), (1530, 0), (1540, 0), (1550, 0), (1560, 0), (1570, 0), (1580, 0), (1590, 0), (1600, 0), (1610, 0), (1620, 0), (1630, 0), (1640, 0), (1650, 0), (1660, 0), (1670, 0), (1680, 0), (1690, 0), (1700, 0), (1710, 0), (1720, 0), (1730, 0), (1740, 0), (1750, 0), (1760, 0), (1770, 0), (1780, 1), (1790, 0), (1800, 0), (1810, 0), (1820, 0), (1830, 0), (1840, 0), (1850, 0), (1860, 0), (1870, 0), (1880, 1), (1890, 1), (1900, 0), (1910, 0), (1920, 0), (1930, 0), (1940, 0), (1950, 0), (1960, 1), (1970, 1), (1980, 1), (1990, 1), (2000, 1), (2010, 1), (2020, 1), (2030, 1), (2040, 1), (2050, 1)]
Vdin0_22  din0_22  0 PWL (0n 0.0v 9.495n 0.0v 9.505n 3.3v 19.495n 3.3v 19.505n 0.0v 29.495n 0.0v 29.505n 0.0v 39.495n 0.0v 39.505n 0.0v 49.495n 0.0v 49.505n 0.0v 59.495n 0.0v 59.505n 0.0v 69.495n 0.0v 69.505n 0.0v 79.495n 0.0v 79.505n 0.0v 89.495n 0.0v 89.505n 0.0v 99.495n 0.0v 99.505n 0.0v 109.495n 0.0v 109.505n 0.0v 119.495n 0.0v 119.505n 0.0v 129.495n 0.0v 129.505n 0.0v 139.495n 0.0v 139.505n 0.0v 149.495n 0.0v 149.505n 0.0v 159.495n 0.0v 159.505n 0.0v 169.495n 0.0v 169.505n 0.0v 179.495n 0.0v 179.505n 0.0v 189.495n 0.0v 189.505n 0.0v 199.495n 0.0v 199.505n 0.0v 209.495n 0.0v 209.505n 0.0v 219.495n 0.0v 219.505n 0.0v 229.495n 0.0v 229.505n 0.0v 239.495n 0.0v 239.505n 0.0v 249.495n 0.0v 249.505n 0.0v 259.495n 0.0v 259.505n 0.0v 269.495n 0.0v 269.505n 3.3v 279.495n 3.3v 279.505n 0.0v 289.495n 0.0v 289.505n 3.3v 299.495n 3.3v 299.505n 3.3v 309.495n 3.3v 309.505n 0.0v 319.495n 0.0v 319.505n 0.0v 329.495n 0.0v 329.505n 3.3v 339.495n 3.3v 339.505n 0.0v 349.495n 0.0v 349.505n 0.0v 359.495n 0.0v 359.505n 0.0v 369.495n 0.0v 369.505n 0.0v 379.495n 0.0v 379.505n 0.0v 389.495n 0.0v 389.505n 3.3v 399.495n 3.3v 399.505n 3.3v 409.495n 3.3v 409.505n 3.3v 419.495n 3.3v 419.505n 0.0v 429.495n 0.0v 429.505n 3.3v 439.495n 3.3v 439.505n 3.3v 449.495n 3.3v 449.505n 3.3v 459.495n 3.3v 459.505n 0.0v 469.495n 0.0v 469.505n 3.3v 479.495n 3.3v 479.505n 3.3v 489.495n 3.3v 489.505n 3.3v 499.495n 3.3v 499.505n 3.3v 509.495n 3.3v 509.505n 3.3v 519.495n 3.3v 519.505n 3.3v 529.495n 3.3v 529.505n 0.0v 539.495n 0.0v 539.505n 3.3v 549.495n 3.3v 549.505n 3.3v 559.495n 3.3v 559.505n 0.0v 569.495n 0.0v 569.505n 0.0v 579.495n 0.0v 579.505n 3.3v 589.495n 3.3v 589.505n 3.3v 599.495n 3.3v 599.505n 3.3v 609.495n 3.3v 609.505n 3.3v 619.495n 3.3v 619.505n 3.3v 629.495n 3.3v 629.505n 3.3v 639.495n 3.3v 639.505n 3.3v 649.495n 3.3v 649.505n 3.3v 659.495n 3.3v 659.505n 3.3v 669.495n 3.3v 669.505n 3.3v 679.495n 3.3v 679.505n 3.3v 689.495n 3.3v 689.505n 3.3v 699.495n 3.3v 699.505n 3.3v 709.495n 3.3v 709.505n 3.3v 719.495n 3.3v 719.505n 3.3v 729.495n 3.3v 729.505n 3.3v 739.495n 3.3v 739.505n 3.3v 749.495n 3.3v 749.505n 3.3v 759.495n 3.3v 759.505n 3.3v 769.495n 3.3v 769.505n 3.3v 779.495n 3.3v 779.505n 3.3v 789.495n 3.3v 789.505n 0.0v 799.495n 0.0v 799.505n 0.0v 809.495n 0.0v 809.505n 0.0v 819.495n 0.0v 819.505n 0.0v 829.495n 0.0v 829.505n 0.0v 839.495n 0.0v 839.505n 0.0v 849.495n 0.0v 849.505n 0.0v 859.495n 0.0v 859.505n 0.0v 869.495n 0.0v 869.505n 0.0v 879.495n 0.0v 879.505n 0.0v 889.495n 0.0v 889.505n 0.0v 899.495n 0.0v 899.505n 0.0v 909.495n 0.0v 909.505n 0.0v 919.495n 0.0v 919.505n 0.0v 929.495n 0.0v 929.505n 0.0v 939.495n 0.0v 939.505n 0.0v 949.495n 0.0v 949.505n 0.0v 959.495n 0.0v 959.505n 0.0v 969.495n 0.0v 969.505n 0.0v 979.495n 0.0v 979.505n 0.0v 989.495n 0.0v 989.505n 0.0v 999.495n 0.0v 999.505n 0.0v 1009.495n 0.0v 1009.505n 0.0v 1019.495n 0.0v 1019.505n 0.0v 1029.495n 0.0v 1029.505n 0.0v 1039.495n 0.0v 1039.505n 0.0v 1049.495n 0.0v 1049.505n 3.3v 1059.495n 3.3v 1059.505n 3.3v 1069.495n 3.3v 1069.505n 0.0v 1079.495n 0.0v 1079.505n 0.0v 1089.495n 0.0v 1089.505n 0.0v 1099.495n 0.0v 1099.505n 0.0v 1109.495n 0.0v 1109.505n 0.0v 1119.495n 0.0v 1119.505n 0.0v 1129.495n 0.0v 1129.505n 0.0v 1139.495n 0.0v 1139.505n 0.0v 1149.495n 0.0v 1149.505n 3.3v 1159.495n 3.3v 1159.505n 3.3v 1169.495n 3.3v 1169.505n 3.3v 1179.495n 3.3v 1179.505n 3.3v 1189.495n 3.3v 1189.505n 3.3v 1199.495n 3.3v 1199.505n 3.3v 1209.495n 3.3v 1209.505n 3.3v 1219.495n 3.3v 1219.505n 3.3v 1229.495n 3.3v 1229.505n 3.3v 1239.495n 3.3v 1239.505n 3.3v 1249.495n 3.3v 1249.505n 3.3v 1259.495n 3.3v 1259.505n 3.3v 1269.495n 3.3v 1269.505n 3.3v 1279.495n 3.3v 1279.505n 0.0v 1289.495n 0.0v 1289.505n 0.0v 1299.495n 0.0v 1299.505n 0.0v 1309.495n 0.0v 1309.505n 0.0v 1319.495n 0.0v 1319.505n 0.0v 1329.495n 0.0v 1329.505n 0.0v 1339.495n 0.0v 1339.505n 0.0v 1349.495n 0.0v 1349.505n 0.0v 1359.495n 0.0v 1359.505n 3.3v 1369.495n 3.3v 1369.505n 0.0v 1379.495n 0.0v 1379.505n 0.0v 1389.495n 0.0v 1389.505n 0.0v 1399.495n 0.0v 1399.505n 0.0v 1409.495n 0.0v 1409.505n 0.0v 1419.495n 0.0v 1419.505n 0.0v 1429.495n 0.0v 1429.505n 0.0v 1439.495n 0.0v 1439.505n 0.0v 1449.495n 0.0v 1449.505n 0.0v 1459.495n 0.0v 1459.505n 3.3v 1469.495n 3.3v 1469.505n 3.3v 1479.495n 3.3v 1479.505n 3.3v 1489.495n 3.3v 1489.505n 3.3v 1499.495n 3.3v 1499.505n 0.0v 1509.495n 0.0v 1509.505n 0.0v 1519.495n 0.0v 1519.505n 0.0v 1529.495n 0.0v 1529.505n 0.0v 1539.495n 0.0v 1539.505n 0.0v 1549.495n 0.0v 1549.505n 0.0v 1559.495n 0.0v 1559.505n 0.0v 1569.495n 0.0v 1569.505n 0.0v 1579.495n 0.0v 1579.505n 0.0v 1589.495n 0.0v 1589.505n 0.0v 1599.495n 0.0v 1599.505n 0.0v 1609.495n 0.0v 1609.505n 0.0v 1619.495n 0.0v 1619.505n 0.0v 1629.495n 0.0v 1629.505n 0.0v 1639.495n 0.0v 1639.505n 0.0v 1649.495n 0.0v 1649.505n 0.0v 1659.495n 0.0v 1659.505n 0.0v 1669.495n 0.0v 1669.505n 0.0v 1679.495n 0.0v 1679.505n 0.0v 1689.495n 0.0v 1689.505n 0.0v 1699.495n 0.0v 1699.505n 0.0v 1709.495n 0.0v 1709.505n 0.0v 1719.495n 0.0v 1719.505n 0.0v 1729.495n 0.0v 1729.505n 0.0v 1739.495n 0.0v 1739.505n 0.0v 1749.495n 0.0v 1749.505n 0.0v 1759.495n 0.0v 1759.505n 0.0v 1769.495n 0.0v 1769.505n 0.0v 1779.495n 0.0v 1779.505n 3.3v 1789.495n 3.3v 1789.505n 0.0v 1799.495n 0.0v 1799.505n 0.0v 1809.495n 0.0v 1809.505n 0.0v 1819.495n 0.0v 1819.505n 0.0v 1829.495n 0.0v 1829.505n 0.0v 1839.495n 0.0v 1839.505n 0.0v 1849.495n 0.0v 1849.505n 0.0v 1859.495n 0.0v 1859.505n 0.0v 1869.495n 0.0v 1869.505n 0.0v 1879.495n 0.0v 1879.505n 3.3v 1889.495n 3.3v 1889.505n 3.3v 1899.495n 3.3v 1899.505n 0.0v 1909.495n 0.0v 1909.505n 0.0v 1919.495n 0.0v 1919.505n 0.0v 1929.495n 0.0v 1929.505n 0.0v 1939.495n 0.0v 1939.505n 0.0v 1949.495n 0.0v 1949.505n 0.0v 1959.495n 0.0v 1959.505n 3.3v 1969.495n 3.3v 1969.505n 3.3v 1979.495n 3.3v 1979.505n 3.3v 1989.495n 3.3v 1989.505n 3.3v 1999.495n 3.3v 1999.505n 3.3v 2009.495n 3.3v 2009.505n 3.3v 2019.495n 3.3v 2019.505n 3.3v 2029.495n 3.3v 2029.505n 3.3v 2039.495n 3.3v 2039.505n 3.3v 2049.495n 3.3v 2049.505n 3.3v )
* (time, data): [(0, 0), (10, 0), (20, 0), (30, 1), (40, 1), (50, 1), (60, 1), (70, 1), (80, 1), (90, 1), (100, 0), (110, 0), (120, 0), (130, 0), (140, 0), (150, 0), (160, 0), (170, 0), (180, 0), (190, 0), (200, 0), (210, 0), (220, 0), (230, 0), (240, 0), (250, 0), (260, 1), (270, 0), (280, 1), (290, 0), (300, 0), (310, 0), (320, 0), (330, 1), (340, 1), (350, 1), (360, 1), (370, 1), (380, 1), (390, 0), (400, 0), (410, 0), (420, 0), (430, 0), (440, 0), (450, 0), (460, 1), (470, 0), (480, 0), (490, 0), (500, 0), (510, 0), (520, 0), (530, 1), (540, 0), (550, 0), (560, 0), (570, 0), (580, 1), (590, 1), (600, 1), (610, 1), (620, 1), (630, 1), (640, 1), (650, 1), (660, 1), (670, 1), (680, 1), (690, 1), (700, 1), (710, 1), (720, 1), (730, 1), (740, 1), (750, 1), (760, 1), (770, 1), (780, 0), (790, 1), (800, 1), (810, 1), (820, 1), (830, 1), (840, 1), (850, 1), (860, 1), (870, 1), (880, 1), (890, 1), (900, 1), (910, 1), (920, 1), (930, 1), (940, 1), (950, 1), (960, 1), (970, 1), (980, 1), (990, 0), (1000, 0), (1010, 0), (1020, 0), (1030, 0), (1040, 0), (1050, 1), (1060, 1), (1070, 1), (1080, 1), (1090, 1), (1100, 1), (1110, 1), (1120, 1), (1130, 1), (1140, 1), (1150, 1), (1160, 1), (1170, 1), (1180, 1), (1190, 1), (1200, 1), (1210, 1), (1220, 1), (1230, 1), (1240, 1), (1250, 1), (1260, 1), (1270, 1), (1280, 0), (1290, 1), (1300, 1), (1310, 1), (1320, 1), (1330, 1), (1340, 1), (1350, 1), (1360, 0), (1370, 1), (1380, 1), (1390, 1), (1400, 1), (1410, 1), (1420, 1), (1430, 1), (1440, 1), (1450, 1), (1460, 0), (1470, 0), (1480, 0), (1490, 0), (1500, 1), (1510, 1), (1520, 1), (1530, 0), (1540, 0), (1550, 0), (1560, 0), (1570, 0), (1580, 0), (1590, 0), (1600, 0), (1610, 0), (1620, 0), (1630, 0), (1640, 0), (1650, 0), (1660, 1), (1670, 1), (1680, 1), (1690, 1), (1700, 1), (1710, 0), (1720, 0), (1730, 0), (1740, 0), (1750, 0), (1760, 0), (1770, 0), (1780, 0), (1790, 0), (1800, 0), (1810, 0), (1820, 0), (1830, 0), (1840, 0), (1850, 1), (1860, 1), (1870, 1), (1880, 1), (1890, 1), (1900, 1), (1910, 1), (1920, 1), (1930, 1), (1940, 1), (1950, 1), (1960, 0), (1970, 0), (1980, 0), (1990, 0), (2000, 0), (2010, 0), (2020, 0), (2030, 0), (2040, 0), (2050, 0)]
Vdin0_23  din0_23  0 PWL (0n 0.0v 9.495n 0.0v 9.505n 0.0v 19.495n 0.0v 19.505n 0.0v 29.495n 0.0v 29.505n 3.3v 39.495n 3.3v 39.505n 3.3v 49.495n 3.3v 49.505n 3.3v 59.495n 3.3v 59.505n 3.3v 69.495n 3.3v 69.505n 3.3v 79.495n 3.3v 79.505n 3.3v 89.495n 3.3v 89.505n 3.3v 99.495n 3.3v 99.505n 0.0v 109.495n 0.0v 109.505n 0.0v 119.495n 0.0v 119.505n 0.0v 129.495n 0.0v 129.505n 0.0v 139.495n 0.0v 139.505n 0.0v 149.495n 0.0v 149.505n 0.0v 159.495n 0.0v 159.505n 0.0v 169.495n 0.0v 169.505n 0.0v 179.495n 0.0v 179.505n 0.0v 189.495n 0.0v 189.505n 0.0v 199.495n 0.0v 199.505n 0.0v 209.495n 0.0v 209.505n 0.0v 219.495n 0.0v 219.505n 0.0v 229.495n 0.0v 229.505n 0.0v 239.495n 0.0v 239.505n 0.0v 249.495n 0.0v 249.505n 0.0v 259.495n 0.0v 259.505n 3.3v 269.495n 3.3v 269.505n 0.0v 279.495n 0.0v 279.505n 3.3v 289.495n 3.3v 289.505n 0.0v 299.495n 0.0v 299.505n 0.0v 309.495n 0.0v 309.505n 0.0v 319.495n 0.0v 319.505n 0.0v 329.495n 0.0v 329.505n 3.3v 339.495n 3.3v 339.505n 3.3v 349.495n 3.3v 349.505n 3.3v 359.495n 3.3v 359.505n 3.3v 369.495n 3.3v 369.505n 3.3v 379.495n 3.3v 379.505n 3.3v 389.495n 3.3v 389.505n 0.0v 399.495n 0.0v 399.505n 0.0v 409.495n 0.0v 409.505n 0.0v 419.495n 0.0v 419.505n 0.0v 429.495n 0.0v 429.505n 0.0v 439.495n 0.0v 439.505n 0.0v 449.495n 0.0v 449.505n 0.0v 459.495n 0.0v 459.505n 3.3v 469.495n 3.3v 469.505n 0.0v 479.495n 0.0v 479.505n 0.0v 489.495n 0.0v 489.505n 0.0v 499.495n 0.0v 499.505n 0.0v 509.495n 0.0v 509.505n 0.0v 519.495n 0.0v 519.505n 0.0v 529.495n 0.0v 529.505n 3.3v 539.495n 3.3v 539.505n 0.0v 549.495n 0.0v 549.505n 0.0v 559.495n 0.0v 559.505n 0.0v 569.495n 0.0v 569.505n 0.0v 579.495n 0.0v 579.505n 3.3v 589.495n 3.3v 589.505n 3.3v 599.495n 3.3v 599.505n 3.3v 609.495n 3.3v 609.505n 3.3v 619.495n 3.3v 619.505n 3.3v 629.495n 3.3v 629.505n 3.3v 639.495n 3.3v 639.505n 3.3v 649.495n 3.3v 649.505n 3.3v 659.495n 3.3v 659.505n 3.3v 669.495n 3.3v 669.505n 3.3v 679.495n 3.3v 679.505n 3.3v 689.495n 3.3v 689.505n 3.3v 699.495n 3.3v 699.505n 3.3v 709.495n 3.3v 709.505n 3.3v 719.495n 3.3v 719.505n 3.3v 729.495n 3.3v 729.505n 3.3v 739.495n 3.3v 739.505n 3.3v 749.495n 3.3v 749.505n 3.3v 759.495n 3.3v 759.505n 3.3v 769.495n 3.3v 769.505n 3.3v 779.495n 3.3v 779.505n 0.0v 789.495n 0.0v 789.505n 3.3v 799.495n 3.3v 799.505n 3.3v 809.495n 3.3v 809.505n 3.3v 819.495n 3.3v 819.505n 3.3v 829.495n 3.3v 829.505n 3.3v 839.495n 3.3v 839.505n 3.3v 849.495n 3.3v 849.505n 3.3v 859.495n 3.3v 859.505n 3.3v 869.495n 3.3v 869.505n 3.3v 879.495n 3.3v 879.505n 3.3v 889.495n 3.3v 889.505n 3.3v 899.495n 3.3v 899.505n 3.3v 909.495n 3.3v 909.505n 3.3v 919.495n 3.3v 919.505n 3.3v 929.495n 3.3v 929.505n 3.3v 939.495n 3.3v 939.505n 3.3v 949.495n 3.3v 949.505n 3.3v 959.495n 3.3v 959.505n 3.3v 969.495n 3.3v 969.505n 3.3v 979.495n 3.3v 979.505n 3.3v 989.495n 3.3v 989.505n 0.0v 999.495n 0.0v 999.505n 0.0v 1009.495n 0.0v 1009.505n 0.0v 1019.495n 0.0v 1019.505n 0.0v 1029.495n 0.0v 1029.505n 0.0v 1039.495n 0.0v 1039.505n 0.0v 1049.495n 0.0v 1049.505n 3.3v 1059.495n 3.3v 1059.505n 3.3v 1069.495n 3.3v 1069.505n 3.3v 1079.495n 3.3v 1079.505n 3.3v 1089.495n 3.3v 1089.505n 3.3v 1099.495n 3.3v 1099.505n 3.3v 1109.495n 3.3v 1109.505n 3.3v 1119.495n 3.3v 1119.505n 3.3v 1129.495n 3.3v 1129.505n 3.3v 1139.495n 3.3v 1139.505n 3.3v 1149.495n 3.3v 1149.505n 3.3v 1159.495n 3.3v 1159.505n 3.3v 1169.495n 3.3v 1169.505n 3.3v 1179.495n 3.3v 1179.505n 3.3v 1189.495n 3.3v 1189.505n 3.3v 1199.495n 3.3v 1199.505n 3.3v 1209.495n 3.3v 1209.505n 3.3v 1219.495n 3.3v 1219.505n 3.3v 1229.495n 3.3v 1229.505n 3.3v 1239.495n 3.3v 1239.505n 3.3v 1249.495n 3.3v 1249.505n 3.3v 1259.495n 3.3v 1259.505n 3.3v 1269.495n 3.3v 1269.505n 3.3v 1279.495n 3.3v 1279.505n 0.0v 1289.495n 0.0v 1289.505n 3.3v 1299.495n 3.3v 1299.505n 3.3v 1309.495n 3.3v 1309.505n 3.3v 1319.495n 3.3v 1319.505n 3.3v 1329.495n 3.3v 1329.505n 3.3v 1339.495n 3.3v 1339.505n 3.3v 1349.495n 3.3v 1349.505n 3.3v 1359.495n 3.3v 1359.505n 0.0v 1369.495n 0.0v 1369.505n 3.3v 1379.495n 3.3v 1379.505n 3.3v 1389.495n 3.3v 1389.505n 3.3v 1399.495n 3.3v 1399.505n 3.3v 1409.495n 3.3v 1409.505n 3.3v 1419.495n 3.3v 1419.505n 3.3v 1429.495n 3.3v 1429.505n 3.3v 1439.495n 3.3v 1439.505n 3.3v 1449.495n 3.3v 1449.505n 3.3v 1459.495n 3.3v 1459.505n 0.0v 1469.495n 0.0v 1469.505n 0.0v 1479.495n 0.0v 1479.505n 0.0v 1489.495n 0.0v 1489.505n 0.0v 1499.495n 0.0v 1499.505n 3.3v 1509.495n 3.3v 1509.505n 3.3v 1519.495n 3.3v 1519.505n 3.3v 1529.495n 3.3v 1529.505n 0.0v 1539.495n 0.0v 1539.505n 0.0v 1549.495n 0.0v 1549.505n 0.0v 1559.495n 0.0v 1559.505n 0.0v 1569.495n 0.0v 1569.505n 0.0v 1579.495n 0.0v 1579.505n 0.0v 1589.495n 0.0v 1589.505n 0.0v 1599.495n 0.0v 1599.505n 0.0v 1609.495n 0.0v 1609.505n 0.0v 1619.495n 0.0v 1619.505n 0.0v 1629.495n 0.0v 1629.505n 0.0v 1639.495n 0.0v 1639.505n 0.0v 1649.495n 0.0v 1649.505n 0.0v 1659.495n 0.0v 1659.505n 3.3v 1669.495n 3.3v 1669.505n 3.3v 1679.495n 3.3v 1679.505n 3.3v 1689.495n 3.3v 1689.505n 3.3v 1699.495n 3.3v 1699.505n 3.3v 1709.495n 3.3v 1709.505n 0.0v 1719.495n 0.0v 1719.505n 0.0v 1729.495n 0.0v 1729.505n 0.0v 1739.495n 0.0v 1739.505n 0.0v 1749.495n 0.0v 1749.505n 0.0v 1759.495n 0.0v 1759.505n 0.0v 1769.495n 0.0v 1769.505n 0.0v 1779.495n 0.0v 1779.505n 0.0v 1789.495n 0.0v 1789.505n 0.0v 1799.495n 0.0v 1799.505n 0.0v 1809.495n 0.0v 1809.505n 0.0v 1819.495n 0.0v 1819.505n 0.0v 1829.495n 0.0v 1829.505n 0.0v 1839.495n 0.0v 1839.505n 0.0v 1849.495n 0.0v 1849.505n 3.3v 1859.495n 3.3v 1859.505n 3.3v 1869.495n 3.3v 1869.505n 3.3v 1879.495n 3.3v 1879.505n 3.3v 1889.495n 3.3v 1889.505n 3.3v 1899.495n 3.3v 1899.505n 3.3v 1909.495n 3.3v 1909.505n 3.3v 1919.495n 3.3v 1919.505n 3.3v 1929.495n 3.3v 1929.505n 3.3v 1939.495n 3.3v 1939.505n 3.3v 1949.495n 3.3v 1949.505n 3.3v 1959.495n 3.3v 1959.505n 0.0v 1969.495n 0.0v 1969.505n 0.0v 1979.495n 0.0v 1979.505n 0.0v 1989.495n 0.0v 1989.505n 0.0v 1999.495n 0.0v 1999.505n 0.0v 2009.495n 0.0v 2009.505n 0.0v 2019.495n 0.0v 2019.505n 0.0v 2029.495n 0.0v 2029.505n 0.0v 2039.495n 0.0v 2039.505n 0.0v 2049.495n 0.0v 2049.505n 0.0v )
* (time, data): [(0, 0), (10, 1), (20, 1), (30, 0), (40, 0), (50, 0), (60, 1), (70, 1), (80, 1), (90, 1), (100, 1), (110, 1), (120, 1), (130, 1), (140, 1), (150, 1), (160, 1), (170, 1), (180, 1), (190, 1), (200, 1), (210, 1), (220, 0), (230, 0), (240, 0), (250, 0), (260, 1), (270, 1), (280, 0), (290, 1), (300, 1), (310, 0), (320, 0), (330, 0), (340, 1), (350, 1), (360, 1), (370, 1), (380, 1), (390, 0), (400, 0), (410, 0), (420, 1), (430, 1), (440, 1), (450, 1), (460, 1), (470, 0), (480, 0), (490, 0), (500, 0), (510, 0), (520, 0), (530, 1), (540, 1), (550, 1), (560, 1), (570, 1), (580, 0), (590, 0), (600, 0), (610, 1), (620, 1), (630, 1), (640, 1), (650, 1), (660, 1), (670, 1), (680, 1), (690, 1), (700, 1), (710, 0), (720, 0), (730, 0), (740, 0), (750, 0), (760, 0), (770, 0), (780, 0), (790, 1), (800, 1), (810, 1), (820, 1), (830, 1), (840, 1), (850, 1), (860, 1), (870, 1), (880, 1), (890, 1), (900, 1), (910, 1), (920, 1), (930, 1), (940, 1), (950, 1), (960, 1), (970, 1), (980, 1), (990, 0), (1000, 1), (1010, 1), (1020, 0), (1030, 0), (1040, 0), (1050, 0), (1060, 0), (1070, 1), (1080, 1), (1090, 1), (1100, 1), (1110, 1), (1120, 1), (1130, 1), (1140, 1), (1150, 0), (1160, 0), (1170, 0), (1180, 0), (1190, 0), (1200, 0), (1210, 0), (1220, 0), (1230, 0), (1240, 0), (1250, 0), (1260, 1), (1270, 1), (1280, 1), (1290, 1), (1300, 1), (1310, 1), (1320, 1), (1330, 1), (1340, 0), (1350, 0), (1360, 0), (1370, 0), (1380, 0), (1390, 0), (1400, 0), (1410, 0), (1420, 0), (1430, 0), (1440, 0), (1450, 0), (1460, 1), (1470, 1), (1480, 1), (1490, 1), (1500, 0), (1510, 0), (1520, 0), (1530, 1), (1540, 1), (1550, 1), (1560, 1), (1570, 1), (1580, 1), (1590, 1), (1600, 1), (1610, 1), (1620, 1), (1630, 1), (1640, 1), (1650, 1), (1660, 1), (1670, 1), (1680, 1), (1690, 1), (1700, 1), (1710, 1), (1720, 1), (1730, 1), (1740, 1), (1750, 1), (1760, 1), (1770, 1), (1780, 1), (1790, 0), (1800, 0), (1810, 0), (1820, 0), (1830, 0), (1840, 0), (1850, 0), (1860, 0), (1870, 0), (1880, 0), (1890, 0), (1900, 1), (1910, 1), (1920, 1), (1930, 1), (1940, 1), (1950, 1), (1960, 0), (1970, 0), (1980, 0), (1990, 1), (2000, 1), (2010, 1), (2020, 1), (2030, 1), (2040, 1), (2050, 1)]
Vdin0_24  din0_24  0 PWL (0n 0.0v 9.495n 0.0v 9.505n 3.3v 19.495n 3.3v 19.505n 3.3v 29.495n 3.3v 29.505n 0.0v 39.495n 0.0v 39.505n 0.0v 49.495n 0.0v 49.505n 0.0v 59.495n 0.0v 59.505n 3.3v 69.495n 3.3v 69.505n 3.3v 79.495n 3.3v 79.505n 3.3v 89.495n 3.3v 89.505n 3.3v 99.495n 3.3v 99.505n 3.3v 109.495n 3.3v 109.505n 3.3v 119.495n 3.3v 119.505n 3.3v 129.495n 3.3v 129.505n 3.3v 139.495n 3.3v 139.505n 3.3v 149.495n 3.3v 149.505n 3.3v 159.495n 3.3v 159.505n 3.3v 169.495n 3.3v 169.505n 3.3v 179.495n 3.3v 179.505n 3.3v 189.495n 3.3v 189.505n 3.3v 199.495n 3.3v 199.505n 3.3v 209.495n 3.3v 209.505n 3.3v 219.495n 3.3v 219.505n 0.0v 229.495n 0.0v 229.505n 0.0v 239.495n 0.0v 239.505n 0.0v 249.495n 0.0v 249.505n 0.0v 259.495n 0.0v 259.505n 3.3v 269.495n 3.3v 269.505n 3.3v 279.495n 3.3v 279.505n 0.0v 289.495n 0.0v 289.505n 3.3v 299.495n 3.3v 299.505n 3.3v 309.495n 3.3v 309.505n 0.0v 319.495n 0.0v 319.505n 0.0v 329.495n 0.0v 329.505n 0.0v 339.495n 0.0v 339.505n 3.3v 349.495n 3.3v 349.505n 3.3v 359.495n 3.3v 359.505n 3.3v 369.495n 3.3v 369.505n 3.3v 379.495n 3.3v 379.505n 3.3v 389.495n 3.3v 389.505n 0.0v 399.495n 0.0v 399.505n 0.0v 409.495n 0.0v 409.505n 0.0v 419.495n 0.0v 419.505n 3.3v 429.495n 3.3v 429.505n 3.3v 439.495n 3.3v 439.505n 3.3v 449.495n 3.3v 449.505n 3.3v 459.495n 3.3v 459.505n 3.3v 469.495n 3.3v 469.505n 0.0v 479.495n 0.0v 479.505n 0.0v 489.495n 0.0v 489.505n 0.0v 499.495n 0.0v 499.505n 0.0v 509.495n 0.0v 509.505n 0.0v 519.495n 0.0v 519.505n 0.0v 529.495n 0.0v 529.505n 3.3v 539.495n 3.3v 539.505n 3.3v 549.495n 3.3v 549.505n 3.3v 559.495n 3.3v 559.505n 3.3v 569.495n 3.3v 569.505n 3.3v 579.495n 3.3v 579.505n 0.0v 589.495n 0.0v 589.505n 0.0v 599.495n 0.0v 599.505n 0.0v 609.495n 0.0v 609.505n 3.3v 619.495n 3.3v 619.505n 3.3v 629.495n 3.3v 629.505n 3.3v 639.495n 3.3v 639.505n 3.3v 649.495n 3.3v 649.505n 3.3v 659.495n 3.3v 659.505n 3.3v 669.495n 3.3v 669.505n 3.3v 679.495n 3.3v 679.505n 3.3v 689.495n 3.3v 689.505n 3.3v 699.495n 3.3v 699.505n 3.3v 709.495n 3.3v 709.505n 0.0v 719.495n 0.0v 719.505n 0.0v 729.495n 0.0v 729.505n 0.0v 739.495n 0.0v 739.505n 0.0v 749.495n 0.0v 749.505n 0.0v 759.495n 0.0v 759.505n 0.0v 769.495n 0.0v 769.505n 0.0v 779.495n 0.0v 779.505n 0.0v 789.495n 0.0v 789.505n 3.3v 799.495n 3.3v 799.505n 3.3v 809.495n 3.3v 809.505n 3.3v 819.495n 3.3v 819.505n 3.3v 829.495n 3.3v 829.505n 3.3v 839.495n 3.3v 839.505n 3.3v 849.495n 3.3v 849.505n 3.3v 859.495n 3.3v 859.505n 3.3v 869.495n 3.3v 869.505n 3.3v 879.495n 3.3v 879.505n 3.3v 889.495n 3.3v 889.505n 3.3v 899.495n 3.3v 899.505n 3.3v 909.495n 3.3v 909.505n 3.3v 919.495n 3.3v 919.505n 3.3v 929.495n 3.3v 929.505n 3.3v 939.495n 3.3v 939.505n 3.3v 949.495n 3.3v 949.505n 3.3v 959.495n 3.3v 959.505n 3.3v 969.495n 3.3v 969.505n 3.3v 979.495n 3.3v 979.505n 3.3v 989.495n 3.3v 989.505n 0.0v 999.495n 0.0v 999.505n 3.3v 1009.495n 3.3v 1009.505n 3.3v 1019.495n 3.3v 1019.505n 0.0v 1029.495n 0.0v 1029.505n 0.0v 1039.495n 0.0v 1039.505n 0.0v 1049.495n 0.0v 1049.505n 0.0v 1059.495n 0.0v 1059.505n 0.0v 1069.495n 0.0v 1069.505n 3.3v 1079.495n 3.3v 1079.505n 3.3v 1089.495n 3.3v 1089.505n 3.3v 1099.495n 3.3v 1099.505n 3.3v 1109.495n 3.3v 1109.505n 3.3v 1119.495n 3.3v 1119.505n 3.3v 1129.495n 3.3v 1129.505n 3.3v 1139.495n 3.3v 1139.505n 3.3v 1149.495n 3.3v 1149.505n 0.0v 1159.495n 0.0v 1159.505n 0.0v 1169.495n 0.0v 1169.505n 0.0v 1179.495n 0.0v 1179.505n 0.0v 1189.495n 0.0v 1189.505n 0.0v 1199.495n 0.0v 1199.505n 0.0v 1209.495n 0.0v 1209.505n 0.0v 1219.495n 0.0v 1219.505n 0.0v 1229.495n 0.0v 1229.505n 0.0v 1239.495n 0.0v 1239.505n 0.0v 1249.495n 0.0v 1249.505n 0.0v 1259.495n 0.0v 1259.505n 3.3v 1269.495n 3.3v 1269.505n 3.3v 1279.495n 3.3v 1279.505n 3.3v 1289.495n 3.3v 1289.505n 3.3v 1299.495n 3.3v 1299.505n 3.3v 1309.495n 3.3v 1309.505n 3.3v 1319.495n 3.3v 1319.505n 3.3v 1329.495n 3.3v 1329.505n 3.3v 1339.495n 3.3v 1339.505n 0.0v 1349.495n 0.0v 1349.505n 0.0v 1359.495n 0.0v 1359.505n 0.0v 1369.495n 0.0v 1369.505n 0.0v 1379.495n 0.0v 1379.505n 0.0v 1389.495n 0.0v 1389.505n 0.0v 1399.495n 0.0v 1399.505n 0.0v 1409.495n 0.0v 1409.505n 0.0v 1419.495n 0.0v 1419.505n 0.0v 1429.495n 0.0v 1429.505n 0.0v 1439.495n 0.0v 1439.505n 0.0v 1449.495n 0.0v 1449.505n 0.0v 1459.495n 0.0v 1459.505n 3.3v 1469.495n 3.3v 1469.505n 3.3v 1479.495n 3.3v 1479.505n 3.3v 1489.495n 3.3v 1489.505n 3.3v 1499.495n 3.3v 1499.505n 0.0v 1509.495n 0.0v 1509.505n 0.0v 1519.495n 0.0v 1519.505n 0.0v 1529.495n 0.0v 1529.505n 3.3v 1539.495n 3.3v 1539.505n 3.3v 1549.495n 3.3v 1549.505n 3.3v 1559.495n 3.3v 1559.505n 3.3v 1569.495n 3.3v 1569.505n 3.3v 1579.495n 3.3v 1579.505n 3.3v 1589.495n 3.3v 1589.505n 3.3v 1599.495n 3.3v 1599.505n 3.3v 1609.495n 3.3v 1609.505n 3.3v 1619.495n 3.3v 1619.505n 3.3v 1629.495n 3.3v 1629.505n 3.3v 1639.495n 3.3v 1639.505n 3.3v 1649.495n 3.3v 1649.505n 3.3v 1659.495n 3.3v 1659.505n 3.3v 1669.495n 3.3v 1669.505n 3.3v 1679.495n 3.3v 1679.505n 3.3v 1689.495n 3.3v 1689.505n 3.3v 1699.495n 3.3v 1699.505n 3.3v 1709.495n 3.3v 1709.505n 3.3v 1719.495n 3.3v 1719.505n 3.3v 1729.495n 3.3v 1729.505n 3.3v 1739.495n 3.3v 1739.505n 3.3v 1749.495n 3.3v 1749.505n 3.3v 1759.495n 3.3v 1759.505n 3.3v 1769.495n 3.3v 1769.505n 3.3v 1779.495n 3.3v 1779.505n 3.3v 1789.495n 3.3v 1789.505n 0.0v 1799.495n 0.0v 1799.505n 0.0v 1809.495n 0.0v 1809.505n 0.0v 1819.495n 0.0v 1819.505n 0.0v 1829.495n 0.0v 1829.505n 0.0v 1839.495n 0.0v 1839.505n 0.0v 1849.495n 0.0v 1849.505n 0.0v 1859.495n 0.0v 1859.505n 0.0v 1869.495n 0.0v 1869.505n 0.0v 1879.495n 0.0v 1879.505n 0.0v 1889.495n 0.0v 1889.505n 0.0v 1899.495n 0.0v 1899.505n 3.3v 1909.495n 3.3v 1909.505n 3.3v 1919.495n 3.3v 1919.505n 3.3v 1929.495n 3.3v 1929.505n 3.3v 1939.495n 3.3v 1939.505n 3.3v 1949.495n 3.3v 1949.505n 3.3v 1959.495n 3.3v 1959.505n 0.0v 1969.495n 0.0v 1969.505n 0.0v 1979.495n 0.0v 1979.505n 0.0v 1989.495n 0.0v 1989.505n 3.3v 1999.495n 3.3v 1999.505n 3.3v 2009.495n 3.3v 2009.505n 3.3v 2019.495n 3.3v 2019.505n 3.3v 2029.495n 3.3v 2029.505n 3.3v 2039.495n 3.3v 2039.505n 3.3v 2049.495n 3.3v 2049.505n 3.3v )
* (time, data): [(0, 0), (10, 1), (20, 0), (30, 0), (40, 0), (50, 0), (60, 1), (70, 1), (80, 1), (90, 1), (100, 1), (110, 1), (120, 1), (130, 1), (140, 1), (150, 1), (160, 1), (170, 1), (180, 1), (190, 1), (200, 1), (210, 1), (220, 0), (230, 0), (240, 0), (250, 0), (260, 0), (270, 1), (280, 0), (290, 1), (300, 1), (310, 1), (320, 1), (330, 0), (340, 0), (350, 0), (360, 0), (370, 0), (380, 0), (390, 1), (400, 1), (410, 1), (420, 0), (430, 1), (440, 1), (450, 1), (460, 0), (470, 1), (480, 1), (490, 1), (500, 1), (510, 1), (520, 1), (530, 0), (540, 1), (550, 1), (560, 1), (570, 1), (580, 1), (590, 1), (600, 1), (610, 0), (620, 0), (630, 0), (640, 0), (650, 0), (660, 0), (670, 0), (680, 0), (690, 0), (700, 0), (710, 1), (720, 1), (730, 1), (740, 1), (750, 1), (760, 1), (770, 1), (780, 1), (790, 1), (800, 1), (810, 1), (820, 1), (830, 1), (840, 1), (850, 0), (860, 0), (870, 0), (880, 0), (890, 0), (900, 0), (910, 0), (920, 0), (930, 0), (940, 0), (950, 0), (960, 0), (970, 0), (980, 0), (990, 1), (1000, 1), (1010, 0), (1020, 0), (1030, 0), (1040, 0), (1050, 1), (1060, 1), (1070, 0), (1080, 0), (1090, 0), (1100, 0), (1110, 0), (1120, 0), (1130, 0), (1140, 0), (1150, 0), (1160, 0), (1170, 0), (1180, 0), (1190, 0), (1200, 0), (1210, 0), (1220, 0), (1230, 0), (1240, 1), (1250, 1), (1260, 0), (1270, 0), (1280, 0), (1290, 1), (1300, 1), (1310, 1), (1320, 1), (1330, 1), (1340, 1), (1350, 1), (1360, 1), (1370, 0), (1380, 0), (1390, 0), (1400, 0), (1410, 0), (1420, 0), (1430, 0), (1440, 0), (1450, 0), (1460, 0), (1470, 0), (1480, 0), (1490, 0), (1500, 1), (1510, 1), (1520, 1), (1530, 1), (1540, 1), (1550, 1), (1560, 1), (1570, 1), (1580, 1), (1590, 1), (1600, 1), (1610, 1), (1620, 1), (1630, 1), (1640, 1), (1650, 1), (1660, 0), (1670, 0), (1680, 0), (1690, 0), (1700, 0), (1710, 1), (1720, 1), (1730, 1), (1740, 1), (1750, 1), (1760, 1), (1770, 1), (1780, 1), (1790, 0), (1800, 0), (1810, 0), (1820, 1), (1830, 1), (1840, 1), (1850, 0), (1860, 0), (1870, 0), (1880, 1), (1890, 1), (1900, 1), (1910, 1), (1920, 1), (1930, 1), (1940, 1), (1950, 1), (1960, 1), (1970, 1), (1980, 1), (1990, 1), (2000, 1), (2010, 1), (2020, 1), (2030, 1), (2040, 1), (2050, 1)]
Vdin0_25  din0_25  0 PWL (0n 0.0v 9.495n 0.0v 9.505n 3.3v 19.495n 3.3v 19.505n 0.0v 29.495n 0.0v 29.505n 0.0v 39.495n 0.0v 39.505n 0.0v 49.495n 0.0v 49.505n 0.0v 59.495n 0.0v 59.505n 3.3v 69.495n 3.3v 69.505n 3.3v 79.495n 3.3v 79.505n 3.3v 89.495n 3.3v 89.505n 3.3v 99.495n 3.3v 99.505n 3.3v 109.495n 3.3v 109.505n 3.3v 119.495n 3.3v 119.505n 3.3v 129.495n 3.3v 129.505n 3.3v 139.495n 3.3v 139.505n 3.3v 149.495n 3.3v 149.505n 3.3v 159.495n 3.3v 159.505n 3.3v 169.495n 3.3v 169.505n 3.3v 179.495n 3.3v 179.505n 3.3v 189.495n 3.3v 189.505n 3.3v 199.495n 3.3v 199.505n 3.3v 209.495n 3.3v 209.505n 3.3v 219.495n 3.3v 219.505n 0.0v 229.495n 0.0v 229.505n 0.0v 239.495n 0.0v 239.505n 0.0v 249.495n 0.0v 249.505n 0.0v 259.495n 0.0v 259.505n 0.0v 269.495n 0.0v 269.505n 3.3v 279.495n 3.3v 279.505n 0.0v 289.495n 0.0v 289.505n 3.3v 299.495n 3.3v 299.505n 3.3v 309.495n 3.3v 309.505n 3.3v 319.495n 3.3v 319.505n 3.3v 329.495n 3.3v 329.505n 0.0v 339.495n 0.0v 339.505n 0.0v 349.495n 0.0v 349.505n 0.0v 359.495n 0.0v 359.505n 0.0v 369.495n 0.0v 369.505n 0.0v 379.495n 0.0v 379.505n 0.0v 389.495n 0.0v 389.505n 3.3v 399.495n 3.3v 399.505n 3.3v 409.495n 3.3v 409.505n 3.3v 419.495n 3.3v 419.505n 0.0v 429.495n 0.0v 429.505n 3.3v 439.495n 3.3v 439.505n 3.3v 449.495n 3.3v 449.505n 3.3v 459.495n 3.3v 459.505n 0.0v 469.495n 0.0v 469.505n 3.3v 479.495n 3.3v 479.505n 3.3v 489.495n 3.3v 489.505n 3.3v 499.495n 3.3v 499.505n 3.3v 509.495n 3.3v 509.505n 3.3v 519.495n 3.3v 519.505n 3.3v 529.495n 3.3v 529.505n 0.0v 539.495n 0.0v 539.505n 3.3v 549.495n 3.3v 549.505n 3.3v 559.495n 3.3v 559.505n 3.3v 569.495n 3.3v 569.505n 3.3v 579.495n 3.3v 579.505n 3.3v 589.495n 3.3v 589.505n 3.3v 599.495n 3.3v 599.505n 3.3v 609.495n 3.3v 609.505n 0.0v 619.495n 0.0v 619.505n 0.0v 629.495n 0.0v 629.505n 0.0v 639.495n 0.0v 639.505n 0.0v 649.495n 0.0v 649.505n 0.0v 659.495n 0.0v 659.505n 0.0v 669.495n 0.0v 669.505n 0.0v 679.495n 0.0v 679.505n 0.0v 689.495n 0.0v 689.505n 0.0v 699.495n 0.0v 699.505n 0.0v 709.495n 0.0v 709.505n 3.3v 719.495n 3.3v 719.505n 3.3v 729.495n 3.3v 729.505n 3.3v 739.495n 3.3v 739.505n 3.3v 749.495n 3.3v 749.505n 3.3v 759.495n 3.3v 759.505n 3.3v 769.495n 3.3v 769.505n 3.3v 779.495n 3.3v 779.505n 3.3v 789.495n 3.3v 789.505n 3.3v 799.495n 3.3v 799.505n 3.3v 809.495n 3.3v 809.505n 3.3v 819.495n 3.3v 819.505n 3.3v 829.495n 3.3v 829.505n 3.3v 839.495n 3.3v 839.505n 3.3v 849.495n 3.3v 849.505n 0.0v 859.495n 0.0v 859.505n 0.0v 869.495n 0.0v 869.505n 0.0v 879.495n 0.0v 879.505n 0.0v 889.495n 0.0v 889.505n 0.0v 899.495n 0.0v 899.505n 0.0v 909.495n 0.0v 909.505n 0.0v 919.495n 0.0v 919.505n 0.0v 929.495n 0.0v 929.505n 0.0v 939.495n 0.0v 939.505n 0.0v 949.495n 0.0v 949.505n 0.0v 959.495n 0.0v 959.505n 0.0v 969.495n 0.0v 969.505n 0.0v 979.495n 0.0v 979.505n 0.0v 989.495n 0.0v 989.505n 3.3v 999.495n 3.3v 999.505n 3.3v 1009.495n 3.3v 1009.505n 0.0v 1019.495n 0.0v 1019.505n 0.0v 1029.495n 0.0v 1029.505n 0.0v 1039.495n 0.0v 1039.505n 0.0v 1049.495n 0.0v 1049.505n 3.3v 1059.495n 3.3v 1059.505n 3.3v 1069.495n 3.3v 1069.505n 0.0v 1079.495n 0.0v 1079.505n 0.0v 1089.495n 0.0v 1089.505n 0.0v 1099.495n 0.0v 1099.505n 0.0v 1109.495n 0.0v 1109.505n 0.0v 1119.495n 0.0v 1119.505n 0.0v 1129.495n 0.0v 1129.505n 0.0v 1139.495n 0.0v 1139.505n 0.0v 1149.495n 0.0v 1149.505n 0.0v 1159.495n 0.0v 1159.505n 0.0v 1169.495n 0.0v 1169.505n 0.0v 1179.495n 0.0v 1179.505n 0.0v 1189.495n 0.0v 1189.505n 0.0v 1199.495n 0.0v 1199.505n 0.0v 1209.495n 0.0v 1209.505n 0.0v 1219.495n 0.0v 1219.505n 0.0v 1229.495n 0.0v 1229.505n 0.0v 1239.495n 0.0v 1239.505n 3.3v 1249.495n 3.3v 1249.505n 3.3v 1259.495n 3.3v 1259.505n 0.0v 1269.495n 0.0v 1269.505n 0.0v 1279.495n 0.0v 1279.505n 0.0v 1289.495n 0.0v 1289.505n 3.3v 1299.495n 3.3v 1299.505n 3.3v 1309.495n 3.3v 1309.505n 3.3v 1319.495n 3.3v 1319.505n 3.3v 1329.495n 3.3v 1329.505n 3.3v 1339.495n 3.3v 1339.505n 3.3v 1349.495n 3.3v 1349.505n 3.3v 1359.495n 3.3v 1359.505n 3.3v 1369.495n 3.3v 1369.505n 0.0v 1379.495n 0.0v 1379.505n 0.0v 1389.495n 0.0v 1389.505n 0.0v 1399.495n 0.0v 1399.505n 0.0v 1409.495n 0.0v 1409.505n 0.0v 1419.495n 0.0v 1419.505n 0.0v 1429.495n 0.0v 1429.505n 0.0v 1439.495n 0.0v 1439.505n 0.0v 1449.495n 0.0v 1449.505n 0.0v 1459.495n 0.0v 1459.505n 0.0v 1469.495n 0.0v 1469.505n 0.0v 1479.495n 0.0v 1479.505n 0.0v 1489.495n 0.0v 1489.505n 0.0v 1499.495n 0.0v 1499.505n 3.3v 1509.495n 3.3v 1509.505n 3.3v 1519.495n 3.3v 1519.505n 3.3v 1529.495n 3.3v 1529.505n 3.3v 1539.495n 3.3v 1539.505n 3.3v 1549.495n 3.3v 1549.505n 3.3v 1559.495n 3.3v 1559.505n 3.3v 1569.495n 3.3v 1569.505n 3.3v 1579.495n 3.3v 1579.505n 3.3v 1589.495n 3.3v 1589.505n 3.3v 1599.495n 3.3v 1599.505n 3.3v 1609.495n 3.3v 1609.505n 3.3v 1619.495n 3.3v 1619.505n 3.3v 1629.495n 3.3v 1629.505n 3.3v 1639.495n 3.3v 1639.505n 3.3v 1649.495n 3.3v 1649.505n 3.3v 1659.495n 3.3v 1659.505n 0.0v 1669.495n 0.0v 1669.505n 0.0v 1679.495n 0.0v 1679.505n 0.0v 1689.495n 0.0v 1689.505n 0.0v 1699.495n 0.0v 1699.505n 0.0v 1709.495n 0.0v 1709.505n 3.3v 1719.495n 3.3v 1719.505n 3.3v 1729.495n 3.3v 1729.505n 3.3v 1739.495n 3.3v 1739.505n 3.3v 1749.495n 3.3v 1749.505n 3.3v 1759.495n 3.3v 1759.505n 3.3v 1769.495n 3.3v 1769.505n 3.3v 1779.495n 3.3v 1779.505n 3.3v 1789.495n 3.3v 1789.505n 0.0v 1799.495n 0.0v 1799.505n 0.0v 1809.495n 0.0v 1809.505n 0.0v 1819.495n 0.0v 1819.505n 3.3v 1829.495n 3.3v 1829.505n 3.3v 1839.495n 3.3v 1839.505n 3.3v 1849.495n 3.3v 1849.505n 0.0v 1859.495n 0.0v 1859.505n 0.0v 1869.495n 0.0v 1869.505n 0.0v 1879.495n 0.0v 1879.505n 3.3v 1889.495n 3.3v 1889.505n 3.3v 1899.495n 3.3v 1899.505n 3.3v 1909.495n 3.3v 1909.505n 3.3v 1919.495n 3.3v 1919.505n 3.3v 1929.495n 3.3v 1929.505n 3.3v 1939.495n 3.3v 1939.505n 3.3v 1949.495n 3.3v 1949.505n 3.3v 1959.495n 3.3v 1959.505n 3.3v 1969.495n 3.3v 1969.505n 3.3v 1979.495n 3.3v 1979.505n 3.3v 1989.495n 3.3v 1989.505n 3.3v 1999.495n 3.3v 1999.505n 3.3v 2009.495n 3.3v 2009.505n 3.3v 2019.495n 3.3v 2019.505n 3.3v 2029.495n 3.3v 2029.505n 3.3v 2039.495n 3.3v 2039.505n 3.3v 2049.495n 3.3v 2049.505n 3.3v )
* (time, data): [(0, 0), (10, 0), (20, 1), (30, 0), (40, 0), (50, 0), (60, 0), (70, 0), (80, 0), (90, 0), (100, 1), (110, 1), (120, 1), (130, 1), (140, 1), (150, 1), (160, 1), (170, 1), (180, 1), (190, 1), (200, 1), (210, 1), (220, 0), (230, 0), (240, 0), (250, 0), (260, 0), (270, 1), (280, 1), (290, 1), (300, 1), (310, 0), (320, 0), (330, 1), (340, 0), (350, 0), (360, 0), (370, 0), (380, 0), (390, 0), (400, 0), (410, 0), (420, 0), (430, 0), (440, 0), (450, 0), (460, 1), (470, 1), (480, 1), (490, 1), (500, 1), (510, 1), (520, 1), (530, 1), (540, 0), (550, 0), (560, 0), (570, 0), (580, 1), (590, 1), (600, 1), (610, 1), (620, 1), (630, 1), (640, 1), (650, 1), (660, 1), (670, 1), (680, 1), (690, 1), (700, 1), (710, 1), (720, 1), (730, 1), (740, 1), (750, 1), (760, 1), (770, 1), (780, 1), (790, 1), (800, 1), (810, 1), (820, 1), (830, 1), (840, 1), (850, 0), (860, 0), (870, 0), (880, 0), (890, 0), (900, 0), (910, 0), (920, 0), (930, 0), (940, 0), (950, 0), (960, 0), (970, 0), (980, 0), (990, 0), (1000, 1), (1010, 1), (1020, 1), (1030, 1), (1040, 1), (1050, 0), (1060, 0), (1070, 1), (1080, 1), (1090, 1), (1100, 1), (1110, 1), (1120, 1), (1130, 1), (1140, 1), (1150, 0), (1160, 0), (1170, 0), (1180, 0), (1190, 0), (1200, 0), (1210, 0), (1220, 0), (1230, 0), (1240, 1), (1250, 1), (1260, 1), (1270, 1), (1280, 1), (1290, 1), (1300, 1), (1310, 1), (1320, 1), (1330, 1), (1340, 0), (1350, 0), (1360, 0), (1370, 0), (1380, 0), (1390, 0), (1400, 0), (1410, 0), (1420, 0), (1430, 0), (1440, 0), (1450, 0), (1460, 0), (1470, 0), (1480, 0), (1490, 0), (1500, 0), (1510, 0), (1520, 0), (1530, 1), (1540, 1), (1550, 1), (1560, 1), (1570, 1), (1580, 1), (1590, 1), (1600, 1), (1610, 1), (1620, 1), (1630, 1), (1640, 1), (1650, 1), (1660, 0), (1670, 0), (1680, 0), (1690, 0), (1700, 0), (1710, 1), (1720, 1), (1730, 1), (1740, 1), (1750, 1), (1760, 1), (1770, 1), (1780, 1), (1790, 0), (1800, 0), (1810, 0), (1820, 1), (1830, 1), (1840, 1), (1850, 1), (1860, 1), (1870, 1), (1880, 0), (1890, 0), (1900, 1), (1910, 1), (1920, 1), (1930, 1), (1940, 1), (1950, 1), (1960, 1), (1970, 1), (1980, 1), (1990, 1), (2000, 1), (2010, 1), (2020, 1), (2030, 1), (2040, 1), (2050, 1)]
Vdin0_26  din0_26  0 PWL (0n 0.0v 9.495n 0.0v 9.505n 0.0v 19.495n 0.0v 19.505n 3.3v 29.495n 3.3v 29.505n 0.0v 39.495n 0.0v 39.505n 0.0v 49.495n 0.0v 49.505n 0.0v 59.495n 0.0v 59.505n 0.0v 69.495n 0.0v 69.505n 0.0v 79.495n 0.0v 79.505n 0.0v 89.495n 0.0v 89.505n 0.0v 99.495n 0.0v 99.505n 3.3v 109.495n 3.3v 109.505n 3.3v 119.495n 3.3v 119.505n 3.3v 129.495n 3.3v 129.505n 3.3v 139.495n 3.3v 139.505n 3.3v 149.495n 3.3v 149.505n 3.3v 159.495n 3.3v 159.505n 3.3v 169.495n 3.3v 169.505n 3.3v 179.495n 3.3v 179.505n 3.3v 189.495n 3.3v 189.505n 3.3v 199.495n 3.3v 199.505n 3.3v 209.495n 3.3v 209.505n 3.3v 219.495n 3.3v 219.505n 0.0v 229.495n 0.0v 229.505n 0.0v 239.495n 0.0v 239.505n 0.0v 249.495n 0.0v 249.505n 0.0v 259.495n 0.0v 259.505n 0.0v 269.495n 0.0v 269.505n 3.3v 279.495n 3.3v 279.505n 3.3v 289.495n 3.3v 289.505n 3.3v 299.495n 3.3v 299.505n 3.3v 309.495n 3.3v 309.505n 0.0v 319.495n 0.0v 319.505n 0.0v 329.495n 0.0v 329.505n 3.3v 339.495n 3.3v 339.505n 0.0v 349.495n 0.0v 349.505n 0.0v 359.495n 0.0v 359.505n 0.0v 369.495n 0.0v 369.505n 0.0v 379.495n 0.0v 379.505n 0.0v 389.495n 0.0v 389.505n 0.0v 399.495n 0.0v 399.505n 0.0v 409.495n 0.0v 409.505n 0.0v 419.495n 0.0v 419.505n 0.0v 429.495n 0.0v 429.505n 0.0v 439.495n 0.0v 439.505n 0.0v 449.495n 0.0v 449.505n 0.0v 459.495n 0.0v 459.505n 3.3v 469.495n 3.3v 469.505n 3.3v 479.495n 3.3v 479.505n 3.3v 489.495n 3.3v 489.505n 3.3v 499.495n 3.3v 499.505n 3.3v 509.495n 3.3v 509.505n 3.3v 519.495n 3.3v 519.505n 3.3v 529.495n 3.3v 529.505n 3.3v 539.495n 3.3v 539.505n 0.0v 549.495n 0.0v 549.505n 0.0v 559.495n 0.0v 559.505n 0.0v 569.495n 0.0v 569.505n 0.0v 579.495n 0.0v 579.505n 3.3v 589.495n 3.3v 589.505n 3.3v 599.495n 3.3v 599.505n 3.3v 609.495n 3.3v 609.505n 3.3v 619.495n 3.3v 619.505n 3.3v 629.495n 3.3v 629.505n 3.3v 639.495n 3.3v 639.505n 3.3v 649.495n 3.3v 649.505n 3.3v 659.495n 3.3v 659.505n 3.3v 669.495n 3.3v 669.505n 3.3v 679.495n 3.3v 679.505n 3.3v 689.495n 3.3v 689.505n 3.3v 699.495n 3.3v 699.505n 3.3v 709.495n 3.3v 709.505n 3.3v 719.495n 3.3v 719.505n 3.3v 729.495n 3.3v 729.505n 3.3v 739.495n 3.3v 739.505n 3.3v 749.495n 3.3v 749.505n 3.3v 759.495n 3.3v 759.505n 3.3v 769.495n 3.3v 769.505n 3.3v 779.495n 3.3v 779.505n 3.3v 789.495n 3.3v 789.505n 3.3v 799.495n 3.3v 799.505n 3.3v 809.495n 3.3v 809.505n 3.3v 819.495n 3.3v 819.505n 3.3v 829.495n 3.3v 829.505n 3.3v 839.495n 3.3v 839.505n 3.3v 849.495n 3.3v 849.505n 0.0v 859.495n 0.0v 859.505n 0.0v 869.495n 0.0v 869.505n 0.0v 879.495n 0.0v 879.505n 0.0v 889.495n 0.0v 889.505n 0.0v 899.495n 0.0v 899.505n 0.0v 909.495n 0.0v 909.505n 0.0v 919.495n 0.0v 919.505n 0.0v 929.495n 0.0v 929.505n 0.0v 939.495n 0.0v 939.505n 0.0v 949.495n 0.0v 949.505n 0.0v 959.495n 0.0v 959.505n 0.0v 969.495n 0.0v 969.505n 0.0v 979.495n 0.0v 979.505n 0.0v 989.495n 0.0v 989.505n 0.0v 999.495n 0.0v 999.505n 3.3v 1009.495n 3.3v 1009.505n 3.3v 1019.495n 3.3v 1019.505n 3.3v 1029.495n 3.3v 1029.505n 3.3v 1039.495n 3.3v 1039.505n 3.3v 1049.495n 3.3v 1049.505n 0.0v 1059.495n 0.0v 1059.505n 0.0v 1069.495n 0.0v 1069.505n 3.3v 1079.495n 3.3v 1079.505n 3.3v 1089.495n 3.3v 1089.505n 3.3v 1099.495n 3.3v 1099.505n 3.3v 1109.495n 3.3v 1109.505n 3.3v 1119.495n 3.3v 1119.505n 3.3v 1129.495n 3.3v 1129.505n 3.3v 1139.495n 3.3v 1139.505n 3.3v 1149.495n 3.3v 1149.505n 0.0v 1159.495n 0.0v 1159.505n 0.0v 1169.495n 0.0v 1169.505n 0.0v 1179.495n 0.0v 1179.505n 0.0v 1189.495n 0.0v 1189.505n 0.0v 1199.495n 0.0v 1199.505n 0.0v 1209.495n 0.0v 1209.505n 0.0v 1219.495n 0.0v 1219.505n 0.0v 1229.495n 0.0v 1229.505n 0.0v 1239.495n 0.0v 1239.505n 3.3v 1249.495n 3.3v 1249.505n 3.3v 1259.495n 3.3v 1259.505n 3.3v 1269.495n 3.3v 1269.505n 3.3v 1279.495n 3.3v 1279.505n 3.3v 1289.495n 3.3v 1289.505n 3.3v 1299.495n 3.3v 1299.505n 3.3v 1309.495n 3.3v 1309.505n 3.3v 1319.495n 3.3v 1319.505n 3.3v 1329.495n 3.3v 1329.505n 3.3v 1339.495n 3.3v 1339.505n 0.0v 1349.495n 0.0v 1349.505n 0.0v 1359.495n 0.0v 1359.505n 0.0v 1369.495n 0.0v 1369.505n 0.0v 1379.495n 0.0v 1379.505n 0.0v 1389.495n 0.0v 1389.505n 0.0v 1399.495n 0.0v 1399.505n 0.0v 1409.495n 0.0v 1409.505n 0.0v 1419.495n 0.0v 1419.505n 0.0v 1429.495n 0.0v 1429.505n 0.0v 1439.495n 0.0v 1439.505n 0.0v 1449.495n 0.0v 1449.505n 0.0v 1459.495n 0.0v 1459.505n 0.0v 1469.495n 0.0v 1469.505n 0.0v 1479.495n 0.0v 1479.505n 0.0v 1489.495n 0.0v 1489.505n 0.0v 1499.495n 0.0v 1499.505n 0.0v 1509.495n 0.0v 1509.505n 0.0v 1519.495n 0.0v 1519.505n 0.0v 1529.495n 0.0v 1529.505n 3.3v 1539.495n 3.3v 1539.505n 3.3v 1549.495n 3.3v 1549.505n 3.3v 1559.495n 3.3v 1559.505n 3.3v 1569.495n 3.3v 1569.505n 3.3v 1579.495n 3.3v 1579.505n 3.3v 1589.495n 3.3v 1589.505n 3.3v 1599.495n 3.3v 1599.505n 3.3v 1609.495n 3.3v 1609.505n 3.3v 1619.495n 3.3v 1619.505n 3.3v 1629.495n 3.3v 1629.505n 3.3v 1639.495n 3.3v 1639.505n 3.3v 1649.495n 3.3v 1649.505n 3.3v 1659.495n 3.3v 1659.505n 0.0v 1669.495n 0.0v 1669.505n 0.0v 1679.495n 0.0v 1679.505n 0.0v 1689.495n 0.0v 1689.505n 0.0v 1699.495n 0.0v 1699.505n 0.0v 1709.495n 0.0v 1709.505n 3.3v 1719.495n 3.3v 1719.505n 3.3v 1729.495n 3.3v 1729.505n 3.3v 1739.495n 3.3v 1739.505n 3.3v 1749.495n 3.3v 1749.505n 3.3v 1759.495n 3.3v 1759.505n 3.3v 1769.495n 3.3v 1769.505n 3.3v 1779.495n 3.3v 1779.505n 3.3v 1789.495n 3.3v 1789.505n 0.0v 1799.495n 0.0v 1799.505n 0.0v 1809.495n 0.0v 1809.505n 0.0v 1819.495n 0.0v 1819.505n 3.3v 1829.495n 3.3v 1829.505n 3.3v 1839.495n 3.3v 1839.505n 3.3v 1849.495n 3.3v 1849.505n 3.3v 1859.495n 3.3v 1859.505n 3.3v 1869.495n 3.3v 1869.505n 3.3v 1879.495n 3.3v 1879.505n 0.0v 1889.495n 0.0v 1889.505n 0.0v 1899.495n 0.0v 1899.505n 3.3v 1909.495n 3.3v 1909.505n 3.3v 1919.495n 3.3v 1919.505n 3.3v 1929.495n 3.3v 1929.505n 3.3v 1939.495n 3.3v 1939.505n 3.3v 1949.495n 3.3v 1949.505n 3.3v 1959.495n 3.3v 1959.505n 3.3v 1969.495n 3.3v 1969.505n 3.3v 1979.495n 3.3v 1979.505n 3.3v 1989.495n 3.3v 1989.505n 3.3v 1999.495n 3.3v 1999.505n 3.3v 2009.495n 3.3v 2009.505n 3.3v 2019.495n 3.3v 2019.505n 3.3v 2029.495n 3.3v 2029.505n 3.3v 2039.495n 3.3v 2039.505n 3.3v 2049.495n 3.3v 2049.505n 3.3v )
* (time, data): [(0, 0), (10, 0), (20, 0), (30, 1), (40, 1), (50, 1), (60, 0), (70, 0), (80, 0), (90, 0), (100, 0), (110, 0), (120, 0), (130, 0), (140, 0), (150, 0), (160, 0), (170, 0), (180, 0), (190, 0), (200, 0), (210, 0), (220, 1), (230, 1), (240, 1), (250, 1), (260, 0), (270, 1), (280, 1), (290, 0), (300, 0), (310, 0), (320, 0), (330, 0), (340, 1), (350, 1), (360, 1), (370, 1), (380, 1), (390, 1), (400, 1), (410, 1), (420, 0), (430, 1), (440, 1), (450, 1), (460, 1), (470, 1), (480, 1), (490, 1), (500, 1), (510, 1), (520, 1), (530, 1), (540, 0), (550, 0), (560, 1), (570, 1), (580, 0), (590, 0), (600, 0), (610, 1), (620, 1), (630, 1), (640, 1), (650, 1), (660, 1), (670, 1), (680, 1), (690, 1), (700, 1), (710, 1), (720, 1), (730, 1), (740, 1), (750, 1), (760, 1), (770, 1), (780, 0), (790, 0), (800, 0), (810, 0), (820, 0), (830, 0), (840, 0), (850, 1), (860, 1), (870, 1), (880, 1), (890, 1), (900, 1), (910, 1), (920, 1), (930, 1), (940, 1), (950, 1), (960, 1), (970, 1), (980, 1), (990, 0), (1000, 0), (1010, 0), (1020, 0), (1030, 0), (1040, 0), (1050, 0), (1060, 0), (1070, 1), (1080, 1), (1090, 1), (1100, 1), (1110, 1), (1120, 1), (1130, 1), (1140, 1), (1150, 0), (1160, 0), (1170, 0), (1180, 0), (1190, 0), (1200, 0), (1210, 0), (1220, 0), (1230, 0), (1240, 1), (1250, 1), (1260, 1), (1270, 1), (1280, 0), (1290, 1), (1300, 1), (1310, 1), (1320, 1), (1330, 1), (1340, 0), (1350, 0), (1360, 1), (1370, 0), (1380, 0), (1390, 0), (1400, 0), (1410, 0), (1420, 0), (1430, 0), (1440, 0), (1450, 0), (1460, 0), (1470, 0), (1480, 0), (1490, 0), (1500, 1), (1510, 1), (1520, 1), (1530, 1), (1540, 1), (1550, 1), (1560, 1), (1570, 1), (1580, 1), (1590, 1), (1600, 1), (1610, 1), (1620, 1), (1630, 1), (1640, 1), (1650, 1), (1660, 1), (1670, 1), (1680, 1), (1690, 1), (1700, 1), (1710, 0), (1720, 0), (1730, 0), (1740, 0), (1750, 0), (1760, 0), (1770, 0), (1780, 1), (1790, 0), (1800, 0), (1810, 0), (1820, 0), (1830, 0), (1840, 0), (1850, 0), (1860, 0), (1870, 0), (1880, 0), (1890, 0), (1900, 1), (1910, 1), (1920, 1), (1930, 1), (1940, 1), (1950, 1), (1960, 1), (1970, 1), (1980, 1), (1990, 1), (2000, 1), (2010, 1), (2020, 1), (2030, 1), (2040, 1), (2050, 1)]
Vdin0_27  din0_27  0 PWL (0n 0.0v 9.495n 0.0v 9.505n 0.0v 19.495n 0.0v 19.505n 0.0v 29.495n 0.0v 29.505n 3.3v 39.495n 3.3v 39.505n 3.3v 49.495n 3.3v 49.505n 3.3v 59.495n 3.3v 59.505n 0.0v 69.495n 0.0v 69.505n 0.0v 79.495n 0.0v 79.505n 0.0v 89.495n 0.0v 89.505n 0.0v 99.495n 0.0v 99.505n 0.0v 109.495n 0.0v 109.505n 0.0v 119.495n 0.0v 119.505n 0.0v 129.495n 0.0v 129.505n 0.0v 139.495n 0.0v 139.505n 0.0v 149.495n 0.0v 149.505n 0.0v 159.495n 0.0v 159.505n 0.0v 169.495n 0.0v 169.505n 0.0v 179.495n 0.0v 179.505n 0.0v 189.495n 0.0v 189.505n 0.0v 199.495n 0.0v 199.505n 0.0v 209.495n 0.0v 209.505n 0.0v 219.495n 0.0v 219.505n 3.3v 229.495n 3.3v 229.505n 3.3v 239.495n 3.3v 239.505n 3.3v 249.495n 3.3v 249.505n 3.3v 259.495n 3.3v 259.505n 0.0v 269.495n 0.0v 269.505n 3.3v 279.495n 3.3v 279.505n 3.3v 289.495n 3.3v 289.505n 0.0v 299.495n 0.0v 299.505n 0.0v 309.495n 0.0v 309.505n 0.0v 319.495n 0.0v 319.505n 0.0v 329.495n 0.0v 329.505n 0.0v 339.495n 0.0v 339.505n 3.3v 349.495n 3.3v 349.505n 3.3v 359.495n 3.3v 359.505n 3.3v 369.495n 3.3v 369.505n 3.3v 379.495n 3.3v 379.505n 3.3v 389.495n 3.3v 389.505n 3.3v 399.495n 3.3v 399.505n 3.3v 409.495n 3.3v 409.505n 3.3v 419.495n 3.3v 419.505n 0.0v 429.495n 0.0v 429.505n 3.3v 439.495n 3.3v 439.505n 3.3v 449.495n 3.3v 449.505n 3.3v 459.495n 3.3v 459.505n 3.3v 469.495n 3.3v 469.505n 3.3v 479.495n 3.3v 479.505n 3.3v 489.495n 3.3v 489.505n 3.3v 499.495n 3.3v 499.505n 3.3v 509.495n 3.3v 509.505n 3.3v 519.495n 3.3v 519.505n 3.3v 529.495n 3.3v 529.505n 3.3v 539.495n 3.3v 539.505n 0.0v 549.495n 0.0v 549.505n 0.0v 559.495n 0.0v 559.505n 3.3v 569.495n 3.3v 569.505n 3.3v 579.495n 3.3v 579.505n 0.0v 589.495n 0.0v 589.505n 0.0v 599.495n 0.0v 599.505n 0.0v 609.495n 0.0v 609.505n 3.3v 619.495n 3.3v 619.505n 3.3v 629.495n 3.3v 629.505n 3.3v 639.495n 3.3v 639.505n 3.3v 649.495n 3.3v 649.505n 3.3v 659.495n 3.3v 659.505n 3.3v 669.495n 3.3v 669.505n 3.3v 679.495n 3.3v 679.505n 3.3v 689.495n 3.3v 689.505n 3.3v 699.495n 3.3v 699.505n 3.3v 709.495n 3.3v 709.505n 3.3v 719.495n 3.3v 719.505n 3.3v 729.495n 3.3v 729.505n 3.3v 739.495n 3.3v 739.505n 3.3v 749.495n 3.3v 749.505n 3.3v 759.495n 3.3v 759.505n 3.3v 769.495n 3.3v 769.505n 3.3v 779.495n 3.3v 779.505n 0.0v 789.495n 0.0v 789.505n 0.0v 799.495n 0.0v 799.505n 0.0v 809.495n 0.0v 809.505n 0.0v 819.495n 0.0v 819.505n 0.0v 829.495n 0.0v 829.505n 0.0v 839.495n 0.0v 839.505n 0.0v 849.495n 0.0v 849.505n 3.3v 859.495n 3.3v 859.505n 3.3v 869.495n 3.3v 869.505n 3.3v 879.495n 3.3v 879.505n 3.3v 889.495n 3.3v 889.505n 3.3v 899.495n 3.3v 899.505n 3.3v 909.495n 3.3v 909.505n 3.3v 919.495n 3.3v 919.505n 3.3v 929.495n 3.3v 929.505n 3.3v 939.495n 3.3v 939.505n 3.3v 949.495n 3.3v 949.505n 3.3v 959.495n 3.3v 959.505n 3.3v 969.495n 3.3v 969.505n 3.3v 979.495n 3.3v 979.505n 3.3v 989.495n 3.3v 989.505n 0.0v 999.495n 0.0v 999.505n 0.0v 1009.495n 0.0v 1009.505n 0.0v 1019.495n 0.0v 1019.505n 0.0v 1029.495n 0.0v 1029.505n 0.0v 1039.495n 0.0v 1039.505n 0.0v 1049.495n 0.0v 1049.505n 0.0v 1059.495n 0.0v 1059.505n 0.0v 1069.495n 0.0v 1069.505n 3.3v 1079.495n 3.3v 1079.505n 3.3v 1089.495n 3.3v 1089.505n 3.3v 1099.495n 3.3v 1099.505n 3.3v 1109.495n 3.3v 1109.505n 3.3v 1119.495n 3.3v 1119.505n 3.3v 1129.495n 3.3v 1129.505n 3.3v 1139.495n 3.3v 1139.505n 3.3v 1149.495n 3.3v 1149.505n 0.0v 1159.495n 0.0v 1159.505n 0.0v 1169.495n 0.0v 1169.505n 0.0v 1179.495n 0.0v 1179.505n 0.0v 1189.495n 0.0v 1189.505n 0.0v 1199.495n 0.0v 1199.505n 0.0v 1209.495n 0.0v 1209.505n 0.0v 1219.495n 0.0v 1219.505n 0.0v 1229.495n 0.0v 1229.505n 0.0v 1239.495n 0.0v 1239.505n 3.3v 1249.495n 3.3v 1249.505n 3.3v 1259.495n 3.3v 1259.505n 3.3v 1269.495n 3.3v 1269.505n 3.3v 1279.495n 3.3v 1279.505n 0.0v 1289.495n 0.0v 1289.505n 3.3v 1299.495n 3.3v 1299.505n 3.3v 1309.495n 3.3v 1309.505n 3.3v 1319.495n 3.3v 1319.505n 3.3v 1329.495n 3.3v 1329.505n 3.3v 1339.495n 3.3v 1339.505n 0.0v 1349.495n 0.0v 1349.505n 0.0v 1359.495n 0.0v 1359.505n 3.3v 1369.495n 3.3v 1369.505n 0.0v 1379.495n 0.0v 1379.505n 0.0v 1389.495n 0.0v 1389.505n 0.0v 1399.495n 0.0v 1399.505n 0.0v 1409.495n 0.0v 1409.505n 0.0v 1419.495n 0.0v 1419.505n 0.0v 1429.495n 0.0v 1429.505n 0.0v 1439.495n 0.0v 1439.505n 0.0v 1449.495n 0.0v 1449.505n 0.0v 1459.495n 0.0v 1459.505n 0.0v 1469.495n 0.0v 1469.505n 0.0v 1479.495n 0.0v 1479.505n 0.0v 1489.495n 0.0v 1489.505n 0.0v 1499.495n 0.0v 1499.505n 3.3v 1509.495n 3.3v 1509.505n 3.3v 1519.495n 3.3v 1519.505n 3.3v 1529.495n 3.3v 1529.505n 3.3v 1539.495n 3.3v 1539.505n 3.3v 1549.495n 3.3v 1549.505n 3.3v 1559.495n 3.3v 1559.505n 3.3v 1569.495n 3.3v 1569.505n 3.3v 1579.495n 3.3v 1579.505n 3.3v 1589.495n 3.3v 1589.505n 3.3v 1599.495n 3.3v 1599.505n 3.3v 1609.495n 3.3v 1609.505n 3.3v 1619.495n 3.3v 1619.505n 3.3v 1629.495n 3.3v 1629.505n 3.3v 1639.495n 3.3v 1639.505n 3.3v 1649.495n 3.3v 1649.505n 3.3v 1659.495n 3.3v 1659.505n 3.3v 1669.495n 3.3v 1669.505n 3.3v 1679.495n 3.3v 1679.505n 3.3v 1689.495n 3.3v 1689.505n 3.3v 1699.495n 3.3v 1699.505n 3.3v 1709.495n 3.3v 1709.505n 0.0v 1719.495n 0.0v 1719.505n 0.0v 1729.495n 0.0v 1729.505n 0.0v 1739.495n 0.0v 1739.505n 0.0v 1749.495n 0.0v 1749.505n 0.0v 1759.495n 0.0v 1759.505n 0.0v 1769.495n 0.0v 1769.505n 0.0v 1779.495n 0.0v 1779.505n 3.3v 1789.495n 3.3v 1789.505n 0.0v 1799.495n 0.0v 1799.505n 0.0v 1809.495n 0.0v 1809.505n 0.0v 1819.495n 0.0v 1819.505n 0.0v 1829.495n 0.0v 1829.505n 0.0v 1839.495n 0.0v 1839.505n 0.0v 1849.495n 0.0v 1849.505n 0.0v 1859.495n 0.0v 1859.505n 0.0v 1869.495n 0.0v 1869.505n 0.0v 1879.495n 0.0v 1879.505n 0.0v 1889.495n 0.0v 1889.505n 0.0v 1899.495n 0.0v 1899.505n 3.3v 1909.495n 3.3v 1909.505n 3.3v 1919.495n 3.3v 1919.505n 3.3v 1929.495n 3.3v 1929.505n 3.3v 1939.495n 3.3v 1939.505n 3.3v 1949.495n 3.3v 1949.505n 3.3v 1959.495n 3.3v 1959.505n 3.3v 1969.495n 3.3v 1969.505n 3.3v 1979.495n 3.3v 1979.505n 3.3v 1989.495n 3.3v 1989.505n 3.3v 1999.495n 3.3v 1999.505n 3.3v 2009.495n 3.3v 2009.505n 3.3v 2019.495n 3.3v 2019.505n 3.3v 2029.495n 3.3v 2029.505n 3.3v 2039.495n 3.3v 2039.505n 3.3v 2049.495n 3.3v 2049.505n 3.3v )
* (time, data): [(0, 0), (10, 0), (20, 1), (30, 1), (40, 1), (50, 1), (60, 1), (70, 1), (80, 1), (90, 1), (100, 1), (110, 1), (120, 1), (130, 1), (140, 1), (150, 1), (160, 1), (170, 1), (180, 1), (190, 1), (200, 1), (210, 1), (220, 0), (230, 0), (240, 0), (250, 0), (260, 1), (270, 1), (280, 1), (290, 0), (300, 0), (310, 1), (320, 1), (330, 0), (340, 1), (350, 1), (360, 1), (370, 1), (380, 1), (390, 1), (400, 1), (410, 1), (420, 0), (430, 0), (440, 0), (450, 0), (460, 0), (470, 0), (480, 0), (490, 0), (500, 0), (510, 0), (520, 0), (530, 1), (540, 1), (550, 1), (560, 0), (570, 0), (580, 1), (590, 1), (600, 1), (610, 0), (620, 0), (630, 0), (640, 0), (650, 0), (660, 0), (670, 0), (680, 0), (690, 0), (700, 0), (710, 1), (720, 1), (730, 1), (740, 1), (750, 1), (760, 1), (770, 1), (780, 1), (790, 0), (800, 0), (810, 0), (820, 0), (830, 0), (840, 0), (850, 0), (860, 0), (870, 0), (880, 0), (890, 0), (900, 0), (910, 0), (920, 0), (930, 0), (940, 0), (950, 0), (960, 0), (970, 0), (980, 0), (990, 1), (1000, 1), (1010, 1), (1020, 0), (1030, 0), (1040, 0), (1050, 0), (1060, 0), (1070, 1), (1080, 1), (1090, 1), (1100, 1), (1110, 1), (1120, 1), (1130, 1), (1140, 1), (1150, 0), (1160, 0), (1170, 0), (1180, 0), (1190, 0), (1200, 0), (1210, 0), (1220, 0), (1230, 0), (1240, 0), (1250, 0), (1260, 1), (1270, 1), (1280, 1), (1290, 0), (1300, 0), (1310, 0), (1320, 0), (1330, 0), (1340, 1), (1350, 1), (1360, 0), (1370, 1), (1380, 1), (1390, 1), (1400, 1), (1410, 1), (1420, 1), (1430, 1), (1440, 1), (1450, 1), (1460, 0), (1470, 0), (1480, 0), (1490, 0), (1500, 0), (1510, 0), (1520, 0), (1530, 1), (1540, 1), (1550, 1), (1560, 1), (1570, 1), (1580, 1), (1590, 1), (1600, 1), (1610, 1), (1620, 1), (1630, 1), (1640, 1), (1650, 1), (1660, 1), (1670, 1), (1680, 1), (1690, 1), (1700, 1), (1710, 0), (1720, 0), (1730, 0), (1740, 0), (1750, 0), (1760, 0), (1770, 0), (1780, 0), (1790, 1), (1800, 1), (1810, 1), (1820, 1), (1830, 1), (1840, 1), (1850, 1), (1860, 1), (1870, 1), (1880, 1), (1890, 1), (1900, 1), (1910, 1), (1920, 1), (1930, 1), (1940, 1), (1950, 1), (1960, 0), (1970, 0), (1980, 0), (1990, 1), (2000, 1), (2010, 1), (2020, 1), (2030, 1), (2040, 1), (2050, 1)]
Vdin0_28  din0_28  0 PWL (0n 0.0v 9.495n 0.0v 9.505n 0.0v 19.495n 0.0v 19.505n 3.3v 29.495n 3.3v 29.505n 3.3v 39.495n 3.3v 39.505n 3.3v 49.495n 3.3v 49.505n 3.3v 59.495n 3.3v 59.505n 3.3v 69.495n 3.3v 69.505n 3.3v 79.495n 3.3v 79.505n 3.3v 89.495n 3.3v 89.505n 3.3v 99.495n 3.3v 99.505n 3.3v 109.495n 3.3v 109.505n 3.3v 119.495n 3.3v 119.505n 3.3v 129.495n 3.3v 129.505n 3.3v 139.495n 3.3v 139.505n 3.3v 149.495n 3.3v 149.505n 3.3v 159.495n 3.3v 159.505n 3.3v 169.495n 3.3v 169.505n 3.3v 179.495n 3.3v 179.505n 3.3v 189.495n 3.3v 189.505n 3.3v 199.495n 3.3v 199.505n 3.3v 209.495n 3.3v 209.505n 3.3v 219.495n 3.3v 219.505n 0.0v 229.495n 0.0v 229.505n 0.0v 239.495n 0.0v 239.505n 0.0v 249.495n 0.0v 249.505n 0.0v 259.495n 0.0v 259.505n 3.3v 269.495n 3.3v 269.505n 3.3v 279.495n 3.3v 279.505n 3.3v 289.495n 3.3v 289.505n 0.0v 299.495n 0.0v 299.505n 0.0v 309.495n 0.0v 309.505n 3.3v 319.495n 3.3v 319.505n 3.3v 329.495n 3.3v 329.505n 0.0v 339.495n 0.0v 339.505n 3.3v 349.495n 3.3v 349.505n 3.3v 359.495n 3.3v 359.505n 3.3v 369.495n 3.3v 369.505n 3.3v 379.495n 3.3v 379.505n 3.3v 389.495n 3.3v 389.505n 3.3v 399.495n 3.3v 399.505n 3.3v 409.495n 3.3v 409.505n 3.3v 419.495n 3.3v 419.505n 0.0v 429.495n 0.0v 429.505n 0.0v 439.495n 0.0v 439.505n 0.0v 449.495n 0.0v 449.505n 0.0v 459.495n 0.0v 459.505n 0.0v 469.495n 0.0v 469.505n 0.0v 479.495n 0.0v 479.505n 0.0v 489.495n 0.0v 489.505n 0.0v 499.495n 0.0v 499.505n 0.0v 509.495n 0.0v 509.505n 0.0v 519.495n 0.0v 519.505n 0.0v 529.495n 0.0v 529.505n 3.3v 539.495n 3.3v 539.505n 3.3v 549.495n 3.3v 549.505n 3.3v 559.495n 3.3v 559.505n 0.0v 569.495n 0.0v 569.505n 0.0v 579.495n 0.0v 579.505n 3.3v 589.495n 3.3v 589.505n 3.3v 599.495n 3.3v 599.505n 3.3v 609.495n 3.3v 609.505n 0.0v 619.495n 0.0v 619.505n 0.0v 629.495n 0.0v 629.505n 0.0v 639.495n 0.0v 639.505n 0.0v 649.495n 0.0v 649.505n 0.0v 659.495n 0.0v 659.505n 0.0v 669.495n 0.0v 669.505n 0.0v 679.495n 0.0v 679.505n 0.0v 689.495n 0.0v 689.505n 0.0v 699.495n 0.0v 699.505n 0.0v 709.495n 0.0v 709.505n 3.3v 719.495n 3.3v 719.505n 3.3v 729.495n 3.3v 729.505n 3.3v 739.495n 3.3v 739.505n 3.3v 749.495n 3.3v 749.505n 3.3v 759.495n 3.3v 759.505n 3.3v 769.495n 3.3v 769.505n 3.3v 779.495n 3.3v 779.505n 3.3v 789.495n 3.3v 789.505n 0.0v 799.495n 0.0v 799.505n 0.0v 809.495n 0.0v 809.505n 0.0v 819.495n 0.0v 819.505n 0.0v 829.495n 0.0v 829.505n 0.0v 839.495n 0.0v 839.505n 0.0v 849.495n 0.0v 849.505n 0.0v 859.495n 0.0v 859.505n 0.0v 869.495n 0.0v 869.505n 0.0v 879.495n 0.0v 879.505n 0.0v 889.495n 0.0v 889.505n 0.0v 899.495n 0.0v 899.505n 0.0v 909.495n 0.0v 909.505n 0.0v 919.495n 0.0v 919.505n 0.0v 929.495n 0.0v 929.505n 0.0v 939.495n 0.0v 939.505n 0.0v 949.495n 0.0v 949.505n 0.0v 959.495n 0.0v 959.505n 0.0v 969.495n 0.0v 969.505n 0.0v 979.495n 0.0v 979.505n 0.0v 989.495n 0.0v 989.505n 3.3v 999.495n 3.3v 999.505n 3.3v 1009.495n 3.3v 1009.505n 3.3v 1019.495n 3.3v 1019.505n 0.0v 1029.495n 0.0v 1029.505n 0.0v 1039.495n 0.0v 1039.505n 0.0v 1049.495n 0.0v 1049.505n 0.0v 1059.495n 0.0v 1059.505n 0.0v 1069.495n 0.0v 1069.505n 3.3v 1079.495n 3.3v 1079.505n 3.3v 1089.495n 3.3v 1089.505n 3.3v 1099.495n 3.3v 1099.505n 3.3v 1109.495n 3.3v 1109.505n 3.3v 1119.495n 3.3v 1119.505n 3.3v 1129.495n 3.3v 1129.505n 3.3v 1139.495n 3.3v 1139.505n 3.3v 1149.495n 3.3v 1149.505n 0.0v 1159.495n 0.0v 1159.505n 0.0v 1169.495n 0.0v 1169.505n 0.0v 1179.495n 0.0v 1179.505n 0.0v 1189.495n 0.0v 1189.505n 0.0v 1199.495n 0.0v 1199.505n 0.0v 1209.495n 0.0v 1209.505n 0.0v 1219.495n 0.0v 1219.505n 0.0v 1229.495n 0.0v 1229.505n 0.0v 1239.495n 0.0v 1239.505n 0.0v 1249.495n 0.0v 1249.505n 0.0v 1259.495n 0.0v 1259.505n 3.3v 1269.495n 3.3v 1269.505n 3.3v 1279.495n 3.3v 1279.505n 3.3v 1289.495n 3.3v 1289.505n 0.0v 1299.495n 0.0v 1299.505n 0.0v 1309.495n 0.0v 1309.505n 0.0v 1319.495n 0.0v 1319.505n 0.0v 1329.495n 0.0v 1329.505n 0.0v 1339.495n 0.0v 1339.505n 3.3v 1349.495n 3.3v 1349.505n 3.3v 1359.495n 3.3v 1359.505n 0.0v 1369.495n 0.0v 1369.505n 3.3v 1379.495n 3.3v 1379.505n 3.3v 1389.495n 3.3v 1389.505n 3.3v 1399.495n 3.3v 1399.505n 3.3v 1409.495n 3.3v 1409.505n 3.3v 1419.495n 3.3v 1419.505n 3.3v 1429.495n 3.3v 1429.505n 3.3v 1439.495n 3.3v 1439.505n 3.3v 1449.495n 3.3v 1449.505n 3.3v 1459.495n 3.3v 1459.505n 0.0v 1469.495n 0.0v 1469.505n 0.0v 1479.495n 0.0v 1479.505n 0.0v 1489.495n 0.0v 1489.505n 0.0v 1499.495n 0.0v 1499.505n 0.0v 1509.495n 0.0v 1509.505n 0.0v 1519.495n 0.0v 1519.505n 0.0v 1529.495n 0.0v 1529.505n 3.3v 1539.495n 3.3v 1539.505n 3.3v 1549.495n 3.3v 1549.505n 3.3v 1559.495n 3.3v 1559.505n 3.3v 1569.495n 3.3v 1569.505n 3.3v 1579.495n 3.3v 1579.505n 3.3v 1589.495n 3.3v 1589.505n 3.3v 1599.495n 3.3v 1599.505n 3.3v 1609.495n 3.3v 1609.505n 3.3v 1619.495n 3.3v 1619.505n 3.3v 1629.495n 3.3v 1629.505n 3.3v 1639.495n 3.3v 1639.505n 3.3v 1649.495n 3.3v 1649.505n 3.3v 1659.495n 3.3v 1659.505n 3.3v 1669.495n 3.3v 1669.505n 3.3v 1679.495n 3.3v 1679.505n 3.3v 1689.495n 3.3v 1689.505n 3.3v 1699.495n 3.3v 1699.505n 3.3v 1709.495n 3.3v 1709.505n 0.0v 1719.495n 0.0v 1719.505n 0.0v 1729.495n 0.0v 1729.505n 0.0v 1739.495n 0.0v 1739.505n 0.0v 1749.495n 0.0v 1749.505n 0.0v 1759.495n 0.0v 1759.505n 0.0v 1769.495n 0.0v 1769.505n 0.0v 1779.495n 0.0v 1779.505n 0.0v 1789.495n 0.0v 1789.505n 3.3v 1799.495n 3.3v 1799.505n 3.3v 1809.495n 3.3v 1809.505n 3.3v 1819.495n 3.3v 1819.505n 3.3v 1829.495n 3.3v 1829.505n 3.3v 1839.495n 3.3v 1839.505n 3.3v 1849.495n 3.3v 1849.505n 3.3v 1859.495n 3.3v 1859.505n 3.3v 1869.495n 3.3v 1869.505n 3.3v 1879.495n 3.3v 1879.505n 3.3v 1889.495n 3.3v 1889.505n 3.3v 1899.495n 3.3v 1899.505n 3.3v 1909.495n 3.3v 1909.505n 3.3v 1919.495n 3.3v 1919.505n 3.3v 1929.495n 3.3v 1929.505n 3.3v 1939.495n 3.3v 1939.505n 3.3v 1949.495n 3.3v 1949.505n 3.3v 1959.495n 3.3v 1959.505n 0.0v 1969.495n 0.0v 1969.505n 0.0v 1979.495n 0.0v 1979.505n 0.0v 1989.495n 0.0v 1989.505n 3.3v 1999.495n 3.3v 1999.505n 3.3v 2009.495n 3.3v 2009.505n 3.3v 2019.495n 3.3v 2019.505n 3.3v 2029.495n 3.3v 2029.505n 3.3v 2039.495n 3.3v 2039.505n 3.3v 2049.495n 3.3v 2049.505n 3.3v )
* (time, data): [(0, 0), (10, 1), (20, 0), (30, 0), (40, 0), (50, 0), (60, 1), (70, 1), (80, 1), (90, 1), (100, 1), (110, 1), (120, 1), (130, 1), (140, 1), (150, 1), (160, 0), (170, 0), (180, 0), (190, 0), (200, 0), (210, 0), (220, 0), (230, 0), (240, 0), (250, 0), (260, 1), (270, 1), (280, 1), (290, 1), (300, 1), (310, 0), (320, 0), (330, 1), (340, 1), (350, 1), (360, 1), (370, 1), (380, 1), (390, 1), (400, 1), (410, 1), (420, 1), (430, 1), (440, 1), (450, 1), (460, 1), (470, 1), (480, 1), (490, 1), (500, 1), (510, 1), (520, 1), (530, 1), (540, 0), (550, 0), (560, 1), (570, 1), (580, 1), (590, 1), (600, 1), (610, 0), (620, 0), (630, 0), (640, 0), (650, 0), (660, 0), (670, 0), (680, 0), (690, 0), (700, 0), (710, 0), (720, 0), (730, 0), (740, 0), (750, 0), (760, 0), (770, 0), (780, 0), (790, 1), (800, 1), (810, 1), (820, 1), (830, 1), (840, 1), (850, 0), (860, 0), (870, 0), (880, 0), (890, 0), (900, 0), (910, 0), (920, 0), (930, 0), (940, 0), (950, 0), (960, 0), (970, 0), (980, 0), (990, 1), (1000, 1), (1010, 1), (1020, 0), (1030, 0), (1040, 0), (1050, 1), (1060, 1), (1070, 1), (1080, 1), (1090, 1), (1100, 1), (1110, 1), (1120, 1), (1130, 1), (1140, 1), (1150, 0), (1160, 0), (1170, 0), (1180, 0), (1190, 0), (1200, 0), (1210, 0), (1220, 0), (1230, 0), (1240, 1), (1250, 1), (1260, 0), (1270, 0), (1280, 0), (1290, 0), (1300, 0), (1310, 0), (1320, 0), (1330, 0), (1340, 0), (1350, 0), (1360, 0), (1370, 0), (1380, 0), (1390, 0), (1400, 0), (1410, 0), (1420, 0), (1430, 0), (1440, 0), (1450, 0), (1460, 0), (1470, 0), (1480, 0), (1490, 0), (1500, 0), (1510, 0), (1520, 0), (1530, 0), (1540, 0), (1550, 0), (1560, 0), (1570, 0), (1580, 0), (1590, 0), (1600, 0), (1610, 0), (1620, 0), (1630, 0), (1640, 0), (1650, 0), (1660, 0), (1670, 0), (1680, 0), (1690, 0), (1700, 0), (1710, 1), (1720, 1), (1730, 1), (1740, 1), (1750, 1), (1760, 1), (1770, 1), (1780, 1), (1790, 0), (1800, 0), (1810, 0), (1820, 0), (1830, 0), (1840, 0), (1850, 1), (1860, 1), (1870, 1), (1880, 0), (1890, 0), (1900, 0), (1910, 0), (1920, 0), (1930, 0), (1940, 0), (1950, 0), (1960, 1), (1970, 1), (1980, 1), (1990, 1), (2000, 1), (2010, 1), (2020, 1), (2030, 1), (2040, 1), (2050, 1)]
Vdin0_29  din0_29  0 PWL (0n 0.0v 9.495n 0.0v 9.505n 3.3v 19.495n 3.3v 19.505n 0.0v 29.495n 0.0v 29.505n 0.0v 39.495n 0.0v 39.505n 0.0v 49.495n 0.0v 49.505n 0.0v 59.495n 0.0v 59.505n 3.3v 69.495n 3.3v 69.505n 3.3v 79.495n 3.3v 79.505n 3.3v 89.495n 3.3v 89.505n 3.3v 99.495n 3.3v 99.505n 3.3v 109.495n 3.3v 109.505n 3.3v 119.495n 3.3v 119.505n 3.3v 129.495n 3.3v 129.505n 3.3v 139.495n 3.3v 139.505n 3.3v 149.495n 3.3v 149.505n 3.3v 159.495n 3.3v 159.505n 0.0v 169.495n 0.0v 169.505n 0.0v 179.495n 0.0v 179.505n 0.0v 189.495n 0.0v 189.505n 0.0v 199.495n 0.0v 199.505n 0.0v 209.495n 0.0v 209.505n 0.0v 219.495n 0.0v 219.505n 0.0v 229.495n 0.0v 229.505n 0.0v 239.495n 0.0v 239.505n 0.0v 249.495n 0.0v 249.505n 0.0v 259.495n 0.0v 259.505n 3.3v 269.495n 3.3v 269.505n 3.3v 279.495n 3.3v 279.505n 3.3v 289.495n 3.3v 289.505n 3.3v 299.495n 3.3v 299.505n 3.3v 309.495n 3.3v 309.505n 0.0v 319.495n 0.0v 319.505n 0.0v 329.495n 0.0v 329.505n 3.3v 339.495n 3.3v 339.505n 3.3v 349.495n 3.3v 349.505n 3.3v 359.495n 3.3v 359.505n 3.3v 369.495n 3.3v 369.505n 3.3v 379.495n 3.3v 379.505n 3.3v 389.495n 3.3v 389.505n 3.3v 399.495n 3.3v 399.505n 3.3v 409.495n 3.3v 409.505n 3.3v 419.495n 3.3v 419.505n 3.3v 429.495n 3.3v 429.505n 3.3v 439.495n 3.3v 439.505n 3.3v 449.495n 3.3v 449.505n 3.3v 459.495n 3.3v 459.505n 3.3v 469.495n 3.3v 469.505n 3.3v 479.495n 3.3v 479.505n 3.3v 489.495n 3.3v 489.505n 3.3v 499.495n 3.3v 499.505n 3.3v 509.495n 3.3v 509.505n 3.3v 519.495n 3.3v 519.505n 3.3v 529.495n 3.3v 529.505n 3.3v 539.495n 3.3v 539.505n 0.0v 549.495n 0.0v 549.505n 0.0v 559.495n 0.0v 559.505n 3.3v 569.495n 3.3v 569.505n 3.3v 579.495n 3.3v 579.505n 3.3v 589.495n 3.3v 589.505n 3.3v 599.495n 3.3v 599.505n 3.3v 609.495n 3.3v 609.505n 0.0v 619.495n 0.0v 619.505n 0.0v 629.495n 0.0v 629.505n 0.0v 639.495n 0.0v 639.505n 0.0v 649.495n 0.0v 649.505n 0.0v 659.495n 0.0v 659.505n 0.0v 669.495n 0.0v 669.505n 0.0v 679.495n 0.0v 679.505n 0.0v 689.495n 0.0v 689.505n 0.0v 699.495n 0.0v 699.505n 0.0v 709.495n 0.0v 709.505n 0.0v 719.495n 0.0v 719.505n 0.0v 729.495n 0.0v 729.505n 0.0v 739.495n 0.0v 739.505n 0.0v 749.495n 0.0v 749.505n 0.0v 759.495n 0.0v 759.505n 0.0v 769.495n 0.0v 769.505n 0.0v 779.495n 0.0v 779.505n 0.0v 789.495n 0.0v 789.505n 3.3v 799.495n 3.3v 799.505n 3.3v 809.495n 3.3v 809.505n 3.3v 819.495n 3.3v 819.505n 3.3v 829.495n 3.3v 829.505n 3.3v 839.495n 3.3v 839.505n 3.3v 849.495n 3.3v 849.505n 0.0v 859.495n 0.0v 859.505n 0.0v 869.495n 0.0v 869.505n 0.0v 879.495n 0.0v 879.505n 0.0v 889.495n 0.0v 889.505n 0.0v 899.495n 0.0v 899.505n 0.0v 909.495n 0.0v 909.505n 0.0v 919.495n 0.0v 919.505n 0.0v 929.495n 0.0v 929.505n 0.0v 939.495n 0.0v 939.505n 0.0v 949.495n 0.0v 949.505n 0.0v 959.495n 0.0v 959.505n 0.0v 969.495n 0.0v 969.505n 0.0v 979.495n 0.0v 979.505n 0.0v 989.495n 0.0v 989.505n 3.3v 999.495n 3.3v 999.505n 3.3v 1009.495n 3.3v 1009.505n 3.3v 1019.495n 3.3v 1019.505n 0.0v 1029.495n 0.0v 1029.505n 0.0v 1039.495n 0.0v 1039.505n 0.0v 1049.495n 0.0v 1049.505n 3.3v 1059.495n 3.3v 1059.505n 3.3v 1069.495n 3.3v 1069.505n 3.3v 1079.495n 3.3v 1079.505n 3.3v 1089.495n 3.3v 1089.505n 3.3v 1099.495n 3.3v 1099.505n 3.3v 1109.495n 3.3v 1109.505n 3.3v 1119.495n 3.3v 1119.505n 3.3v 1129.495n 3.3v 1129.505n 3.3v 1139.495n 3.3v 1139.505n 3.3v 1149.495n 3.3v 1149.505n 0.0v 1159.495n 0.0v 1159.505n 0.0v 1169.495n 0.0v 1169.505n 0.0v 1179.495n 0.0v 1179.505n 0.0v 1189.495n 0.0v 1189.505n 0.0v 1199.495n 0.0v 1199.505n 0.0v 1209.495n 0.0v 1209.505n 0.0v 1219.495n 0.0v 1219.505n 0.0v 1229.495n 0.0v 1229.505n 0.0v 1239.495n 0.0v 1239.505n 3.3v 1249.495n 3.3v 1249.505n 3.3v 1259.495n 3.3v 1259.505n 0.0v 1269.495n 0.0v 1269.505n 0.0v 1279.495n 0.0v 1279.505n 0.0v 1289.495n 0.0v 1289.505n 0.0v 1299.495n 0.0v 1299.505n 0.0v 1309.495n 0.0v 1309.505n 0.0v 1319.495n 0.0v 1319.505n 0.0v 1329.495n 0.0v 1329.505n 0.0v 1339.495n 0.0v 1339.505n 0.0v 1349.495n 0.0v 1349.505n 0.0v 1359.495n 0.0v 1359.505n 0.0v 1369.495n 0.0v 1369.505n 0.0v 1379.495n 0.0v 1379.505n 0.0v 1389.495n 0.0v 1389.505n 0.0v 1399.495n 0.0v 1399.505n 0.0v 1409.495n 0.0v 1409.505n 0.0v 1419.495n 0.0v 1419.505n 0.0v 1429.495n 0.0v 1429.505n 0.0v 1439.495n 0.0v 1439.505n 0.0v 1449.495n 0.0v 1449.505n 0.0v 1459.495n 0.0v 1459.505n 0.0v 1469.495n 0.0v 1469.505n 0.0v 1479.495n 0.0v 1479.505n 0.0v 1489.495n 0.0v 1489.505n 0.0v 1499.495n 0.0v 1499.505n 0.0v 1509.495n 0.0v 1509.505n 0.0v 1519.495n 0.0v 1519.505n 0.0v 1529.495n 0.0v 1529.505n 0.0v 1539.495n 0.0v 1539.505n 0.0v 1549.495n 0.0v 1549.505n 0.0v 1559.495n 0.0v 1559.505n 0.0v 1569.495n 0.0v 1569.505n 0.0v 1579.495n 0.0v 1579.505n 0.0v 1589.495n 0.0v 1589.505n 0.0v 1599.495n 0.0v 1599.505n 0.0v 1609.495n 0.0v 1609.505n 0.0v 1619.495n 0.0v 1619.505n 0.0v 1629.495n 0.0v 1629.505n 0.0v 1639.495n 0.0v 1639.505n 0.0v 1649.495n 0.0v 1649.505n 0.0v 1659.495n 0.0v 1659.505n 0.0v 1669.495n 0.0v 1669.505n 0.0v 1679.495n 0.0v 1679.505n 0.0v 1689.495n 0.0v 1689.505n 0.0v 1699.495n 0.0v 1699.505n 0.0v 1709.495n 0.0v 1709.505n 3.3v 1719.495n 3.3v 1719.505n 3.3v 1729.495n 3.3v 1729.505n 3.3v 1739.495n 3.3v 1739.505n 3.3v 1749.495n 3.3v 1749.505n 3.3v 1759.495n 3.3v 1759.505n 3.3v 1769.495n 3.3v 1769.505n 3.3v 1779.495n 3.3v 1779.505n 3.3v 1789.495n 3.3v 1789.505n 0.0v 1799.495n 0.0v 1799.505n 0.0v 1809.495n 0.0v 1809.505n 0.0v 1819.495n 0.0v 1819.505n 0.0v 1829.495n 0.0v 1829.505n 0.0v 1839.495n 0.0v 1839.505n 0.0v 1849.495n 0.0v 1849.505n 3.3v 1859.495n 3.3v 1859.505n 3.3v 1869.495n 3.3v 1869.505n 3.3v 1879.495n 3.3v 1879.505n 0.0v 1889.495n 0.0v 1889.505n 0.0v 1899.495n 0.0v 1899.505n 0.0v 1909.495n 0.0v 1909.505n 0.0v 1919.495n 0.0v 1919.505n 0.0v 1929.495n 0.0v 1929.505n 0.0v 1939.495n 0.0v 1939.505n 0.0v 1949.495n 0.0v 1949.505n 0.0v 1959.495n 0.0v 1959.505n 3.3v 1969.495n 3.3v 1969.505n 3.3v 1979.495n 3.3v 1979.505n 3.3v 1989.495n 3.3v 1989.505n 3.3v 1999.495n 3.3v 1999.505n 3.3v 2009.495n 3.3v 2009.505n 3.3v 2019.495n 3.3v 2019.505n 3.3v 2029.495n 3.3v 2029.505n 3.3v 2039.495n 3.3v 2039.505n 3.3v 2049.495n 3.3v 2049.505n 3.3v )
* (time, data): [(0, 0), (10, 1), (20, 0), (30, 1), (40, 1), (50, 1), (60, 1), (70, 1), (80, 1), (90, 1), (100, 1), (110, 1), (120, 1), (130, 1), (140, 1), (150, 1), (160, 1), (170, 1), (180, 1), (190, 1), (200, 1), (210, 1), (220, 0), (230, 0), (240, 0), (250, 0), (260, 1), (270, 1), (280, 0), (290, 1), (300, 1), (310, 0), (320, 0), (330, 1), (340, 0), (350, 0), (360, 0), (370, 0), (380, 0), (390, 0), (400, 0), (410, 0), (420, 1), (430, 1), (440, 1), (450, 1), (460, 0), (470, 0), (480, 0), (490, 0), (500, 0), (510, 0), (520, 0), (530, 1), (540, 0), (550, 0), (560, 0), (570, 0), (580, 0), (590, 0), (600, 0), (610, 1), (620, 1), (630, 1), (640, 1), (650, 1), (660, 1), (670, 1), (680, 1), (690, 1), (700, 1), (710, 0), (720, 0), (730, 0), (740, 0), (750, 0), (760, 0), (770, 0), (780, 0), (790, 0), (800, 0), (810, 0), (820, 0), (830, 0), (840, 0), (850, 0), (860, 0), (870, 0), (880, 0), (890, 0), (900, 0), (910, 0), (920, 0), (930, 0), (940, 0), (950, 0), (960, 0), (970, 0), (980, 0), (990, 1), (1000, 0), (1010, 0), (1020, 1), (1030, 1), (1040, 1), (1050, 1), (1060, 1), (1070, 1), (1080, 1), (1090, 1), (1100, 1), (1110, 1), (1120, 1), (1130, 1), (1140, 1), (1150, 1), (1160, 1), (1170, 1), (1180, 1), (1190, 1), (1200, 1), (1210, 1), (1220, 1), (1230, 1), (1240, 0), (1250, 0), (1260, 0), (1270, 0), (1280, 0), (1290, 1), (1300, 1), (1310, 1), (1320, 1), (1330, 1), (1340, 0), (1350, 0), (1360, 0), (1370, 1), (1380, 1), (1390, 1), (1400, 1), (1410, 1), (1420, 1), (1430, 1), (1440, 1), (1450, 1), (1460, 0), (1470, 0), (1480, 0), (1490, 0), (1500, 0), (1510, 0), (1520, 0), (1530, 0), (1540, 0), (1550, 0), (1560, 0), (1570, 0), (1580, 0), (1590, 0), (1600, 0), (1610, 0), (1620, 0), (1630, 0), (1640, 0), (1650, 0), (1660, 1), (1670, 1), (1680, 1), (1690, 1), (1700, 1), (1710, 0), (1720, 0), (1730, 0), (1740, 0), (1750, 0), (1760, 0), (1770, 0), (1780, 1), (1790, 1), (1800, 1), (1810, 1), (1820, 0), (1830, 0), (1840, 0), (1850, 1), (1860, 1), (1870, 1), (1880, 0), (1890, 0), (1900, 0), (1910, 0), (1920, 0), (1930, 0), (1940, 0), (1950, 0), (1960, 0), (1970, 0), (1980, 0), (1990, 0), (2000, 0), (2010, 0), (2020, 0), (2030, 0), (2040, 0), (2050, 0)]
Vdin0_30  din0_30  0 PWL (0n 0.0v 9.495n 0.0v 9.505n 3.3v 19.495n 3.3v 19.505n 0.0v 29.495n 0.0v 29.505n 3.3v 39.495n 3.3v 39.505n 3.3v 49.495n 3.3v 49.505n 3.3v 59.495n 3.3v 59.505n 3.3v 69.495n 3.3v 69.505n 3.3v 79.495n 3.3v 79.505n 3.3v 89.495n 3.3v 89.505n 3.3v 99.495n 3.3v 99.505n 3.3v 109.495n 3.3v 109.505n 3.3v 119.495n 3.3v 119.505n 3.3v 129.495n 3.3v 129.505n 3.3v 139.495n 3.3v 139.505n 3.3v 149.495n 3.3v 149.505n 3.3v 159.495n 3.3v 159.505n 3.3v 169.495n 3.3v 169.505n 3.3v 179.495n 3.3v 179.505n 3.3v 189.495n 3.3v 189.505n 3.3v 199.495n 3.3v 199.505n 3.3v 209.495n 3.3v 209.505n 3.3v 219.495n 3.3v 219.505n 0.0v 229.495n 0.0v 229.505n 0.0v 239.495n 0.0v 239.505n 0.0v 249.495n 0.0v 249.505n 0.0v 259.495n 0.0v 259.505n 3.3v 269.495n 3.3v 269.505n 3.3v 279.495n 3.3v 279.505n 0.0v 289.495n 0.0v 289.505n 3.3v 299.495n 3.3v 299.505n 3.3v 309.495n 3.3v 309.505n 0.0v 319.495n 0.0v 319.505n 0.0v 329.495n 0.0v 329.505n 3.3v 339.495n 3.3v 339.505n 0.0v 349.495n 0.0v 349.505n 0.0v 359.495n 0.0v 359.505n 0.0v 369.495n 0.0v 369.505n 0.0v 379.495n 0.0v 379.505n 0.0v 389.495n 0.0v 389.505n 0.0v 399.495n 0.0v 399.505n 0.0v 409.495n 0.0v 409.505n 0.0v 419.495n 0.0v 419.505n 3.3v 429.495n 3.3v 429.505n 3.3v 439.495n 3.3v 439.505n 3.3v 449.495n 3.3v 449.505n 3.3v 459.495n 3.3v 459.505n 0.0v 469.495n 0.0v 469.505n 0.0v 479.495n 0.0v 479.505n 0.0v 489.495n 0.0v 489.505n 0.0v 499.495n 0.0v 499.505n 0.0v 509.495n 0.0v 509.505n 0.0v 519.495n 0.0v 519.505n 0.0v 529.495n 0.0v 529.505n 3.3v 539.495n 3.3v 539.505n 0.0v 549.495n 0.0v 549.505n 0.0v 559.495n 0.0v 559.505n 0.0v 569.495n 0.0v 569.505n 0.0v 579.495n 0.0v 579.505n 0.0v 589.495n 0.0v 589.505n 0.0v 599.495n 0.0v 599.505n 0.0v 609.495n 0.0v 609.505n 3.3v 619.495n 3.3v 619.505n 3.3v 629.495n 3.3v 629.505n 3.3v 639.495n 3.3v 639.505n 3.3v 649.495n 3.3v 649.505n 3.3v 659.495n 3.3v 659.505n 3.3v 669.495n 3.3v 669.505n 3.3v 679.495n 3.3v 679.505n 3.3v 689.495n 3.3v 689.505n 3.3v 699.495n 3.3v 699.505n 3.3v 709.495n 3.3v 709.505n 0.0v 719.495n 0.0v 719.505n 0.0v 729.495n 0.0v 729.505n 0.0v 739.495n 0.0v 739.505n 0.0v 749.495n 0.0v 749.505n 0.0v 759.495n 0.0v 759.505n 0.0v 769.495n 0.0v 769.505n 0.0v 779.495n 0.0v 779.505n 0.0v 789.495n 0.0v 789.505n 0.0v 799.495n 0.0v 799.505n 0.0v 809.495n 0.0v 809.505n 0.0v 819.495n 0.0v 819.505n 0.0v 829.495n 0.0v 829.505n 0.0v 839.495n 0.0v 839.505n 0.0v 849.495n 0.0v 849.505n 0.0v 859.495n 0.0v 859.505n 0.0v 869.495n 0.0v 869.505n 0.0v 879.495n 0.0v 879.505n 0.0v 889.495n 0.0v 889.505n 0.0v 899.495n 0.0v 899.505n 0.0v 909.495n 0.0v 909.505n 0.0v 919.495n 0.0v 919.505n 0.0v 929.495n 0.0v 929.505n 0.0v 939.495n 0.0v 939.505n 0.0v 949.495n 0.0v 949.505n 0.0v 959.495n 0.0v 959.505n 0.0v 969.495n 0.0v 969.505n 0.0v 979.495n 0.0v 979.505n 0.0v 989.495n 0.0v 989.505n 3.3v 999.495n 3.3v 999.505n 0.0v 1009.495n 0.0v 1009.505n 0.0v 1019.495n 0.0v 1019.505n 3.3v 1029.495n 3.3v 1029.505n 3.3v 1039.495n 3.3v 1039.505n 3.3v 1049.495n 3.3v 1049.505n 3.3v 1059.495n 3.3v 1059.505n 3.3v 1069.495n 3.3v 1069.505n 3.3v 1079.495n 3.3v 1079.505n 3.3v 1089.495n 3.3v 1089.505n 3.3v 1099.495n 3.3v 1099.505n 3.3v 1109.495n 3.3v 1109.505n 3.3v 1119.495n 3.3v 1119.505n 3.3v 1129.495n 3.3v 1129.505n 3.3v 1139.495n 3.3v 1139.505n 3.3v 1149.495n 3.3v 1149.505n 3.3v 1159.495n 3.3v 1159.505n 3.3v 1169.495n 3.3v 1169.505n 3.3v 1179.495n 3.3v 1179.505n 3.3v 1189.495n 3.3v 1189.505n 3.3v 1199.495n 3.3v 1199.505n 3.3v 1209.495n 3.3v 1209.505n 3.3v 1219.495n 3.3v 1219.505n 3.3v 1229.495n 3.3v 1229.505n 3.3v 1239.495n 3.3v 1239.505n 0.0v 1249.495n 0.0v 1249.505n 0.0v 1259.495n 0.0v 1259.505n 0.0v 1269.495n 0.0v 1269.505n 0.0v 1279.495n 0.0v 1279.505n 0.0v 1289.495n 0.0v 1289.505n 3.3v 1299.495n 3.3v 1299.505n 3.3v 1309.495n 3.3v 1309.505n 3.3v 1319.495n 3.3v 1319.505n 3.3v 1329.495n 3.3v 1329.505n 3.3v 1339.495n 3.3v 1339.505n 0.0v 1349.495n 0.0v 1349.505n 0.0v 1359.495n 0.0v 1359.505n 0.0v 1369.495n 0.0v 1369.505n 3.3v 1379.495n 3.3v 1379.505n 3.3v 1389.495n 3.3v 1389.505n 3.3v 1399.495n 3.3v 1399.505n 3.3v 1409.495n 3.3v 1409.505n 3.3v 1419.495n 3.3v 1419.505n 3.3v 1429.495n 3.3v 1429.505n 3.3v 1439.495n 3.3v 1439.505n 3.3v 1449.495n 3.3v 1449.505n 3.3v 1459.495n 3.3v 1459.505n 0.0v 1469.495n 0.0v 1469.505n 0.0v 1479.495n 0.0v 1479.505n 0.0v 1489.495n 0.0v 1489.505n 0.0v 1499.495n 0.0v 1499.505n 0.0v 1509.495n 0.0v 1509.505n 0.0v 1519.495n 0.0v 1519.505n 0.0v 1529.495n 0.0v 1529.505n 0.0v 1539.495n 0.0v 1539.505n 0.0v 1549.495n 0.0v 1549.505n 0.0v 1559.495n 0.0v 1559.505n 0.0v 1569.495n 0.0v 1569.505n 0.0v 1579.495n 0.0v 1579.505n 0.0v 1589.495n 0.0v 1589.505n 0.0v 1599.495n 0.0v 1599.505n 0.0v 1609.495n 0.0v 1609.505n 0.0v 1619.495n 0.0v 1619.505n 0.0v 1629.495n 0.0v 1629.505n 0.0v 1639.495n 0.0v 1639.505n 0.0v 1649.495n 0.0v 1649.505n 0.0v 1659.495n 0.0v 1659.505n 3.3v 1669.495n 3.3v 1669.505n 3.3v 1679.495n 3.3v 1679.505n 3.3v 1689.495n 3.3v 1689.505n 3.3v 1699.495n 3.3v 1699.505n 3.3v 1709.495n 3.3v 1709.505n 0.0v 1719.495n 0.0v 1719.505n 0.0v 1729.495n 0.0v 1729.505n 0.0v 1739.495n 0.0v 1739.505n 0.0v 1749.495n 0.0v 1749.505n 0.0v 1759.495n 0.0v 1759.505n 0.0v 1769.495n 0.0v 1769.505n 0.0v 1779.495n 0.0v 1779.505n 3.3v 1789.495n 3.3v 1789.505n 3.3v 1799.495n 3.3v 1799.505n 3.3v 1809.495n 3.3v 1809.505n 3.3v 1819.495n 3.3v 1819.505n 0.0v 1829.495n 0.0v 1829.505n 0.0v 1839.495n 0.0v 1839.505n 0.0v 1849.495n 0.0v 1849.505n 3.3v 1859.495n 3.3v 1859.505n 3.3v 1869.495n 3.3v 1869.505n 3.3v 1879.495n 3.3v 1879.505n 0.0v 1889.495n 0.0v 1889.505n 0.0v 1899.495n 0.0v 1899.505n 0.0v 1909.495n 0.0v 1909.505n 0.0v 1919.495n 0.0v 1919.505n 0.0v 1929.495n 0.0v 1929.505n 0.0v 1939.495n 0.0v 1939.505n 0.0v 1949.495n 0.0v 1949.505n 0.0v 1959.495n 0.0v 1959.505n 0.0v 1969.495n 0.0v 1969.505n 0.0v 1979.495n 0.0v 1979.505n 0.0v 1989.495n 0.0v 1989.505n 0.0v 1999.495n 0.0v 1999.505n 0.0v 2009.495n 0.0v 2009.505n 0.0v 2019.495n 0.0v 2019.505n 0.0v 2029.495n 0.0v 2029.505n 0.0v 2039.495n 0.0v 2039.505n 0.0v 2049.495n 0.0v 2049.505n 0.0v )
* (time, data): [(0, 0), (10, 1), (20, 1), (30, 1), (40, 1), (50, 1), (60, 1), (70, 1), (80, 1), (90, 1), (100, 0), (110, 0), (120, 0), (130, 0), (140, 0), (150, 0), (160, 0), (170, 0), (180, 0), (190, 0), (200, 0), (210, 0), (220, 1), (230, 1), (240, 1), (250, 1), (260, 1), (270, 1), (280, 0), (290, 1), (300, 1), (310, 1), (320, 1), (330, 0), (340, 1), (350, 1), (360, 1), (370, 1), (380, 1), (390, 1), (400, 1), (410, 1), (420, 0), (430, 0), (440, 0), (450, 0), (460, 0), (470, 0), (480, 0), (490, 0), (500, 0), (510, 0), (520, 0), (530, 0), (540, 1), (550, 1), (560, 1), (570, 1), (580, 0), (590, 0), (600, 0), (610, 1), (620, 1), (630, 1), (640, 1), (650, 1), (660, 1), (670, 1), (680, 1), (690, 1), (700, 1), (710, 1), (720, 1), (730, 1), (740, 1), (750, 1), (760, 1), (770, 1), (780, 0), (790, 0), (800, 0), (810, 0), (820, 0), (830, 0), (840, 0), (850, 0), (860, 0), (870, 0), (880, 0), (890, 0), (900, 0), (910, 0), (920, 0), (930, 0), (940, 0), (950, 0), (960, 0), (970, 0), (980, 0), (990, 1), (1000, 0), (1010, 1), (1020, 1), (1030, 1), (1040, 1), (1050, 0), (1060, 0), (1070, 1), (1080, 1), (1090, 1), (1100, 1), (1110, 1), (1120, 1), (1130, 1), (1140, 1), (1150, 1), (1160, 1), (1170, 1), (1180, 1), (1190, 1), (1200, 1), (1210, 1), (1220, 1), (1230, 1), (1240, 0), (1250, 0), (1260, 1), (1270, 1), (1280, 1), (1290, 1), (1300, 1), (1310, 1), (1320, 1), (1330, 1), (1340, 0), (1350, 0), (1360, 0), (1370, 1), (1380, 1), (1390, 1), (1400, 1), (1410, 1), (1420, 1), (1430, 1), (1440, 1), (1450, 1), (1460, 1), (1470, 1), (1480, 1), (1490, 1), (1500, 0), (1510, 0), (1520, 0), (1530, 0), (1540, 0), (1550, 0), (1560, 0), (1570, 0), (1580, 0), (1590, 0), (1600, 0), (1610, 0), (1620, 0), (1630, 0), (1640, 0), (1650, 0), (1660, 0), (1670, 0), (1680, 0), (1690, 0), (1700, 0), (1710, 1), (1720, 1), (1730, 1), (1740, 1), (1750, 1), (1760, 1), (1770, 1), (1780, 0), (1790, 0), (1800, 0), (1810, 0), (1820, 1), (1830, 1), (1840, 1), (1850, 1), (1860, 1), (1870, 1), (1880, 1), (1890, 1), (1900, 1), (1910, 1), (1920, 1), (1930, 1), (1940, 1), (1950, 1), (1960, 0), (1970, 0), (1980, 0), (1990, 1), (2000, 1), (2010, 1), (2020, 1), (2030, 1), (2040, 1), (2050, 1)]
Vdin0_31  din0_31  0 PWL (0n 0.0v 9.495n 0.0v 9.505n 3.3v 19.495n 3.3v 19.505n 3.3v 29.495n 3.3v 29.505n 3.3v 39.495n 3.3v 39.505n 3.3v 49.495n 3.3v 49.505n 3.3v 59.495n 3.3v 59.505n 3.3v 69.495n 3.3v 69.505n 3.3v 79.495n 3.3v 79.505n 3.3v 89.495n 3.3v 89.505n 3.3v 99.495n 3.3v 99.505n 0.0v 109.495n 0.0v 109.505n 0.0v 119.495n 0.0v 119.505n 0.0v 129.495n 0.0v 129.505n 0.0v 139.495n 0.0v 139.505n 0.0v 149.495n 0.0v 149.505n 0.0v 159.495n 0.0v 159.505n 0.0v 169.495n 0.0v 169.505n 0.0v 179.495n 0.0v 179.505n 0.0v 189.495n 0.0v 189.505n 0.0v 199.495n 0.0v 199.505n 0.0v 209.495n 0.0v 209.505n 0.0v 219.495n 0.0v 219.505n 3.3v 229.495n 3.3v 229.505n 3.3v 239.495n 3.3v 239.505n 3.3v 249.495n 3.3v 249.505n 3.3v 259.495n 3.3v 259.505n 3.3v 269.495n 3.3v 269.505n 3.3v 279.495n 3.3v 279.505n 0.0v 289.495n 0.0v 289.505n 3.3v 299.495n 3.3v 299.505n 3.3v 309.495n 3.3v 309.505n 3.3v 319.495n 3.3v 319.505n 3.3v 329.495n 3.3v 329.505n 0.0v 339.495n 0.0v 339.505n 3.3v 349.495n 3.3v 349.505n 3.3v 359.495n 3.3v 359.505n 3.3v 369.495n 3.3v 369.505n 3.3v 379.495n 3.3v 379.505n 3.3v 389.495n 3.3v 389.505n 3.3v 399.495n 3.3v 399.505n 3.3v 409.495n 3.3v 409.505n 3.3v 419.495n 3.3v 419.505n 0.0v 429.495n 0.0v 429.505n 0.0v 439.495n 0.0v 439.505n 0.0v 449.495n 0.0v 449.505n 0.0v 459.495n 0.0v 459.505n 0.0v 469.495n 0.0v 469.505n 0.0v 479.495n 0.0v 479.505n 0.0v 489.495n 0.0v 489.505n 0.0v 499.495n 0.0v 499.505n 0.0v 509.495n 0.0v 509.505n 0.0v 519.495n 0.0v 519.505n 0.0v 529.495n 0.0v 529.505n 0.0v 539.495n 0.0v 539.505n 3.3v 549.495n 3.3v 549.505n 3.3v 559.495n 3.3v 559.505n 3.3v 569.495n 3.3v 569.505n 3.3v 579.495n 3.3v 579.505n 0.0v 589.495n 0.0v 589.505n 0.0v 599.495n 0.0v 599.505n 0.0v 609.495n 0.0v 609.505n 3.3v 619.495n 3.3v 619.505n 3.3v 629.495n 3.3v 629.505n 3.3v 639.495n 3.3v 639.505n 3.3v 649.495n 3.3v 649.505n 3.3v 659.495n 3.3v 659.505n 3.3v 669.495n 3.3v 669.505n 3.3v 679.495n 3.3v 679.505n 3.3v 689.495n 3.3v 689.505n 3.3v 699.495n 3.3v 699.505n 3.3v 709.495n 3.3v 709.505n 3.3v 719.495n 3.3v 719.505n 3.3v 729.495n 3.3v 729.505n 3.3v 739.495n 3.3v 739.505n 3.3v 749.495n 3.3v 749.505n 3.3v 759.495n 3.3v 759.505n 3.3v 769.495n 3.3v 769.505n 3.3v 779.495n 3.3v 779.505n 0.0v 789.495n 0.0v 789.505n 0.0v 799.495n 0.0v 799.505n 0.0v 809.495n 0.0v 809.505n 0.0v 819.495n 0.0v 819.505n 0.0v 829.495n 0.0v 829.505n 0.0v 839.495n 0.0v 839.505n 0.0v 849.495n 0.0v 849.505n 0.0v 859.495n 0.0v 859.505n 0.0v 869.495n 0.0v 869.505n 0.0v 879.495n 0.0v 879.505n 0.0v 889.495n 0.0v 889.505n 0.0v 899.495n 0.0v 899.505n 0.0v 909.495n 0.0v 909.505n 0.0v 919.495n 0.0v 919.505n 0.0v 929.495n 0.0v 929.505n 0.0v 939.495n 0.0v 939.505n 0.0v 949.495n 0.0v 949.505n 0.0v 959.495n 0.0v 959.505n 0.0v 969.495n 0.0v 969.505n 0.0v 979.495n 0.0v 979.505n 0.0v 989.495n 0.0v 989.505n 3.3v 999.495n 3.3v 999.505n 0.0v 1009.495n 0.0v 1009.505n 3.3v 1019.495n 3.3v 1019.505n 3.3v 1029.495n 3.3v 1029.505n 3.3v 1039.495n 3.3v 1039.505n 3.3v 1049.495n 3.3v 1049.505n 0.0v 1059.495n 0.0v 1059.505n 0.0v 1069.495n 0.0v 1069.505n 3.3v 1079.495n 3.3v 1079.505n 3.3v 1089.495n 3.3v 1089.505n 3.3v 1099.495n 3.3v 1099.505n 3.3v 1109.495n 3.3v 1109.505n 3.3v 1119.495n 3.3v 1119.505n 3.3v 1129.495n 3.3v 1129.505n 3.3v 1139.495n 3.3v 1139.505n 3.3v 1149.495n 3.3v 1149.505n 3.3v 1159.495n 3.3v 1159.505n 3.3v 1169.495n 3.3v 1169.505n 3.3v 1179.495n 3.3v 1179.505n 3.3v 1189.495n 3.3v 1189.505n 3.3v 1199.495n 3.3v 1199.505n 3.3v 1209.495n 3.3v 1209.505n 3.3v 1219.495n 3.3v 1219.505n 3.3v 1229.495n 3.3v 1229.505n 3.3v 1239.495n 3.3v 1239.505n 0.0v 1249.495n 0.0v 1249.505n 0.0v 1259.495n 0.0v 1259.505n 3.3v 1269.495n 3.3v 1269.505n 3.3v 1279.495n 3.3v 1279.505n 3.3v 1289.495n 3.3v 1289.505n 3.3v 1299.495n 3.3v 1299.505n 3.3v 1309.495n 3.3v 1309.505n 3.3v 1319.495n 3.3v 1319.505n 3.3v 1329.495n 3.3v 1329.505n 3.3v 1339.495n 3.3v 1339.505n 0.0v 1349.495n 0.0v 1349.505n 0.0v 1359.495n 0.0v 1359.505n 0.0v 1369.495n 0.0v 1369.505n 3.3v 1379.495n 3.3v 1379.505n 3.3v 1389.495n 3.3v 1389.505n 3.3v 1399.495n 3.3v 1399.505n 3.3v 1409.495n 3.3v 1409.505n 3.3v 1419.495n 3.3v 1419.505n 3.3v 1429.495n 3.3v 1429.505n 3.3v 1439.495n 3.3v 1439.505n 3.3v 1449.495n 3.3v 1449.505n 3.3v 1459.495n 3.3v 1459.505n 3.3v 1469.495n 3.3v 1469.505n 3.3v 1479.495n 3.3v 1479.505n 3.3v 1489.495n 3.3v 1489.505n 3.3v 1499.495n 3.3v 1499.505n 0.0v 1509.495n 0.0v 1509.505n 0.0v 1519.495n 0.0v 1519.505n 0.0v 1529.495n 0.0v 1529.505n 0.0v 1539.495n 0.0v 1539.505n 0.0v 1549.495n 0.0v 1549.505n 0.0v 1559.495n 0.0v 1559.505n 0.0v 1569.495n 0.0v 1569.505n 0.0v 1579.495n 0.0v 1579.505n 0.0v 1589.495n 0.0v 1589.505n 0.0v 1599.495n 0.0v 1599.505n 0.0v 1609.495n 0.0v 1609.505n 0.0v 1619.495n 0.0v 1619.505n 0.0v 1629.495n 0.0v 1629.505n 0.0v 1639.495n 0.0v 1639.505n 0.0v 1649.495n 0.0v 1649.505n 0.0v 1659.495n 0.0v 1659.505n 0.0v 1669.495n 0.0v 1669.505n 0.0v 1679.495n 0.0v 1679.505n 0.0v 1689.495n 0.0v 1689.505n 0.0v 1699.495n 0.0v 1699.505n 0.0v 1709.495n 0.0v 1709.505n 3.3v 1719.495n 3.3v 1719.505n 3.3v 1729.495n 3.3v 1729.505n 3.3v 1739.495n 3.3v 1739.505n 3.3v 1749.495n 3.3v 1749.505n 3.3v 1759.495n 3.3v 1759.505n 3.3v 1769.495n 3.3v 1769.505n 3.3v 1779.495n 3.3v 1779.505n 0.0v 1789.495n 0.0v 1789.505n 0.0v 1799.495n 0.0v 1799.505n 0.0v 1809.495n 0.0v 1809.505n 0.0v 1819.495n 0.0v 1819.505n 3.3v 1829.495n 3.3v 1829.505n 3.3v 1839.495n 3.3v 1839.505n 3.3v 1849.495n 3.3v 1849.505n 3.3v 1859.495n 3.3v 1859.505n 3.3v 1869.495n 3.3v 1869.505n 3.3v 1879.495n 3.3v 1879.505n 3.3v 1889.495n 3.3v 1889.505n 3.3v 1899.495n 3.3v 1899.505n 3.3v 1909.495n 3.3v 1909.505n 3.3v 1919.495n 3.3v 1919.505n 3.3v 1929.495n 3.3v 1929.505n 3.3v 1939.495n 3.3v 1939.505n 3.3v 1949.495n 3.3v 1949.505n 3.3v 1959.495n 3.3v 1959.505n 0.0v 1969.495n 0.0v 1969.505n 0.0v 1979.495n 0.0v 1979.505n 0.0v 1989.495n 0.0v 1989.505n 3.3v 1999.495n 3.3v 1999.505n 3.3v 2009.495n 3.3v 2009.505n 3.3v 2019.495n 3.3v 2019.505n 3.3v 2029.495n 3.3v 2029.505n 3.3v 2039.495n 3.3v 2039.505n 3.3v 2049.495n 3.3v 2049.505n 3.3v )
* (time, data): [(0, 0), (10, 1), (20, 1), (30, 0), (40, 0), (50, 0), (60, 0), (70, 0), (80, 1), (90, 1), (100, 1), (110, 1), (120, 1), (130, 1), (140, 0), (150, 0), (160, 0), (170, 0), (180, 0), (190, 0), (200, 0), (210, 0), (220, 0), (230, 0), (240, 1), (250, 1), (260, 1), (270, 1), (280, 1), (290, 1), (300, 1), (310, 1), (320, 1), (330, 1), (340, 1), (350, 1), (360, 1), (370, 0), (380, 1), (390, 1), (400, 0), (410, 0), (420, 0), (430, 0), (440, 0), (450, 0), (460, 0), (470, 0), (480, 0), (490, 0), (500, 1), (510, 1), (520, 1), (530, 1), (540, 1), (550, 1), (560, 1), (570, 1), (580, 1), (590, 1), (600, 1), (610, 1), (620, 1), (630, 1), (640, 1), (650, 1), (660, 0), (670, 0), (680, 0), (690, 0), (700, 0), (710, 0), (720, 0), (730, 0), (740, 0), (750, 0), (760, 0), (770, 0), (780, 0), (790, 0), (800, 0), (810, 0), (820, 0), (830, 0), (840, 0), (850, 0), (860, 1), (870, 0), (880, 0), (890, 0), (900, 0), (910, 0), (920, 0), (930, 0), (940, 0), (950, 0), (960, 0), (970, 0), (980, 0), (990, 0), (1000, 0), (1010, 0), (1020, 0), (1030, 0), (1040, 1), (1050, 1), (1060, 1), (1070, 1), (1080, 1), (1090, 1), (1100, 0), (1110, 0), (1120, 0), (1130, 0), (1140, 1), (1150, 1), (1160, 1), (1170, 1), (1180, 1), (1190, 1), (1200, 1), (1210, 1), (1220, 1), (1230, 1), (1240, 1), (1250, 1), (1260, 1), (1270, 1), (1280, 1), (1290, 1), (1300, 1), (1310, 0), (1320, 0), (1330, 0), (1340, 0), (1350, 0), (1360, 0), (1370, 0), (1380, 0), (1390, 0), (1400, 0), (1410, 0), (1420, 0), (1430, 0), (1440, 0), (1450, 0), (1460, 0), (1470, 0), (1480, 0), (1490, 1), (1500, 1), (1510, 1), (1520, 1), (1530, 1), (1540, 1), (1550, 1), (1560, 1), (1570, 1), (1580, 1), (1590, 1), (1600, 1), (1610, 1), (1620, 1), (1630, 1), (1640, 1), (1650, 1), (1660, 1), (1670, 1), (1680, 1), (1690, 1), (1700, 1), (1710, 1), (1720, 1), (1730, 1), (1740, 1), (1750, 0), (1760, 0), (1770, 0), (1780, 0), (1790, 0), (1800, 0), (1810, 0), (1820, 0), (1830, 0), (1840, 0), (1850, 0), (1860, 1), (1870, 1), (1880, 0), (1890, 0), (1900, 0), (1910, 1), (1920, 1), (1930, 1), (1940, 0), (1950, 0), (1960, 0), (1970, 0), (1980, 0), (1990, 0), (2000, 1), (2010, 1), (2020, 0), (2030, 1), (2040, 1), (2050, 1)]
Vdin1_0  din1_0  0 PWL (0n 0.0v 9.495n 0.0v 9.505n 3.3v 19.495n 3.3v 19.505n 3.3v 29.495n 3.3v 29.505n 0.0v 39.495n 0.0v 39.505n 0.0v 49.495n 0.0v 49.505n 0.0v 59.495n 0.0v 59.505n 0.0v 69.495n 0.0v 69.505n 0.0v 79.495n 0.0v 79.505n 3.3v 89.495n 3.3v 89.505n 3.3v 99.495n 3.3v 99.505n 3.3v 109.495n 3.3v 109.505n 3.3v 119.495n 3.3v 119.505n 3.3v 129.495n 3.3v 129.505n 3.3v 139.495n 3.3v 139.505n 0.0v 149.495n 0.0v 149.505n 0.0v 159.495n 0.0v 159.505n 0.0v 169.495n 0.0v 169.505n 0.0v 179.495n 0.0v 179.505n 0.0v 189.495n 0.0v 189.505n 0.0v 199.495n 0.0v 199.505n 0.0v 209.495n 0.0v 209.505n 0.0v 219.495n 0.0v 219.505n 0.0v 229.495n 0.0v 229.505n 0.0v 239.495n 0.0v 239.505n 3.3v 249.495n 3.3v 249.505n 3.3v 259.495n 3.3v 259.505n 3.3v 269.495n 3.3v 269.505n 3.3v 279.495n 3.3v 279.505n 3.3v 289.495n 3.3v 289.505n 3.3v 299.495n 3.3v 299.505n 3.3v 309.495n 3.3v 309.505n 3.3v 319.495n 3.3v 319.505n 3.3v 329.495n 3.3v 329.505n 3.3v 339.495n 3.3v 339.505n 3.3v 349.495n 3.3v 349.505n 3.3v 359.495n 3.3v 359.505n 3.3v 369.495n 3.3v 369.505n 0.0v 379.495n 0.0v 379.505n 3.3v 389.495n 3.3v 389.505n 3.3v 399.495n 3.3v 399.505n 0.0v 409.495n 0.0v 409.505n 0.0v 419.495n 0.0v 419.505n 0.0v 429.495n 0.0v 429.505n 0.0v 439.495n 0.0v 439.505n 0.0v 449.495n 0.0v 449.505n 0.0v 459.495n 0.0v 459.505n 0.0v 469.495n 0.0v 469.505n 0.0v 479.495n 0.0v 479.505n 0.0v 489.495n 0.0v 489.505n 0.0v 499.495n 0.0v 499.505n 3.3v 509.495n 3.3v 509.505n 3.3v 519.495n 3.3v 519.505n 3.3v 529.495n 3.3v 529.505n 3.3v 539.495n 3.3v 539.505n 3.3v 549.495n 3.3v 549.505n 3.3v 559.495n 3.3v 559.505n 3.3v 569.495n 3.3v 569.505n 3.3v 579.495n 3.3v 579.505n 3.3v 589.495n 3.3v 589.505n 3.3v 599.495n 3.3v 599.505n 3.3v 609.495n 3.3v 609.505n 3.3v 619.495n 3.3v 619.505n 3.3v 629.495n 3.3v 629.505n 3.3v 639.495n 3.3v 639.505n 3.3v 649.495n 3.3v 649.505n 3.3v 659.495n 3.3v 659.505n 0.0v 669.495n 0.0v 669.505n 0.0v 679.495n 0.0v 679.505n 0.0v 689.495n 0.0v 689.505n 0.0v 699.495n 0.0v 699.505n 0.0v 709.495n 0.0v 709.505n 0.0v 719.495n 0.0v 719.505n 0.0v 729.495n 0.0v 729.505n 0.0v 739.495n 0.0v 739.505n 0.0v 749.495n 0.0v 749.505n 0.0v 759.495n 0.0v 759.505n 0.0v 769.495n 0.0v 769.505n 0.0v 779.495n 0.0v 779.505n 0.0v 789.495n 0.0v 789.505n 0.0v 799.495n 0.0v 799.505n 0.0v 809.495n 0.0v 809.505n 0.0v 819.495n 0.0v 819.505n 0.0v 829.495n 0.0v 829.505n 0.0v 839.495n 0.0v 839.505n 0.0v 849.495n 0.0v 849.505n 0.0v 859.495n 0.0v 859.505n 3.3v 869.495n 3.3v 869.505n 0.0v 879.495n 0.0v 879.505n 0.0v 889.495n 0.0v 889.505n 0.0v 899.495n 0.0v 899.505n 0.0v 909.495n 0.0v 909.505n 0.0v 919.495n 0.0v 919.505n 0.0v 929.495n 0.0v 929.505n 0.0v 939.495n 0.0v 939.505n 0.0v 949.495n 0.0v 949.505n 0.0v 959.495n 0.0v 959.505n 0.0v 969.495n 0.0v 969.505n 0.0v 979.495n 0.0v 979.505n 0.0v 989.495n 0.0v 989.505n 0.0v 999.495n 0.0v 999.505n 0.0v 1009.495n 0.0v 1009.505n 0.0v 1019.495n 0.0v 1019.505n 0.0v 1029.495n 0.0v 1029.505n 0.0v 1039.495n 0.0v 1039.505n 3.3v 1049.495n 3.3v 1049.505n 3.3v 1059.495n 3.3v 1059.505n 3.3v 1069.495n 3.3v 1069.505n 3.3v 1079.495n 3.3v 1079.505n 3.3v 1089.495n 3.3v 1089.505n 3.3v 1099.495n 3.3v 1099.505n 0.0v 1109.495n 0.0v 1109.505n 0.0v 1119.495n 0.0v 1119.505n 0.0v 1129.495n 0.0v 1129.505n 0.0v 1139.495n 0.0v 1139.505n 3.3v 1149.495n 3.3v 1149.505n 3.3v 1159.495n 3.3v 1159.505n 3.3v 1169.495n 3.3v 1169.505n 3.3v 1179.495n 3.3v 1179.505n 3.3v 1189.495n 3.3v 1189.505n 3.3v 1199.495n 3.3v 1199.505n 3.3v 1209.495n 3.3v 1209.505n 3.3v 1219.495n 3.3v 1219.505n 3.3v 1229.495n 3.3v 1229.505n 3.3v 1239.495n 3.3v 1239.505n 3.3v 1249.495n 3.3v 1249.505n 3.3v 1259.495n 3.3v 1259.505n 3.3v 1269.495n 3.3v 1269.505n 3.3v 1279.495n 3.3v 1279.505n 3.3v 1289.495n 3.3v 1289.505n 3.3v 1299.495n 3.3v 1299.505n 3.3v 1309.495n 3.3v 1309.505n 0.0v 1319.495n 0.0v 1319.505n 0.0v 1329.495n 0.0v 1329.505n 0.0v 1339.495n 0.0v 1339.505n 0.0v 1349.495n 0.0v 1349.505n 0.0v 1359.495n 0.0v 1359.505n 0.0v 1369.495n 0.0v 1369.505n 0.0v 1379.495n 0.0v 1379.505n 0.0v 1389.495n 0.0v 1389.505n 0.0v 1399.495n 0.0v 1399.505n 0.0v 1409.495n 0.0v 1409.505n 0.0v 1419.495n 0.0v 1419.505n 0.0v 1429.495n 0.0v 1429.505n 0.0v 1439.495n 0.0v 1439.505n 0.0v 1449.495n 0.0v 1449.505n 0.0v 1459.495n 0.0v 1459.505n 0.0v 1469.495n 0.0v 1469.505n 0.0v 1479.495n 0.0v 1479.505n 0.0v 1489.495n 0.0v 1489.505n 3.3v 1499.495n 3.3v 1499.505n 3.3v 1509.495n 3.3v 1509.505n 3.3v 1519.495n 3.3v 1519.505n 3.3v 1529.495n 3.3v 1529.505n 3.3v 1539.495n 3.3v 1539.505n 3.3v 1549.495n 3.3v 1549.505n 3.3v 1559.495n 3.3v 1559.505n 3.3v 1569.495n 3.3v 1569.505n 3.3v 1579.495n 3.3v 1579.505n 3.3v 1589.495n 3.3v 1589.505n 3.3v 1599.495n 3.3v 1599.505n 3.3v 1609.495n 3.3v 1609.505n 3.3v 1619.495n 3.3v 1619.505n 3.3v 1629.495n 3.3v 1629.505n 3.3v 1639.495n 3.3v 1639.505n 3.3v 1649.495n 3.3v 1649.505n 3.3v 1659.495n 3.3v 1659.505n 3.3v 1669.495n 3.3v 1669.505n 3.3v 1679.495n 3.3v 1679.505n 3.3v 1689.495n 3.3v 1689.505n 3.3v 1699.495n 3.3v 1699.505n 3.3v 1709.495n 3.3v 1709.505n 3.3v 1719.495n 3.3v 1719.505n 3.3v 1729.495n 3.3v 1729.505n 3.3v 1739.495n 3.3v 1739.505n 3.3v 1749.495n 3.3v 1749.505n 0.0v 1759.495n 0.0v 1759.505n 0.0v 1769.495n 0.0v 1769.505n 0.0v 1779.495n 0.0v 1779.505n 0.0v 1789.495n 0.0v 1789.505n 0.0v 1799.495n 0.0v 1799.505n 0.0v 1809.495n 0.0v 1809.505n 0.0v 1819.495n 0.0v 1819.505n 0.0v 1829.495n 0.0v 1829.505n 0.0v 1839.495n 0.0v 1839.505n 0.0v 1849.495n 0.0v 1849.505n 0.0v 1859.495n 0.0v 1859.505n 3.3v 1869.495n 3.3v 1869.505n 3.3v 1879.495n 3.3v 1879.505n 0.0v 1889.495n 0.0v 1889.505n 0.0v 1899.495n 0.0v 1899.505n 0.0v 1909.495n 0.0v 1909.505n 3.3v 1919.495n 3.3v 1919.505n 3.3v 1929.495n 3.3v 1929.505n 3.3v 1939.495n 3.3v 1939.505n 0.0v 1949.495n 0.0v 1949.505n 0.0v 1959.495n 0.0v 1959.505n 0.0v 1969.495n 0.0v 1969.505n 0.0v 1979.495n 0.0v 1979.505n 0.0v 1989.495n 0.0v 1989.505n 0.0v 1999.495n 0.0v 1999.505n 3.3v 2009.495n 3.3v 2009.505n 3.3v 2019.495n 3.3v 2019.505n 0.0v 2029.495n 0.0v 2029.505n 3.3v 2039.495n 3.3v 2039.505n 3.3v 2049.495n 3.3v 2049.505n 3.3v )
* (time, data): [(0, 0), (10, 0), (20, 1), (30, 0), (40, 0), (50, 0), (60, 0), (70, 1), (80, 1), (90, 1), (100, 1), (110, 1), (120, 0), (130, 0), (140, 0), (150, 0), (160, 0), (170, 0), (180, 0), (190, 0), (200, 0), (210, 0), (220, 0), (230, 0), (240, 0), (250, 0), (260, 0), (270, 0), (280, 0), (290, 0), (300, 0), (310, 0), (320, 0), (330, 0), (340, 0), (350, 0), (360, 0), (370, 0), (380, 0), (390, 0), (400, 0), (410, 0), (420, 0), (430, 0), (440, 0), (450, 0), (460, 0), (470, 0), (480, 0), (490, 0), (500, 0), (510, 0), (520, 0), (530, 0), (540, 0), (550, 0), (560, 0), (570, 0), (580, 0), (590, 0), (600, 0), (610, 0), (620, 0), (630, 0), (640, 0), (650, 0), (660, 0), (670, 0), (680, 1), (690, 1), (700, 1), (710, 1), (720, 1), (730, 1), (740, 1), (750, 1), (760, 1), (770, 1), (780, 1), (790, 1), (800, 1), (810, 1), (820, 1), (830, 1), (840, 1), (850, 1), (860, 0), (870, 1), (880, 1), (890, 1), (900, 1), (910, 1), (920, 1), (930, 1), (940, 1), (950, 0), (960, 0), (970, 0), (980, 0), (990, 0), (1000, 0), (1010, 0), (1020, 0), (1030, 0), (1040, 1), (1050, 1), (1060, 1), (1070, 1), (1080, 1), (1090, 1), (1100, 0), (1110, 0), (1120, 0), (1130, 0), (1140, 1), (1150, 1), (1160, 1), (1170, 1), (1180, 1), (1190, 1), (1200, 1), (1210, 1), (1220, 1), (1230, 1), (1240, 1), (1250, 1), (1260, 1), (1270, 1), (1280, 1), (1290, 1), (1300, 1), (1310, 0), (1320, 0), (1330, 0), (1340, 0), (1350, 0), (1360, 0), (1370, 0), (1380, 0), (1390, 0), (1400, 0), (1410, 0), (1420, 0), (1430, 0), (1440, 1), (1450, 1), (1460, 1), (1470, 1), (1480, 1), (1490, 0), (1500, 0), (1510, 0), (1520, 0), (1530, 0), (1540, 0), (1550, 0), (1560, 0), (1570, 0), (1580, 0), (1590, 0), (1600, 1), (1610, 1), (1620, 1), (1630, 1), (1640, 1), (1650, 1), (1660, 1), (1670, 1), (1680, 1), (1690, 1), (1700, 1), (1710, 1), (1720, 1), (1730, 1), (1740, 1), (1750, 0), (1760, 0), (1770, 0), (1780, 0), (1790, 0), (1800, 0), (1810, 0), (1820, 1), (1830, 1), (1840, 1), (1850, 1), (1860, 0), (1870, 0), (1880, 1), (1890, 1), (1900, 1), (1910, 0), (1920, 0), (1930, 0), (1940, 0), (1950, 0), (1960, 0), (1970, 0), (1980, 1), (1990, 1), (2000, 0), (2010, 0), (2020, 0), (2030, 0), (2040, 0), (2050, 0)]
Vdin1_1  din1_1  0 PWL (0n 0.0v 9.495n 0.0v 9.505n 0.0v 19.495n 0.0v 19.505n 3.3v 29.495n 3.3v 29.505n 0.0v 39.495n 0.0v 39.505n 0.0v 49.495n 0.0v 49.505n 0.0v 59.495n 0.0v 59.505n 0.0v 69.495n 0.0v 69.505n 3.3v 79.495n 3.3v 79.505n 3.3v 89.495n 3.3v 89.505n 3.3v 99.495n 3.3v 99.505n 3.3v 109.495n 3.3v 109.505n 3.3v 119.495n 3.3v 119.505n 0.0v 129.495n 0.0v 129.505n 0.0v 139.495n 0.0v 139.505n 0.0v 149.495n 0.0v 149.505n 0.0v 159.495n 0.0v 159.505n 0.0v 169.495n 0.0v 169.505n 0.0v 179.495n 0.0v 179.505n 0.0v 189.495n 0.0v 189.505n 0.0v 199.495n 0.0v 199.505n 0.0v 209.495n 0.0v 209.505n 0.0v 219.495n 0.0v 219.505n 0.0v 229.495n 0.0v 229.505n 0.0v 239.495n 0.0v 239.505n 0.0v 249.495n 0.0v 249.505n 0.0v 259.495n 0.0v 259.505n 0.0v 269.495n 0.0v 269.505n 0.0v 279.495n 0.0v 279.505n 0.0v 289.495n 0.0v 289.505n 0.0v 299.495n 0.0v 299.505n 0.0v 309.495n 0.0v 309.505n 0.0v 319.495n 0.0v 319.505n 0.0v 329.495n 0.0v 329.505n 0.0v 339.495n 0.0v 339.505n 0.0v 349.495n 0.0v 349.505n 0.0v 359.495n 0.0v 359.505n 0.0v 369.495n 0.0v 369.505n 0.0v 379.495n 0.0v 379.505n 0.0v 389.495n 0.0v 389.505n 0.0v 399.495n 0.0v 399.505n 0.0v 409.495n 0.0v 409.505n 0.0v 419.495n 0.0v 419.505n 0.0v 429.495n 0.0v 429.505n 0.0v 439.495n 0.0v 439.505n 0.0v 449.495n 0.0v 449.505n 0.0v 459.495n 0.0v 459.505n 0.0v 469.495n 0.0v 469.505n 0.0v 479.495n 0.0v 479.505n 0.0v 489.495n 0.0v 489.505n 0.0v 499.495n 0.0v 499.505n 0.0v 509.495n 0.0v 509.505n 0.0v 519.495n 0.0v 519.505n 0.0v 529.495n 0.0v 529.505n 0.0v 539.495n 0.0v 539.505n 0.0v 549.495n 0.0v 549.505n 0.0v 559.495n 0.0v 559.505n 0.0v 569.495n 0.0v 569.505n 0.0v 579.495n 0.0v 579.505n 0.0v 589.495n 0.0v 589.505n 0.0v 599.495n 0.0v 599.505n 0.0v 609.495n 0.0v 609.505n 0.0v 619.495n 0.0v 619.505n 0.0v 629.495n 0.0v 629.505n 0.0v 639.495n 0.0v 639.505n 0.0v 649.495n 0.0v 649.505n 0.0v 659.495n 0.0v 659.505n 0.0v 669.495n 0.0v 669.505n 0.0v 679.495n 0.0v 679.505n 3.3v 689.495n 3.3v 689.505n 3.3v 699.495n 3.3v 699.505n 3.3v 709.495n 3.3v 709.505n 3.3v 719.495n 3.3v 719.505n 3.3v 729.495n 3.3v 729.505n 3.3v 739.495n 3.3v 739.505n 3.3v 749.495n 3.3v 749.505n 3.3v 759.495n 3.3v 759.505n 3.3v 769.495n 3.3v 769.505n 3.3v 779.495n 3.3v 779.505n 3.3v 789.495n 3.3v 789.505n 3.3v 799.495n 3.3v 799.505n 3.3v 809.495n 3.3v 809.505n 3.3v 819.495n 3.3v 819.505n 3.3v 829.495n 3.3v 829.505n 3.3v 839.495n 3.3v 839.505n 3.3v 849.495n 3.3v 849.505n 3.3v 859.495n 3.3v 859.505n 0.0v 869.495n 0.0v 869.505n 3.3v 879.495n 3.3v 879.505n 3.3v 889.495n 3.3v 889.505n 3.3v 899.495n 3.3v 899.505n 3.3v 909.495n 3.3v 909.505n 3.3v 919.495n 3.3v 919.505n 3.3v 929.495n 3.3v 929.505n 3.3v 939.495n 3.3v 939.505n 3.3v 949.495n 3.3v 949.505n 0.0v 959.495n 0.0v 959.505n 0.0v 969.495n 0.0v 969.505n 0.0v 979.495n 0.0v 979.505n 0.0v 989.495n 0.0v 989.505n 0.0v 999.495n 0.0v 999.505n 0.0v 1009.495n 0.0v 1009.505n 0.0v 1019.495n 0.0v 1019.505n 0.0v 1029.495n 0.0v 1029.505n 0.0v 1039.495n 0.0v 1039.505n 3.3v 1049.495n 3.3v 1049.505n 3.3v 1059.495n 3.3v 1059.505n 3.3v 1069.495n 3.3v 1069.505n 3.3v 1079.495n 3.3v 1079.505n 3.3v 1089.495n 3.3v 1089.505n 3.3v 1099.495n 3.3v 1099.505n 0.0v 1109.495n 0.0v 1109.505n 0.0v 1119.495n 0.0v 1119.505n 0.0v 1129.495n 0.0v 1129.505n 0.0v 1139.495n 0.0v 1139.505n 3.3v 1149.495n 3.3v 1149.505n 3.3v 1159.495n 3.3v 1159.505n 3.3v 1169.495n 3.3v 1169.505n 3.3v 1179.495n 3.3v 1179.505n 3.3v 1189.495n 3.3v 1189.505n 3.3v 1199.495n 3.3v 1199.505n 3.3v 1209.495n 3.3v 1209.505n 3.3v 1219.495n 3.3v 1219.505n 3.3v 1229.495n 3.3v 1229.505n 3.3v 1239.495n 3.3v 1239.505n 3.3v 1249.495n 3.3v 1249.505n 3.3v 1259.495n 3.3v 1259.505n 3.3v 1269.495n 3.3v 1269.505n 3.3v 1279.495n 3.3v 1279.505n 3.3v 1289.495n 3.3v 1289.505n 3.3v 1299.495n 3.3v 1299.505n 3.3v 1309.495n 3.3v 1309.505n 0.0v 1319.495n 0.0v 1319.505n 0.0v 1329.495n 0.0v 1329.505n 0.0v 1339.495n 0.0v 1339.505n 0.0v 1349.495n 0.0v 1349.505n 0.0v 1359.495n 0.0v 1359.505n 0.0v 1369.495n 0.0v 1369.505n 0.0v 1379.495n 0.0v 1379.505n 0.0v 1389.495n 0.0v 1389.505n 0.0v 1399.495n 0.0v 1399.505n 0.0v 1409.495n 0.0v 1409.505n 0.0v 1419.495n 0.0v 1419.505n 0.0v 1429.495n 0.0v 1429.505n 0.0v 1439.495n 0.0v 1439.505n 3.3v 1449.495n 3.3v 1449.505n 3.3v 1459.495n 3.3v 1459.505n 3.3v 1469.495n 3.3v 1469.505n 3.3v 1479.495n 3.3v 1479.505n 3.3v 1489.495n 3.3v 1489.505n 0.0v 1499.495n 0.0v 1499.505n 0.0v 1509.495n 0.0v 1509.505n 0.0v 1519.495n 0.0v 1519.505n 0.0v 1529.495n 0.0v 1529.505n 0.0v 1539.495n 0.0v 1539.505n 0.0v 1549.495n 0.0v 1549.505n 0.0v 1559.495n 0.0v 1559.505n 0.0v 1569.495n 0.0v 1569.505n 0.0v 1579.495n 0.0v 1579.505n 0.0v 1589.495n 0.0v 1589.505n 0.0v 1599.495n 0.0v 1599.505n 3.3v 1609.495n 3.3v 1609.505n 3.3v 1619.495n 3.3v 1619.505n 3.3v 1629.495n 3.3v 1629.505n 3.3v 1639.495n 3.3v 1639.505n 3.3v 1649.495n 3.3v 1649.505n 3.3v 1659.495n 3.3v 1659.505n 3.3v 1669.495n 3.3v 1669.505n 3.3v 1679.495n 3.3v 1679.505n 3.3v 1689.495n 3.3v 1689.505n 3.3v 1699.495n 3.3v 1699.505n 3.3v 1709.495n 3.3v 1709.505n 3.3v 1719.495n 3.3v 1719.505n 3.3v 1729.495n 3.3v 1729.505n 3.3v 1739.495n 3.3v 1739.505n 3.3v 1749.495n 3.3v 1749.505n 0.0v 1759.495n 0.0v 1759.505n 0.0v 1769.495n 0.0v 1769.505n 0.0v 1779.495n 0.0v 1779.505n 0.0v 1789.495n 0.0v 1789.505n 0.0v 1799.495n 0.0v 1799.505n 0.0v 1809.495n 0.0v 1809.505n 0.0v 1819.495n 0.0v 1819.505n 3.3v 1829.495n 3.3v 1829.505n 3.3v 1839.495n 3.3v 1839.505n 3.3v 1849.495n 3.3v 1849.505n 3.3v 1859.495n 3.3v 1859.505n 0.0v 1869.495n 0.0v 1869.505n 0.0v 1879.495n 0.0v 1879.505n 3.3v 1889.495n 3.3v 1889.505n 3.3v 1899.495n 3.3v 1899.505n 3.3v 1909.495n 3.3v 1909.505n 0.0v 1919.495n 0.0v 1919.505n 0.0v 1929.495n 0.0v 1929.505n 0.0v 1939.495n 0.0v 1939.505n 0.0v 1949.495n 0.0v 1949.505n 0.0v 1959.495n 0.0v 1959.505n 0.0v 1969.495n 0.0v 1969.505n 0.0v 1979.495n 0.0v 1979.505n 3.3v 1989.495n 3.3v 1989.505n 3.3v 1999.495n 3.3v 1999.505n 0.0v 2009.495n 0.0v 2009.505n 0.0v 2019.495n 0.0v 2019.505n 0.0v 2029.495n 0.0v 2029.505n 0.0v 2039.495n 0.0v 2039.505n 0.0v 2049.495n 0.0v 2049.505n 0.0v )
* (time, data): [(0, 0), (10, 1), (20, 0), (30, 1), (40, 1), (50, 1), (60, 1), (70, 1), (80, 1), (90, 1), (100, 1), (110, 1), (120, 1), (130, 1), (140, 0), (150, 0), (160, 0), (170, 0), (180, 0), (190, 0), (200, 0), (210, 0), (220, 0), (230, 0), (240, 0), (250, 0), (260, 0), (270, 0), (280, 0), (290, 0), (300, 0), (310, 0), (320, 0), (330, 0), (340, 0), (350, 0), (360, 0), (370, 1), (380, 0), (390, 0), (400, 0), (410, 0), (420, 0), (430, 0), (440, 0), (450, 0), (460, 0), (470, 0), (480, 0), (490, 0), (500, 0), (510, 0), (520, 0), (530, 0), (540, 0), (550, 0), (560, 0), (570, 0), (580, 0), (590, 0), (600, 0), (610, 0), (620, 0), (630, 0), (640, 0), (650, 0), (660, 0), (670, 0), (680, 0), (690, 0), (700, 0), (710, 0), (720, 1), (730, 1), (740, 1), (750, 1), (760, 1), (770, 1), (780, 1), (790, 1), (800, 1), (810, 1), (820, 1), (830, 1), (840, 1), (850, 1), (860, 0), (870, 0), (880, 0), (890, 0), (900, 0), (910, 0), (920, 0), (930, 0), (940, 1), (950, 0), (960, 0), (970, 0), (980, 0), (990, 0), (1000, 0), (1010, 0), (1020, 0), (1030, 0), (1040, 0), (1050, 0), (1060, 0), (1070, 0), (1080, 0), (1090, 0), (1100, 1), (1110, 0), (1120, 0), (1130, 0), (1140, 1), (1150, 1), (1160, 1), (1170, 1), (1180, 1), (1190, 1), (1200, 1), (1210, 0), (1220, 0), (1230, 0), (1240, 0), (1250, 0), (1260, 0), (1270, 0), (1280, 0), (1290, 0), (1300, 0), (1310, 0), (1320, 0), (1330, 0), (1340, 0), (1350, 0), (1360, 0), (1370, 0), (1380, 0), (1390, 0), (1400, 0), (1410, 0), (1420, 0), (1430, 0), (1440, 1), (1450, 1), (1460, 1), (1470, 1), (1480, 1), (1490, 1), (1500, 1), (1510, 1), (1520, 1), (1530, 1), (1540, 1), (1550, 0), (1560, 0), (1570, 0), (1580, 0), (1590, 0), (1600, 0), (1610, 0), (1620, 0), (1630, 0), (1640, 0), (1650, 0), (1660, 0), (1670, 0), (1680, 0), (1690, 0), (1700, 0), (1710, 0), (1720, 0), (1730, 1), (1740, 1), (1750, 1), (1760, 1), (1770, 0), (1780, 0), (1790, 0), (1800, 0), (1810, 0), (1820, 1), (1830, 1), (1840, 1), (1850, 1), (1860, 0), (1870, 0), (1880, 0), (1890, 0), (1900, 0), (1910, 1), (1920, 1), (1930, 1), (1940, 0), (1950, 0), (1960, 0), (1970, 0), (1980, 0), (1990, 0), (2000, 0), (2010, 0), (2020, 1), (2030, 1), (2040, 1), (2050, 1)]
Vdin1_2  din1_2  0 PWL (0n 0.0v 9.495n 0.0v 9.505n 3.3v 19.495n 3.3v 19.505n 0.0v 29.495n 0.0v 29.505n 3.3v 39.495n 3.3v 39.505n 3.3v 49.495n 3.3v 49.505n 3.3v 59.495n 3.3v 59.505n 3.3v 69.495n 3.3v 69.505n 3.3v 79.495n 3.3v 79.505n 3.3v 89.495n 3.3v 89.505n 3.3v 99.495n 3.3v 99.505n 3.3v 109.495n 3.3v 109.505n 3.3v 119.495n 3.3v 119.505n 3.3v 129.495n 3.3v 129.505n 3.3v 139.495n 3.3v 139.505n 0.0v 149.495n 0.0v 149.505n 0.0v 159.495n 0.0v 159.505n 0.0v 169.495n 0.0v 169.505n 0.0v 179.495n 0.0v 179.505n 0.0v 189.495n 0.0v 189.505n 0.0v 199.495n 0.0v 199.505n 0.0v 209.495n 0.0v 209.505n 0.0v 219.495n 0.0v 219.505n 0.0v 229.495n 0.0v 229.505n 0.0v 239.495n 0.0v 239.505n 0.0v 249.495n 0.0v 249.505n 0.0v 259.495n 0.0v 259.505n 0.0v 269.495n 0.0v 269.505n 0.0v 279.495n 0.0v 279.505n 0.0v 289.495n 0.0v 289.505n 0.0v 299.495n 0.0v 299.505n 0.0v 309.495n 0.0v 309.505n 0.0v 319.495n 0.0v 319.505n 0.0v 329.495n 0.0v 329.505n 0.0v 339.495n 0.0v 339.505n 0.0v 349.495n 0.0v 349.505n 0.0v 359.495n 0.0v 359.505n 0.0v 369.495n 0.0v 369.505n 3.3v 379.495n 3.3v 379.505n 0.0v 389.495n 0.0v 389.505n 0.0v 399.495n 0.0v 399.505n 0.0v 409.495n 0.0v 409.505n 0.0v 419.495n 0.0v 419.505n 0.0v 429.495n 0.0v 429.505n 0.0v 439.495n 0.0v 439.505n 0.0v 449.495n 0.0v 449.505n 0.0v 459.495n 0.0v 459.505n 0.0v 469.495n 0.0v 469.505n 0.0v 479.495n 0.0v 479.505n 0.0v 489.495n 0.0v 489.505n 0.0v 499.495n 0.0v 499.505n 0.0v 509.495n 0.0v 509.505n 0.0v 519.495n 0.0v 519.505n 0.0v 529.495n 0.0v 529.505n 0.0v 539.495n 0.0v 539.505n 0.0v 549.495n 0.0v 549.505n 0.0v 559.495n 0.0v 559.505n 0.0v 569.495n 0.0v 569.505n 0.0v 579.495n 0.0v 579.505n 0.0v 589.495n 0.0v 589.505n 0.0v 599.495n 0.0v 599.505n 0.0v 609.495n 0.0v 609.505n 0.0v 619.495n 0.0v 619.505n 0.0v 629.495n 0.0v 629.505n 0.0v 639.495n 0.0v 639.505n 0.0v 649.495n 0.0v 649.505n 0.0v 659.495n 0.0v 659.505n 0.0v 669.495n 0.0v 669.505n 0.0v 679.495n 0.0v 679.505n 0.0v 689.495n 0.0v 689.505n 0.0v 699.495n 0.0v 699.505n 0.0v 709.495n 0.0v 709.505n 0.0v 719.495n 0.0v 719.505n 3.3v 729.495n 3.3v 729.505n 3.3v 739.495n 3.3v 739.505n 3.3v 749.495n 3.3v 749.505n 3.3v 759.495n 3.3v 759.505n 3.3v 769.495n 3.3v 769.505n 3.3v 779.495n 3.3v 779.505n 3.3v 789.495n 3.3v 789.505n 3.3v 799.495n 3.3v 799.505n 3.3v 809.495n 3.3v 809.505n 3.3v 819.495n 3.3v 819.505n 3.3v 829.495n 3.3v 829.505n 3.3v 839.495n 3.3v 839.505n 3.3v 849.495n 3.3v 849.505n 3.3v 859.495n 3.3v 859.505n 0.0v 869.495n 0.0v 869.505n 0.0v 879.495n 0.0v 879.505n 0.0v 889.495n 0.0v 889.505n 0.0v 899.495n 0.0v 899.505n 0.0v 909.495n 0.0v 909.505n 0.0v 919.495n 0.0v 919.505n 0.0v 929.495n 0.0v 929.505n 0.0v 939.495n 0.0v 939.505n 3.3v 949.495n 3.3v 949.505n 0.0v 959.495n 0.0v 959.505n 0.0v 969.495n 0.0v 969.505n 0.0v 979.495n 0.0v 979.505n 0.0v 989.495n 0.0v 989.505n 0.0v 999.495n 0.0v 999.505n 0.0v 1009.495n 0.0v 1009.505n 0.0v 1019.495n 0.0v 1019.505n 0.0v 1029.495n 0.0v 1029.505n 0.0v 1039.495n 0.0v 1039.505n 0.0v 1049.495n 0.0v 1049.505n 0.0v 1059.495n 0.0v 1059.505n 0.0v 1069.495n 0.0v 1069.505n 0.0v 1079.495n 0.0v 1079.505n 0.0v 1089.495n 0.0v 1089.505n 0.0v 1099.495n 0.0v 1099.505n 3.3v 1109.495n 3.3v 1109.505n 0.0v 1119.495n 0.0v 1119.505n 0.0v 1129.495n 0.0v 1129.505n 0.0v 1139.495n 0.0v 1139.505n 3.3v 1149.495n 3.3v 1149.505n 3.3v 1159.495n 3.3v 1159.505n 3.3v 1169.495n 3.3v 1169.505n 3.3v 1179.495n 3.3v 1179.505n 3.3v 1189.495n 3.3v 1189.505n 3.3v 1199.495n 3.3v 1199.505n 3.3v 1209.495n 3.3v 1209.505n 0.0v 1219.495n 0.0v 1219.505n 0.0v 1229.495n 0.0v 1229.505n 0.0v 1239.495n 0.0v 1239.505n 0.0v 1249.495n 0.0v 1249.505n 0.0v 1259.495n 0.0v 1259.505n 0.0v 1269.495n 0.0v 1269.505n 0.0v 1279.495n 0.0v 1279.505n 0.0v 1289.495n 0.0v 1289.505n 0.0v 1299.495n 0.0v 1299.505n 0.0v 1309.495n 0.0v 1309.505n 0.0v 1319.495n 0.0v 1319.505n 0.0v 1329.495n 0.0v 1329.505n 0.0v 1339.495n 0.0v 1339.505n 0.0v 1349.495n 0.0v 1349.505n 0.0v 1359.495n 0.0v 1359.505n 0.0v 1369.495n 0.0v 1369.505n 0.0v 1379.495n 0.0v 1379.505n 0.0v 1389.495n 0.0v 1389.505n 0.0v 1399.495n 0.0v 1399.505n 0.0v 1409.495n 0.0v 1409.505n 0.0v 1419.495n 0.0v 1419.505n 0.0v 1429.495n 0.0v 1429.505n 0.0v 1439.495n 0.0v 1439.505n 3.3v 1449.495n 3.3v 1449.505n 3.3v 1459.495n 3.3v 1459.505n 3.3v 1469.495n 3.3v 1469.505n 3.3v 1479.495n 3.3v 1479.505n 3.3v 1489.495n 3.3v 1489.505n 3.3v 1499.495n 3.3v 1499.505n 3.3v 1509.495n 3.3v 1509.505n 3.3v 1519.495n 3.3v 1519.505n 3.3v 1529.495n 3.3v 1529.505n 3.3v 1539.495n 3.3v 1539.505n 3.3v 1549.495n 3.3v 1549.505n 0.0v 1559.495n 0.0v 1559.505n 0.0v 1569.495n 0.0v 1569.505n 0.0v 1579.495n 0.0v 1579.505n 0.0v 1589.495n 0.0v 1589.505n 0.0v 1599.495n 0.0v 1599.505n 0.0v 1609.495n 0.0v 1609.505n 0.0v 1619.495n 0.0v 1619.505n 0.0v 1629.495n 0.0v 1629.505n 0.0v 1639.495n 0.0v 1639.505n 0.0v 1649.495n 0.0v 1649.505n 0.0v 1659.495n 0.0v 1659.505n 0.0v 1669.495n 0.0v 1669.505n 0.0v 1679.495n 0.0v 1679.505n 0.0v 1689.495n 0.0v 1689.505n 0.0v 1699.495n 0.0v 1699.505n 0.0v 1709.495n 0.0v 1709.505n 0.0v 1719.495n 0.0v 1719.505n 0.0v 1729.495n 0.0v 1729.505n 3.3v 1739.495n 3.3v 1739.505n 3.3v 1749.495n 3.3v 1749.505n 3.3v 1759.495n 3.3v 1759.505n 3.3v 1769.495n 3.3v 1769.505n 0.0v 1779.495n 0.0v 1779.505n 0.0v 1789.495n 0.0v 1789.505n 0.0v 1799.495n 0.0v 1799.505n 0.0v 1809.495n 0.0v 1809.505n 0.0v 1819.495n 0.0v 1819.505n 3.3v 1829.495n 3.3v 1829.505n 3.3v 1839.495n 3.3v 1839.505n 3.3v 1849.495n 3.3v 1849.505n 3.3v 1859.495n 3.3v 1859.505n 0.0v 1869.495n 0.0v 1869.505n 0.0v 1879.495n 0.0v 1879.505n 0.0v 1889.495n 0.0v 1889.505n 0.0v 1899.495n 0.0v 1899.505n 0.0v 1909.495n 0.0v 1909.505n 3.3v 1919.495n 3.3v 1919.505n 3.3v 1929.495n 3.3v 1929.505n 3.3v 1939.495n 3.3v 1939.505n 0.0v 1949.495n 0.0v 1949.505n 0.0v 1959.495n 0.0v 1959.505n 0.0v 1969.495n 0.0v 1969.505n 0.0v 1979.495n 0.0v 1979.505n 0.0v 1989.495n 0.0v 1989.505n 0.0v 1999.495n 0.0v 1999.505n 0.0v 2009.495n 0.0v 2009.505n 0.0v 2019.495n 0.0v 2019.505n 3.3v 2029.495n 3.3v 2029.505n 3.3v 2039.495n 3.3v 2039.505n 3.3v 2049.495n 3.3v 2049.505n 3.3v )
* (time, data): [(0, 0), (10, 1), (20, 1), (30, 1), (40, 1), (50, 1), (60, 1), (70, 0), (80, 0), (90, 0), (100, 0), (110, 0), (120, 1), (130, 1), (140, 1), (150, 1), (160, 1), (170, 1), (180, 1), (190, 1), (200, 1), (210, 1), (220, 1), (230, 1), (240, 0), (250, 0), (260, 0), (270, 0), (280, 0), (290, 0), (300, 0), (310, 0), (320, 0), (330, 0), (340, 0), (350, 0), (360, 0), (370, 1), (380, 1), (390, 1), (400, 1), (410, 1), (420, 1), (430, 1), (440, 1), (450, 1), (460, 1), (470, 1), (480, 1), (490, 1), (500, 0), (510, 0), (520, 0), (530, 0), (540, 0), (550, 0), (560, 0), (570, 0), (580, 0), (590, 0), (600, 0), (610, 0), (620, 0), (630, 0), (640, 0), (650, 0), (660, 0), (670, 0), (680, 1), (690, 1), (700, 1), (710, 1), (720, 0), (730, 0), (740, 0), (750, 0), (760, 0), (770, 0), (780, 0), (790, 0), (800, 0), (810, 0), (820, 0), (830, 0), (840, 0), (850, 0), (860, 1), (870, 1), (880, 1), (890, 1), (900, 1), (910, 1), (920, 1), (930, 1), (940, 0), (950, 1), (960, 1), (970, 1), (980, 1), (990, 1), (1000, 1), (1010, 1), (1020, 1), (1030, 1), (1040, 0), (1050, 0), (1060, 0), (1070, 0), (1080, 0), (1090, 0), (1100, 1), (1110, 0), (1120, 0), (1130, 0), (1140, 0), (1150, 0), (1160, 0), (1170, 0), (1180, 0), (1190, 0), (1200, 0), (1210, 1), (1220, 1), (1230, 1), (1240, 1), (1250, 1), (1260, 1), (1270, 1), (1280, 1), (1290, 1), (1300, 1), (1310, 0), (1320, 0), (1330, 0), (1340, 0), (1350, 0), (1360, 0), (1370, 0), (1380, 0), (1390, 0), (1400, 0), (1410, 0), (1420, 0), (1430, 0), (1440, 0), (1450, 0), (1460, 0), (1470, 0), (1480, 0), (1490, 0), (1500, 0), (1510, 0), (1520, 0), (1530, 0), (1540, 0), (1550, 0), (1560, 1), (1570, 1), (1580, 1), (1590, 1), (1600, 0), (1610, 0), (1620, 0), (1630, 0), (1640, 0), (1650, 0), (1660, 0), (1670, 0), (1680, 0), (1690, 0), (1700, 0), (1710, 0), (1720, 0), (1730, 1), (1740, 1), (1750, 0), (1760, 0), (1770, 1), (1780, 1), (1790, 1), (1800, 1), (1810, 1), (1820, 0), (1830, 0), (1840, 0), (1850, 0), (1860, 1), (1870, 1), (1880, 0), (1890, 0), (1900, 0), (1910, 1), (1920, 1), (1930, 1), (1940, 1), (1950, 1), (1960, 1), (1970, 1), (1980, 0), (1990, 0), (2000, 0), (2010, 0), (2020, 1), (2030, 0), (2040, 0), (2050, 0)]
Vdin1_3  din1_3  0 PWL (0n 0.0v 9.495n 0.0v 9.505n 3.3v 19.495n 3.3v 19.505n 3.3v 29.495n 3.3v 29.505n 3.3v 39.495n 3.3v 39.505n 3.3v 49.495n 3.3v 49.505n 3.3v 59.495n 3.3v 59.505n 3.3v 69.495n 3.3v 69.505n 0.0v 79.495n 0.0v 79.505n 0.0v 89.495n 0.0v 89.505n 0.0v 99.495n 0.0v 99.505n 0.0v 109.495n 0.0v 109.505n 0.0v 119.495n 0.0v 119.505n 3.3v 129.495n 3.3v 129.505n 3.3v 139.495n 3.3v 139.505n 3.3v 149.495n 3.3v 149.505n 3.3v 159.495n 3.3v 159.505n 3.3v 169.495n 3.3v 169.505n 3.3v 179.495n 3.3v 179.505n 3.3v 189.495n 3.3v 189.505n 3.3v 199.495n 3.3v 199.505n 3.3v 209.495n 3.3v 209.505n 3.3v 219.495n 3.3v 219.505n 3.3v 229.495n 3.3v 229.505n 3.3v 239.495n 3.3v 239.505n 0.0v 249.495n 0.0v 249.505n 0.0v 259.495n 0.0v 259.505n 0.0v 269.495n 0.0v 269.505n 0.0v 279.495n 0.0v 279.505n 0.0v 289.495n 0.0v 289.505n 0.0v 299.495n 0.0v 299.505n 0.0v 309.495n 0.0v 309.505n 0.0v 319.495n 0.0v 319.505n 0.0v 329.495n 0.0v 329.505n 0.0v 339.495n 0.0v 339.505n 0.0v 349.495n 0.0v 349.505n 0.0v 359.495n 0.0v 359.505n 0.0v 369.495n 0.0v 369.505n 3.3v 379.495n 3.3v 379.505n 3.3v 389.495n 3.3v 389.505n 3.3v 399.495n 3.3v 399.505n 3.3v 409.495n 3.3v 409.505n 3.3v 419.495n 3.3v 419.505n 3.3v 429.495n 3.3v 429.505n 3.3v 439.495n 3.3v 439.505n 3.3v 449.495n 3.3v 449.505n 3.3v 459.495n 3.3v 459.505n 3.3v 469.495n 3.3v 469.505n 3.3v 479.495n 3.3v 479.505n 3.3v 489.495n 3.3v 489.505n 3.3v 499.495n 3.3v 499.505n 0.0v 509.495n 0.0v 509.505n 0.0v 519.495n 0.0v 519.505n 0.0v 529.495n 0.0v 529.505n 0.0v 539.495n 0.0v 539.505n 0.0v 549.495n 0.0v 549.505n 0.0v 559.495n 0.0v 559.505n 0.0v 569.495n 0.0v 569.505n 0.0v 579.495n 0.0v 579.505n 0.0v 589.495n 0.0v 589.505n 0.0v 599.495n 0.0v 599.505n 0.0v 609.495n 0.0v 609.505n 0.0v 619.495n 0.0v 619.505n 0.0v 629.495n 0.0v 629.505n 0.0v 639.495n 0.0v 639.505n 0.0v 649.495n 0.0v 649.505n 0.0v 659.495n 0.0v 659.505n 0.0v 669.495n 0.0v 669.505n 0.0v 679.495n 0.0v 679.505n 3.3v 689.495n 3.3v 689.505n 3.3v 699.495n 3.3v 699.505n 3.3v 709.495n 3.3v 709.505n 3.3v 719.495n 3.3v 719.505n 0.0v 729.495n 0.0v 729.505n 0.0v 739.495n 0.0v 739.505n 0.0v 749.495n 0.0v 749.505n 0.0v 759.495n 0.0v 759.505n 0.0v 769.495n 0.0v 769.505n 0.0v 779.495n 0.0v 779.505n 0.0v 789.495n 0.0v 789.505n 0.0v 799.495n 0.0v 799.505n 0.0v 809.495n 0.0v 809.505n 0.0v 819.495n 0.0v 819.505n 0.0v 829.495n 0.0v 829.505n 0.0v 839.495n 0.0v 839.505n 0.0v 849.495n 0.0v 849.505n 0.0v 859.495n 0.0v 859.505n 3.3v 869.495n 3.3v 869.505n 3.3v 879.495n 3.3v 879.505n 3.3v 889.495n 3.3v 889.505n 3.3v 899.495n 3.3v 899.505n 3.3v 909.495n 3.3v 909.505n 3.3v 919.495n 3.3v 919.505n 3.3v 929.495n 3.3v 929.505n 3.3v 939.495n 3.3v 939.505n 0.0v 949.495n 0.0v 949.505n 3.3v 959.495n 3.3v 959.505n 3.3v 969.495n 3.3v 969.505n 3.3v 979.495n 3.3v 979.505n 3.3v 989.495n 3.3v 989.505n 3.3v 999.495n 3.3v 999.505n 3.3v 1009.495n 3.3v 1009.505n 3.3v 1019.495n 3.3v 1019.505n 3.3v 1029.495n 3.3v 1029.505n 3.3v 1039.495n 3.3v 1039.505n 0.0v 1049.495n 0.0v 1049.505n 0.0v 1059.495n 0.0v 1059.505n 0.0v 1069.495n 0.0v 1069.505n 0.0v 1079.495n 0.0v 1079.505n 0.0v 1089.495n 0.0v 1089.505n 0.0v 1099.495n 0.0v 1099.505n 3.3v 1109.495n 3.3v 1109.505n 0.0v 1119.495n 0.0v 1119.505n 0.0v 1129.495n 0.0v 1129.505n 0.0v 1139.495n 0.0v 1139.505n 0.0v 1149.495n 0.0v 1149.505n 0.0v 1159.495n 0.0v 1159.505n 0.0v 1169.495n 0.0v 1169.505n 0.0v 1179.495n 0.0v 1179.505n 0.0v 1189.495n 0.0v 1189.505n 0.0v 1199.495n 0.0v 1199.505n 0.0v 1209.495n 0.0v 1209.505n 3.3v 1219.495n 3.3v 1219.505n 3.3v 1229.495n 3.3v 1229.505n 3.3v 1239.495n 3.3v 1239.505n 3.3v 1249.495n 3.3v 1249.505n 3.3v 1259.495n 3.3v 1259.505n 3.3v 1269.495n 3.3v 1269.505n 3.3v 1279.495n 3.3v 1279.505n 3.3v 1289.495n 3.3v 1289.505n 3.3v 1299.495n 3.3v 1299.505n 3.3v 1309.495n 3.3v 1309.505n 0.0v 1319.495n 0.0v 1319.505n 0.0v 1329.495n 0.0v 1329.505n 0.0v 1339.495n 0.0v 1339.505n 0.0v 1349.495n 0.0v 1349.505n 0.0v 1359.495n 0.0v 1359.505n 0.0v 1369.495n 0.0v 1369.505n 0.0v 1379.495n 0.0v 1379.505n 0.0v 1389.495n 0.0v 1389.505n 0.0v 1399.495n 0.0v 1399.505n 0.0v 1409.495n 0.0v 1409.505n 0.0v 1419.495n 0.0v 1419.505n 0.0v 1429.495n 0.0v 1429.505n 0.0v 1439.495n 0.0v 1439.505n 0.0v 1449.495n 0.0v 1449.505n 0.0v 1459.495n 0.0v 1459.505n 0.0v 1469.495n 0.0v 1469.505n 0.0v 1479.495n 0.0v 1479.505n 0.0v 1489.495n 0.0v 1489.505n 0.0v 1499.495n 0.0v 1499.505n 0.0v 1509.495n 0.0v 1509.505n 0.0v 1519.495n 0.0v 1519.505n 0.0v 1529.495n 0.0v 1529.505n 0.0v 1539.495n 0.0v 1539.505n 0.0v 1549.495n 0.0v 1549.505n 0.0v 1559.495n 0.0v 1559.505n 3.3v 1569.495n 3.3v 1569.505n 3.3v 1579.495n 3.3v 1579.505n 3.3v 1589.495n 3.3v 1589.505n 3.3v 1599.495n 3.3v 1599.505n 0.0v 1609.495n 0.0v 1609.505n 0.0v 1619.495n 0.0v 1619.505n 0.0v 1629.495n 0.0v 1629.505n 0.0v 1639.495n 0.0v 1639.505n 0.0v 1649.495n 0.0v 1649.505n 0.0v 1659.495n 0.0v 1659.505n 0.0v 1669.495n 0.0v 1669.505n 0.0v 1679.495n 0.0v 1679.505n 0.0v 1689.495n 0.0v 1689.505n 0.0v 1699.495n 0.0v 1699.505n 0.0v 1709.495n 0.0v 1709.505n 0.0v 1719.495n 0.0v 1719.505n 0.0v 1729.495n 0.0v 1729.505n 3.3v 1739.495n 3.3v 1739.505n 3.3v 1749.495n 3.3v 1749.505n 0.0v 1759.495n 0.0v 1759.505n 0.0v 1769.495n 0.0v 1769.505n 3.3v 1779.495n 3.3v 1779.505n 3.3v 1789.495n 3.3v 1789.505n 3.3v 1799.495n 3.3v 1799.505n 3.3v 1809.495n 3.3v 1809.505n 3.3v 1819.495n 3.3v 1819.505n 0.0v 1829.495n 0.0v 1829.505n 0.0v 1839.495n 0.0v 1839.505n 0.0v 1849.495n 0.0v 1849.505n 0.0v 1859.495n 0.0v 1859.505n 3.3v 1869.495n 3.3v 1869.505n 3.3v 1879.495n 3.3v 1879.505n 0.0v 1889.495n 0.0v 1889.505n 0.0v 1899.495n 0.0v 1899.505n 0.0v 1909.495n 0.0v 1909.505n 3.3v 1919.495n 3.3v 1919.505n 3.3v 1929.495n 3.3v 1929.505n 3.3v 1939.495n 3.3v 1939.505n 3.3v 1949.495n 3.3v 1949.505n 3.3v 1959.495n 3.3v 1959.505n 3.3v 1969.495n 3.3v 1969.505n 3.3v 1979.495n 3.3v 1979.505n 0.0v 1989.495n 0.0v 1989.505n 0.0v 1999.495n 0.0v 1999.505n 0.0v 2009.495n 0.0v 2009.505n 0.0v 2019.495n 0.0v 2019.505n 3.3v 2029.495n 3.3v 2029.505n 0.0v 2039.495n 0.0v 2039.505n 0.0v 2049.495n 0.0v 2049.505n 0.0v )
* (time, data): [(0, 0), (10, 0), (20, 1), (30, 0), (40, 0), (50, 0), (60, 0), (70, 1), (80, 0), (90, 0), (100, 0), (110, 0), (120, 1), (130, 1), (140, 1), (150, 1), (160, 1), (170, 0), (180, 0), (190, 0), (200, 0), (210, 0), (220, 0), (230, 0), (240, 1), (250, 1), (260, 1), (270, 1), (280, 1), (290, 1), (300, 1), (310, 1), (320, 1), (330, 1), (340, 1), (350, 1), (360, 1), (370, 0), (380, 0), (390, 0), (400, 1), (410, 1), (420, 1), (430, 1), (440, 1), (450, 1), (460, 1), (470, 1), (480, 1), (490, 1), (500, 0), (510, 0), (520, 0), (530, 0), (540, 0), (550, 0), (560, 0), (570, 0), (580, 0), (590, 0), (600, 0), (610, 0), (620, 0), (630, 0), (640, 0), (650, 0), (660, 1), (670, 1), (680, 0), (690, 0), (700, 0), (710, 1), (720, 0), (730, 0), (740, 0), (750, 0), (760, 0), (770, 0), (780, 0), (790, 0), (800, 0), (810, 0), (820, 0), (830, 0), (840, 0), (850, 0), (860, 0), (870, 0), (880, 0), (890, 0), (900, 0), (910, 0), (920, 0), (930, 0), (940, 0), (950, 0), (960, 0), (970, 0), (980, 0), (990, 0), (1000, 0), (1010, 0), (1020, 0), (1030, 0), (1040, 1), (1050, 1), (1060, 1), (1070, 1), (1080, 1), (1090, 1), (1100, 0), (1110, 0), (1120, 0), (1130, 0), (1140, 1), (1150, 1), (1160, 1), (1170, 1), (1180, 1), (1190, 1), (1200, 1), (1210, 1), (1220, 1), (1230, 1), (1240, 1), (1250, 1), (1260, 1), (1270, 1), (1280, 1), (1290, 1), (1300, 1), (1310, 0), (1320, 0), (1330, 0), (1340, 0), (1350, 0), (1360, 0), (1370, 0), (1380, 0), (1390, 0), (1400, 0), (1410, 0), (1420, 0), (1430, 0), (1440, 0), (1450, 0), (1460, 0), (1470, 0), (1480, 0), (1490, 0), (1500, 0), (1510, 0), (1520, 0), (1530, 0), (1540, 0), (1550, 1), (1560, 0), (1570, 0), (1580, 0), (1590, 0), (1600, 1), (1610, 1), (1620, 1), (1630, 1), (1640, 1), (1650, 1), (1660, 1), (1670, 1), (1680, 1), (1690, 1), (1700, 1), (1710, 1), (1720, 1), (1730, 0), (1740, 0), (1750, 0), (1760, 0), (1770, 1), (1780, 1), (1790, 1), (1800, 1), (1810, 1), (1820, 0), (1830, 0), (1840, 0), (1850, 0), (1860, 1), (1870, 1), (1880, 1), (1890, 1), (1900, 1), (1910, 0), (1920, 0), (1930, 0), (1940, 1), (1950, 1), (1960, 1), (1970, 1), (1980, 0), (1990, 0), (2000, 0), (2010, 0), (2020, 1), (2030, 1), (2040, 1), (2050, 1)]
Vdin1_4  din1_4  0 PWL (0n 0.0v 9.495n 0.0v 9.505n 0.0v 19.495n 0.0v 19.505n 3.3v 29.495n 3.3v 29.505n 0.0v 39.495n 0.0v 39.505n 0.0v 49.495n 0.0v 49.505n 0.0v 59.495n 0.0v 59.505n 0.0v 69.495n 0.0v 69.505n 3.3v 79.495n 3.3v 79.505n 0.0v 89.495n 0.0v 89.505n 0.0v 99.495n 0.0v 99.505n 0.0v 109.495n 0.0v 109.505n 0.0v 119.495n 0.0v 119.505n 3.3v 129.495n 3.3v 129.505n 3.3v 139.495n 3.3v 139.505n 3.3v 149.495n 3.3v 149.505n 3.3v 159.495n 3.3v 159.505n 3.3v 169.495n 3.3v 169.505n 0.0v 179.495n 0.0v 179.505n 0.0v 189.495n 0.0v 189.505n 0.0v 199.495n 0.0v 199.505n 0.0v 209.495n 0.0v 209.505n 0.0v 219.495n 0.0v 219.505n 0.0v 229.495n 0.0v 229.505n 0.0v 239.495n 0.0v 239.505n 3.3v 249.495n 3.3v 249.505n 3.3v 259.495n 3.3v 259.505n 3.3v 269.495n 3.3v 269.505n 3.3v 279.495n 3.3v 279.505n 3.3v 289.495n 3.3v 289.505n 3.3v 299.495n 3.3v 299.505n 3.3v 309.495n 3.3v 309.505n 3.3v 319.495n 3.3v 319.505n 3.3v 329.495n 3.3v 329.505n 3.3v 339.495n 3.3v 339.505n 3.3v 349.495n 3.3v 349.505n 3.3v 359.495n 3.3v 359.505n 3.3v 369.495n 3.3v 369.505n 0.0v 379.495n 0.0v 379.505n 0.0v 389.495n 0.0v 389.505n 0.0v 399.495n 0.0v 399.505n 3.3v 409.495n 3.3v 409.505n 3.3v 419.495n 3.3v 419.505n 3.3v 429.495n 3.3v 429.505n 3.3v 439.495n 3.3v 439.505n 3.3v 449.495n 3.3v 449.505n 3.3v 459.495n 3.3v 459.505n 3.3v 469.495n 3.3v 469.505n 3.3v 479.495n 3.3v 479.505n 3.3v 489.495n 3.3v 489.505n 3.3v 499.495n 3.3v 499.505n 0.0v 509.495n 0.0v 509.505n 0.0v 519.495n 0.0v 519.505n 0.0v 529.495n 0.0v 529.505n 0.0v 539.495n 0.0v 539.505n 0.0v 549.495n 0.0v 549.505n 0.0v 559.495n 0.0v 559.505n 0.0v 569.495n 0.0v 569.505n 0.0v 579.495n 0.0v 579.505n 0.0v 589.495n 0.0v 589.505n 0.0v 599.495n 0.0v 599.505n 0.0v 609.495n 0.0v 609.505n 0.0v 619.495n 0.0v 619.505n 0.0v 629.495n 0.0v 629.505n 0.0v 639.495n 0.0v 639.505n 0.0v 649.495n 0.0v 649.505n 0.0v 659.495n 0.0v 659.505n 3.3v 669.495n 3.3v 669.505n 3.3v 679.495n 3.3v 679.505n 0.0v 689.495n 0.0v 689.505n 0.0v 699.495n 0.0v 699.505n 0.0v 709.495n 0.0v 709.505n 3.3v 719.495n 3.3v 719.505n 0.0v 729.495n 0.0v 729.505n 0.0v 739.495n 0.0v 739.505n 0.0v 749.495n 0.0v 749.505n 0.0v 759.495n 0.0v 759.505n 0.0v 769.495n 0.0v 769.505n 0.0v 779.495n 0.0v 779.505n 0.0v 789.495n 0.0v 789.505n 0.0v 799.495n 0.0v 799.505n 0.0v 809.495n 0.0v 809.505n 0.0v 819.495n 0.0v 819.505n 0.0v 829.495n 0.0v 829.505n 0.0v 839.495n 0.0v 839.505n 0.0v 849.495n 0.0v 849.505n 0.0v 859.495n 0.0v 859.505n 0.0v 869.495n 0.0v 869.505n 0.0v 879.495n 0.0v 879.505n 0.0v 889.495n 0.0v 889.505n 0.0v 899.495n 0.0v 899.505n 0.0v 909.495n 0.0v 909.505n 0.0v 919.495n 0.0v 919.505n 0.0v 929.495n 0.0v 929.505n 0.0v 939.495n 0.0v 939.505n 0.0v 949.495n 0.0v 949.505n 0.0v 959.495n 0.0v 959.505n 0.0v 969.495n 0.0v 969.505n 0.0v 979.495n 0.0v 979.505n 0.0v 989.495n 0.0v 989.505n 0.0v 999.495n 0.0v 999.505n 0.0v 1009.495n 0.0v 1009.505n 0.0v 1019.495n 0.0v 1019.505n 0.0v 1029.495n 0.0v 1029.505n 0.0v 1039.495n 0.0v 1039.505n 3.3v 1049.495n 3.3v 1049.505n 3.3v 1059.495n 3.3v 1059.505n 3.3v 1069.495n 3.3v 1069.505n 3.3v 1079.495n 3.3v 1079.505n 3.3v 1089.495n 3.3v 1089.505n 3.3v 1099.495n 3.3v 1099.505n 0.0v 1109.495n 0.0v 1109.505n 0.0v 1119.495n 0.0v 1119.505n 0.0v 1129.495n 0.0v 1129.505n 0.0v 1139.495n 0.0v 1139.505n 3.3v 1149.495n 3.3v 1149.505n 3.3v 1159.495n 3.3v 1159.505n 3.3v 1169.495n 3.3v 1169.505n 3.3v 1179.495n 3.3v 1179.505n 3.3v 1189.495n 3.3v 1189.505n 3.3v 1199.495n 3.3v 1199.505n 3.3v 1209.495n 3.3v 1209.505n 3.3v 1219.495n 3.3v 1219.505n 3.3v 1229.495n 3.3v 1229.505n 3.3v 1239.495n 3.3v 1239.505n 3.3v 1249.495n 3.3v 1249.505n 3.3v 1259.495n 3.3v 1259.505n 3.3v 1269.495n 3.3v 1269.505n 3.3v 1279.495n 3.3v 1279.505n 3.3v 1289.495n 3.3v 1289.505n 3.3v 1299.495n 3.3v 1299.505n 3.3v 1309.495n 3.3v 1309.505n 0.0v 1319.495n 0.0v 1319.505n 0.0v 1329.495n 0.0v 1329.505n 0.0v 1339.495n 0.0v 1339.505n 0.0v 1349.495n 0.0v 1349.505n 0.0v 1359.495n 0.0v 1359.505n 0.0v 1369.495n 0.0v 1369.505n 0.0v 1379.495n 0.0v 1379.505n 0.0v 1389.495n 0.0v 1389.505n 0.0v 1399.495n 0.0v 1399.505n 0.0v 1409.495n 0.0v 1409.505n 0.0v 1419.495n 0.0v 1419.505n 0.0v 1429.495n 0.0v 1429.505n 0.0v 1439.495n 0.0v 1439.505n 0.0v 1449.495n 0.0v 1449.505n 0.0v 1459.495n 0.0v 1459.505n 0.0v 1469.495n 0.0v 1469.505n 0.0v 1479.495n 0.0v 1479.505n 0.0v 1489.495n 0.0v 1489.505n 0.0v 1499.495n 0.0v 1499.505n 0.0v 1509.495n 0.0v 1509.505n 0.0v 1519.495n 0.0v 1519.505n 0.0v 1529.495n 0.0v 1529.505n 0.0v 1539.495n 0.0v 1539.505n 0.0v 1549.495n 0.0v 1549.505n 3.3v 1559.495n 3.3v 1559.505n 0.0v 1569.495n 0.0v 1569.505n 0.0v 1579.495n 0.0v 1579.505n 0.0v 1589.495n 0.0v 1589.505n 0.0v 1599.495n 0.0v 1599.505n 3.3v 1609.495n 3.3v 1609.505n 3.3v 1619.495n 3.3v 1619.505n 3.3v 1629.495n 3.3v 1629.505n 3.3v 1639.495n 3.3v 1639.505n 3.3v 1649.495n 3.3v 1649.505n 3.3v 1659.495n 3.3v 1659.505n 3.3v 1669.495n 3.3v 1669.505n 3.3v 1679.495n 3.3v 1679.505n 3.3v 1689.495n 3.3v 1689.505n 3.3v 1699.495n 3.3v 1699.505n 3.3v 1709.495n 3.3v 1709.505n 3.3v 1719.495n 3.3v 1719.505n 3.3v 1729.495n 3.3v 1729.505n 0.0v 1739.495n 0.0v 1739.505n 0.0v 1749.495n 0.0v 1749.505n 0.0v 1759.495n 0.0v 1759.505n 0.0v 1769.495n 0.0v 1769.505n 3.3v 1779.495n 3.3v 1779.505n 3.3v 1789.495n 3.3v 1789.505n 3.3v 1799.495n 3.3v 1799.505n 3.3v 1809.495n 3.3v 1809.505n 3.3v 1819.495n 3.3v 1819.505n 0.0v 1829.495n 0.0v 1829.505n 0.0v 1839.495n 0.0v 1839.505n 0.0v 1849.495n 0.0v 1849.505n 0.0v 1859.495n 0.0v 1859.505n 3.3v 1869.495n 3.3v 1869.505n 3.3v 1879.495n 3.3v 1879.505n 3.3v 1889.495n 3.3v 1889.505n 3.3v 1899.495n 3.3v 1899.505n 3.3v 1909.495n 3.3v 1909.505n 0.0v 1919.495n 0.0v 1919.505n 0.0v 1929.495n 0.0v 1929.505n 0.0v 1939.495n 0.0v 1939.505n 3.3v 1949.495n 3.3v 1949.505n 3.3v 1959.495n 3.3v 1959.505n 3.3v 1969.495n 3.3v 1969.505n 3.3v 1979.495n 3.3v 1979.505n 0.0v 1989.495n 0.0v 1989.505n 0.0v 1999.495n 0.0v 1999.505n 0.0v 2009.495n 0.0v 2009.505n 0.0v 2019.495n 0.0v 2019.505n 3.3v 2029.495n 3.3v 2029.505n 3.3v 2039.495n 3.3v 2039.505n 3.3v 2049.495n 3.3v 2049.505n 3.3v )
* (time, data): [(0, 0), (10, 1), (20, 0), (30, 0), (40, 0), (50, 0), (60, 0), (70, 0), (80, 1), (90, 1), (100, 1), (110, 1), (120, 0), (130, 0), (140, 0), (150, 0), (160, 0), (170, 1), (180, 1), (190, 1), (200, 1), (210, 1), (220, 1), (230, 1), (240, 0), (250, 0), (260, 0), (270, 0), (280, 0), (290, 0), (300, 0), (310, 0), (320, 0), (330, 0), (340, 0), (350, 0), (360, 0), (370, 0), (380, 0), (390, 0), (400, 0), (410, 0), (420, 0), (430, 0), (440, 0), (450, 0), (460, 0), (470, 0), (480, 0), (490, 0), (500, 1), (510, 1), (520, 1), (530, 1), (540, 1), (550, 1), (560, 1), (570, 1), (580, 1), (590, 1), (600, 1), (610, 1), (620, 1), (630, 1), (640, 1), (650, 1), (660, 1), (670, 1), (680, 0), (690, 0), (700, 0), (710, 0), (720, 0), (730, 0), (740, 0), (750, 0), (760, 0), (770, 0), (780, 0), (790, 0), (800, 0), (810, 0), (820, 0), (830, 0), (840, 0), (850, 0), (860, 0), (870, 1), (880, 1), (890, 1), (900, 1), (910, 1), (920, 1), (930, 1), (940, 1), (950, 0), (960, 0), (970, 0), (980, 0), (990, 0), (1000, 0), (1010, 0), (1020, 0), (1030, 0), (1040, 0), (1050, 0), (1060, 0), (1070, 0), (1080, 0), (1090, 0), (1100, 1), (1110, 0), (1120, 0), (1130, 0), (1140, 1), (1150, 1), (1160, 1), (1170, 1), (1180, 1), (1190, 1), (1200, 1), (1210, 1), (1220, 1), (1230, 1), (1240, 1), (1250, 0), (1260, 0), (1270, 0), (1280, 0), (1290, 0), (1300, 0), (1310, 0), (1320, 0), (1330, 0), (1340, 0), (1350, 0), (1360, 0), (1370, 0), (1380, 0), (1390, 0), (1400, 0), (1410, 0), (1420, 0), (1430, 0), (1440, 0), (1450, 0), (1460, 0), (1470, 0), (1480, 0), (1490, 0), (1500, 0), (1510, 0), (1520, 0), (1530, 0), (1540, 0), (1550, 1), (1560, 0), (1570, 0), (1580, 0), (1590, 0), (1600, 1), (1610, 1), (1620, 1), (1630, 1), (1640, 1), (1650, 1), (1660, 1), (1670, 1), (1680, 1), (1690, 1), (1700, 1), (1710, 1), (1720, 1), (1730, 1), (1740, 1), (1750, 1), (1760, 1), (1770, 1), (1780, 1), (1790, 1), (1800, 1), (1810, 1), (1820, 0), (1830, 0), (1840, 0), (1850, 0), (1860, 1), (1870, 1), (1880, 1), (1890, 1), (1900, 1), (1910, 1), (1920, 1), (1930, 1), (1940, 1), (1950, 1), (1960, 1), (1970, 1), (1980, 1), (1990, 1), (2000, 0), (2010, 0), (2020, 0), (2030, 1), (2040, 1), (2050, 1)]
Vdin1_5  din1_5  0 PWL (0n 0.0v 9.495n 0.0v 9.505n 3.3v 19.495n 3.3v 19.505n 0.0v 29.495n 0.0v 29.505n 0.0v 39.495n 0.0v 39.505n 0.0v 49.495n 0.0v 49.505n 0.0v 59.495n 0.0v 59.505n 0.0v 69.495n 0.0v 69.505n 0.0v 79.495n 0.0v 79.505n 3.3v 89.495n 3.3v 89.505n 3.3v 99.495n 3.3v 99.505n 3.3v 109.495n 3.3v 109.505n 3.3v 119.495n 3.3v 119.505n 0.0v 129.495n 0.0v 129.505n 0.0v 139.495n 0.0v 139.505n 0.0v 149.495n 0.0v 149.505n 0.0v 159.495n 0.0v 159.505n 0.0v 169.495n 0.0v 169.505n 3.3v 179.495n 3.3v 179.505n 3.3v 189.495n 3.3v 189.505n 3.3v 199.495n 3.3v 199.505n 3.3v 209.495n 3.3v 209.505n 3.3v 219.495n 3.3v 219.505n 3.3v 229.495n 3.3v 229.505n 3.3v 239.495n 3.3v 239.505n 0.0v 249.495n 0.0v 249.505n 0.0v 259.495n 0.0v 259.505n 0.0v 269.495n 0.0v 269.505n 0.0v 279.495n 0.0v 279.505n 0.0v 289.495n 0.0v 289.505n 0.0v 299.495n 0.0v 299.505n 0.0v 309.495n 0.0v 309.505n 0.0v 319.495n 0.0v 319.505n 0.0v 329.495n 0.0v 329.505n 0.0v 339.495n 0.0v 339.505n 0.0v 349.495n 0.0v 349.505n 0.0v 359.495n 0.0v 359.505n 0.0v 369.495n 0.0v 369.505n 0.0v 379.495n 0.0v 379.505n 0.0v 389.495n 0.0v 389.505n 0.0v 399.495n 0.0v 399.505n 0.0v 409.495n 0.0v 409.505n 0.0v 419.495n 0.0v 419.505n 0.0v 429.495n 0.0v 429.505n 0.0v 439.495n 0.0v 439.505n 0.0v 449.495n 0.0v 449.505n 0.0v 459.495n 0.0v 459.505n 0.0v 469.495n 0.0v 469.505n 0.0v 479.495n 0.0v 479.505n 0.0v 489.495n 0.0v 489.505n 0.0v 499.495n 0.0v 499.505n 3.3v 509.495n 3.3v 509.505n 3.3v 519.495n 3.3v 519.505n 3.3v 529.495n 3.3v 529.505n 3.3v 539.495n 3.3v 539.505n 3.3v 549.495n 3.3v 549.505n 3.3v 559.495n 3.3v 559.505n 3.3v 569.495n 3.3v 569.505n 3.3v 579.495n 3.3v 579.505n 3.3v 589.495n 3.3v 589.505n 3.3v 599.495n 3.3v 599.505n 3.3v 609.495n 3.3v 609.505n 3.3v 619.495n 3.3v 619.505n 3.3v 629.495n 3.3v 629.505n 3.3v 639.495n 3.3v 639.505n 3.3v 649.495n 3.3v 649.505n 3.3v 659.495n 3.3v 659.505n 3.3v 669.495n 3.3v 669.505n 3.3v 679.495n 3.3v 679.505n 0.0v 689.495n 0.0v 689.505n 0.0v 699.495n 0.0v 699.505n 0.0v 709.495n 0.0v 709.505n 0.0v 719.495n 0.0v 719.505n 0.0v 729.495n 0.0v 729.505n 0.0v 739.495n 0.0v 739.505n 0.0v 749.495n 0.0v 749.505n 0.0v 759.495n 0.0v 759.505n 0.0v 769.495n 0.0v 769.505n 0.0v 779.495n 0.0v 779.505n 0.0v 789.495n 0.0v 789.505n 0.0v 799.495n 0.0v 799.505n 0.0v 809.495n 0.0v 809.505n 0.0v 819.495n 0.0v 819.505n 0.0v 829.495n 0.0v 829.505n 0.0v 839.495n 0.0v 839.505n 0.0v 849.495n 0.0v 849.505n 0.0v 859.495n 0.0v 859.505n 0.0v 869.495n 0.0v 869.505n 3.3v 879.495n 3.3v 879.505n 3.3v 889.495n 3.3v 889.505n 3.3v 899.495n 3.3v 899.505n 3.3v 909.495n 3.3v 909.505n 3.3v 919.495n 3.3v 919.505n 3.3v 929.495n 3.3v 929.505n 3.3v 939.495n 3.3v 939.505n 3.3v 949.495n 3.3v 949.505n 0.0v 959.495n 0.0v 959.505n 0.0v 969.495n 0.0v 969.505n 0.0v 979.495n 0.0v 979.505n 0.0v 989.495n 0.0v 989.505n 0.0v 999.495n 0.0v 999.505n 0.0v 1009.495n 0.0v 1009.505n 0.0v 1019.495n 0.0v 1019.505n 0.0v 1029.495n 0.0v 1029.505n 0.0v 1039.495n 0.0v 1039.505n 0.0v 1049.495n 0.0v 1049.505n 0.0v 1059.495n 0.0v 1059.505n 0.0v 1069.495n 0.0v 1069.505n 0.0v 1079.495n 0.0v 1079.505n 0.0v 1089.495n 0.0v 1089.505n 0.0v 1099.495n 0.0v 1099.505n 3.3v 1109.495n 3.3v 1109.505n 0.0v 1119.495n 0.0v 1119.505n 0.0v 1129.495n 0.0v 1129.505n 0.0v 1139.495n 0.0v 1139.505n 3.3v 1149.495n 3.3v 1149.505n 3.3v 1159.495n 3.3v 1159.505n 3.3v 1169.495n 3.3v 1169.505n 3.3v 1179.495n 3.3v 1179.505n 3.3v 1189.495n 3.3v 1189.505n 3.3v 1199.495n 3.3v 1199.505n 3.3v 1209.495n 3.3v 1209.505n 3.3v 1219.495n 3.3v 1219.505n 3.3v 1229.495n 3.3v 1229.505n 3.3v 1239.495n 3.3v 1239.505n 3.3v 1249.495n 3.3v 1249.505n 0.0v 1259.495n 0.0v 1259.505n 0.0v 1269.495n 0.0v 1269.505n 0.0v 1279.495n 0.0v 1279.505n 0.0v 1289.495n 0.0v 1289.505n 0.0v 1299.495n 0.0v 1299.505n 0.0v 1309.495n 0.0v 1309.505n 0.0v 1319.495n 0.0v 1319.505n 0.0v 1329.495n 0.0v 1329.505n 0.0v 1339.495n 0.0v 1339.505n 0.0v 1349.495n 0.0v 1349.505n 0.0v 1359.495n 0.0v 1359.505n 0.0v 1369.495n 0.0v 1369.505n 0.0v 1379.495n 0.0v 1379.505n 0.0v 1389.495n 0.0v 1389.505n 0.0v 1399.495n 0.0v 1399.505n 0.0v 1409.495n 0.0v 1409.505n 0.0v 1419.495n 0.0v 1419.505n 0.0v 1429.495n 0.0v 1429.505n 0.0v 1439.495n 0.0v 1439.505n 0.0v 1449.495n 0.0v 1449.505n 0.0v 1459.495n 0.0v 1459.505n 0.0v 1469.495n 0.0v 1469.505n 0.0v 1479.495n 0.0v 1479.505n 0.0v 1489.495n 0.0v 1489.505n 0.0v 1499.495n 0.0v 1499.505n 0.0v 1509.495n 0.0v 1509.505n 0.0v 1519.495n 0.0v 1519.505n 0.0v 1529.495n 0.0v 1529.505n 0.0v 1539.495n 0.0v 1539.505n 0.0v 1549.495n 0.0v 1549.505n 3.3v 1559.495n 3.3v 1559.505n 0.0v 1569.495n 0.0v 1569.505n 0.0v 1579.495n 0.0v 1579.505n 0.0v 1589.495n 0.0v 1589.505n 0.0v 1599.495n 0.0v 1599.505n 3.3v 1609.495n 3.3v 1609.505n 3.3v 1619.495n 3.3v 1619.505n 3.3v 1629.495n 3.3v 1629.505n 3.3v 1639.495n 3.3v 1639.505n 3.3v 1649.495n 3.3v 1649.505n 3.3v 1659.495n 3.3v 1659.505n 3.3v 1669.495n 3.3v 1669.505n 3.3v 1679.495n 3.3v 1679.505n 3.3v 1689.495n 3.3v 1689.505n 3.3v 1699.495n 3.3v 1699.505n 3.3v 1709.495n 3.3v 1709.505n 3.3v 1719.495n 3.3v 1719.505n 3.3v 1729.495n 3.3v 1729.505n 3.3v 1739.495n 3.3v 1739.505n 3.3v 1749.495n 3.3v 1749.505n 3.3v 1759.495n 3.3v 1759.505n 3.3v 1769.495n 3.3v 1769.505n 3.3v 1779.495n 3.3v 1779.505n 3.3v 1789.495n 3.3v 1789.505n 3.3v 1799.495n 3.3v 1799.505n 3.3v 1809.495n 3.3v 1809.505n 3.3v 1819.495n 3.3v 1819.505n 0.0v 1829.495n 0.0v 1829.505n 0.0v 1839.495n 0.0v 1839.505n 0.0v 1849.495n 0.0v 1849.505n 0.0v 1859.495n 0.0v 1859.505n 3.3v 1869.495n 3.3v 1869.505n 3.3v 1879.495n 3.3v 1879.505n 3.3v 1889.495n 3.3v 1889.505n 3.3v 1899.495n 3.3v 1899.505n 3.3v 1909.495n 3.3v 1909.505n 3.3v 1919.495n 3.3v 1919.505n 3.3v 1929.495n 3.3v 1929.505n 3.3v 1939.495n 3.3v 1939.505n 3.3v 1949.495n 3.3v 1949.505n 3.3v 1959.495n 3.3v 1959.505n 3.3v 1969.495n 3.3v 1969.505n 3.3v 1979.495n 3.3v 1979.505n 3.3v 1989.495n 3.3v 1989.505n 3.3v 1999.495n 3.3v 1999.505n 0.0v 2009.495n 0.0v 2009.505n 0.0v 2019.495n 0.0v 2019.505n 0.0v 2029.495n 0.0v 2029.505n 3.3v 2039.495n 3.3v 2039.505n 3.3v 2049.495n 3.3v 2049.505n 3.3v )
* (time, data): [(0, 0), (10, 1), (20, 1), (30, 1), (40, 1), (50, 1), (60, 1), (70, 0), (80, 1), (90, 1), (100, 1), (110, 1), (120, 1), (130, 1), (140, 0), (150, 0), (160, 0), (170, 1), (180, 1), (190, 1), (200, 1), (210, 1), (220, 1), (230, 1), (240, 0), (250, 0), (260, 0), (270, 0), (280, 0), (290, 0), (300, 0), (310, 0), (320, 0), (330, 0), (340, 0), (350, 0), (360, 0), (370, 0), (380, 1), (390, 1), (400, 0), (410, 0), (420, 0), (430, 0), (440, 0), (450, 0), (460, 0), (470, 0), (480, 0), (490, 0), (500, 0), (510, 0), (520, 0), (530, 0), (540, 0), (550, 0), (560, 0), (570, 0), (580, 0), (590, 0), (600, 0), (610, 0), (620, 0), (630, 0), (640, 0), (650, 0), (660, 1), (670, 1), (680, 1), (690, 1), (700, 1), (710, 0), (720, 1), (730, 1), (740, 1), (750, 1), (760, 1), (770, 1), (780, 1), (790, 1), (800, 1), (810, 1), (820, 1), (830, 1), (840, 1), (850, 1), (860, 1), (870, 0), (880, 0), (890, 0), (900, 0), (910, 0), (920, 0), (930, 0), (940, 0), (950, 0), (960, 0), (970, 0), (980, 0), (990, 0), (1000, 0), (1010, 0), (1020, 0), (1030, 0), (1040, 0), (1050, 0), (1060, 0), (1070, 0), (1080, 0), (1090, 0), (1100, 0), (1110, 0), (1120, 0), (1130, 0), (1140, 1), (1150, 1), (1160, 1), (1170, 1), (1180, 1), (1190, 1), (1200, 1), (1210, 0), (1220, 0), (1230, 0), (1240, 0), (1250, 1), (1260, 1), (1270, 1), (1280, 1), (1290, 1), (1300, 1), (1310, 1), (1320, 1), (1330, 1), (1340, 1), (1350, 1), (1360, 1), (1370, 1), (1380, 1), (1390, 1), (1400, 1), (1410, 1), (1420, 1), (1430, 1), (1440, 1), (1450, 1), (1460, 1), (1470, 1), (1480, 1), (1490, 1), (1500, 1), (1510, 1), (1520, 1), (1530, 1), (1540, 1), (1550, 0), (1560, 1), (1570, 1), (1580, 1), (1590, 1), (1600, 1), (1610, 1), (1620, 1), (1630, 1), (1640, 1), (1650, 1), (1660, 1), (1670, 1), (1680, 1), (1690, 1), (1700, 1), (1710, 1), (1720, 1), (1730, 0), (1740, 0), (1750, 1), (1760, 1), (1770, 1), (1780, 1), (1790, 1), (1800, 1), (1810, 1), (1820, 1), (1830, 1), (1840, 1), (1850, 1), (1860, 0), (1870, 0), (1880, 1), (1890, 1), (1900, 1), (1910, 0), (1920, 0), (1930, 0), (1940, 0), (1950, 0), (1960, 0), (1970, 0), (1980, 1), (1990, 1), (2000, 1), (2010, 1), (2020, 0), (2030, 1), (2040, 1), (2050, 1)]
Vdin1_6  din1_6  0 PWL (0n 0.0v 9.495n 0.0v 9.505n 3.3v 19.495n 3.3v 19.505n 3.3v 29.495n 3.3v 29.505n 3.3v 39.495n 3.3v 39.505n 3.3v 49.495n 3.3v 49.505n 3.3v 59.495n 3.3v 59.505n 3.3v 69.495n 3.3v 69.505n 0.0v 79.495n 0.0v 79.505n 3.3v 89.495n 3.3v 89.505n 3.3v 99.495n 3.3v 99.505n 3.3v 109.495n 3.3v 109.505n 3.3v 119.495n 3.3v 119.505n 3.3v 129.495n 3.3v 129.505n 3.3v 139.495n 3.3v 139.505n 0.0v 149.495n 0.0v 149.505n 0.0v 159.495n 0.0v 159.505n 0.0v 169.495n 0.0v 169.505n 3.3v 179.495n 3.3v 179.505n 3.3v 189.495n 3.3v 189.505n 3.3v 199.495n 3.3v 199.505n 3.3v 209.495n 3.3v 209.505n 3.3v 219.495n 3.3v 219.505n 3.3v 229.495n 3.3v 229.505n 3.3v 239.495n 3.3v 239.505n 0.0v 249.495n 0.0v 249.505n 0.0v 259.495n 0.0v 259.505n 0.0v 269.495n 0.0v 269.505n 0.0v 279.495n 0.0v 279.505n 0.0v 289.495n 0.0v 289.505n 0.0v 299.495n 0.0v 299.505n 0.0v 309.495n 0.0v 309.505n 0.0v 319.495n 0.0v 319.505n 0.0v 329.495n 0.0v 329.505n 0.0v 339.495n 0.0v 339.505n 0.0v 349.495n 0.0v 349.505n 0.0v 359.495n 0.0v 359.505n 0.0v 369.495n 0.0v 369.505n 0.0v 379.495n 0.0v 379.505n 3.3v 389.495n 3.3v 389.505n 3.3v 399.495n 3.3v 399.505n 0.0v 409.495n 0.0v 409.505n 0.0v 419.495n 0.0v 419.505n 0.0v 429.495n 0.0v 429.505n 0.0v 439.495n 0.0v 439.505n 0.0v 449.495n 0.0v 449.505n 0.0v 459.495n 0.0v 459.505n 0.0v 469.495n 0.0v 469.505n 0.0v 479.495n 0.0v 479.505n 0.0v 489.495n 0.0v 489.505n 0.0v 499.495n 0.0v 499.505n 0.0v 509.495n 0.0v 509.505n 0.0v 519.495n 0.0v 519.505n 0.0v 529.495n 0.0v 529.505n 0.0v 539.495n 0.0v 539.505n 0.0v 549.495n 0.0v 549.505n 0.0v 559.495n 0.0v 559.505n 0.0v 569.495n 0.0v 569.505n 0.0v 579.495n 0.0v 579.505n 0.0v 589.495n 0.0v 589.505n 0.0v 599.495n 0.0v 599.505n 0.0v 609.495n 0.0v 609.505n 0.0v 619.495n 0.0v 619.505n 0.0v 629.495n 0.0v 629.505n 0.0v 639.495n 0.0v 639.505n 0.0v 649.495n 0.0v 649.505n 0.0v 659.495n 0.0v 659.505n 3.3v 669.495n 3.3v 669.505n 3.3v 679.495n 3.3v 679.505n 3.3v 689.495n 3.3v 689.505n 3.3v 699.495n 3.3v 699.505n 3.3v 709.495n 3.3v 709.505n 0.0v 719.495n 0.0v 719.505n 3.3v 729.495n 3.3v 729.505n 3.3v 739.495n 3.3v 739.505n 3.3v 749.495n 3.3v 749.505n 3.3v 759.495n 3.3v 759.505n 3.3v 769.495n 3.3v 769.505n 3.3v 779.495n 3.3v 779.505n 3.3v 789.495n 3.3v 789.505n 3.3v 799.495n 3.3v 799.505n 3.3v 809.495n 3.3v 809.505n 3.3v 819.495n 3.3v 819.505n 3.3v 829.495n 3.3v 829.505n 3.3v 839.495n 3.3v 839.505n 3.3v 849.495n 3.3v 849.505n 3.3v 859.495n 3.3v 859.505n 3.3v 869.495n 3.3v 869.505n 0.0v 879.495n 0.0v 879.505n 0.0v 889.495n 0.0v 889.505n 0.0v 899.495n 0.0v 899.505n 0.0v 909.495n 0.0v 909.505n 0.0v 919.495n 0.0v 919.505n 0.0v 929.495n 0.0v 929.505n 0.0v 939.495n 0.0v 939.505n 0.0v 949.495n 0.0v 949.505n 0.0v 959.495n 0.0v 959.505n 0.0v 969.495n 0.0v 969.505n 0.0v 979.495n 0.0v 979.505n 0.0v 989.495n 0.0v 989.505n 0.0v 999.495n 0.0v 999.505n 0.0v 1009.495n 0.0v 1009.505n 0.0v 1019.495n 0.0v 1019.505n 0.0v 1029.495n 0.0v 1029.505n 0.0v 1039.495n 0.0v 1039.505n 0.0v 1049.495n 0.0v 1049.505n 0.0v 1059.495n 0.0v 1059.505n 0.0v 1069.495n 0.0v 1069.505n 0.0v 1079.495n 0.0v 1079.505n 0.0v 1089.495n 0.0v 1089.505n 0.0v 1099.495n 0.0v 1099.505n 0.0v 1109.495n 0.0v 1109.505n 0.0v 1119.495n 0.0v 1119.505n 0.0v 1129.495n 0.0v 1129.505n 0.0v 1139.495n 0.0v 1139.505n 3.3v 1149.495n 3.3v 1149.505n 3.3v 1159.495n 3.3v 1159.505n 3.3v 1169.495n 3.3v 1169.505n 3.3v 1179.495n 3.3v 1179.505n 3.3v 1189.495n 3.3v 1189.505n 3.3v 1199.495n 3.3v 1199.505n 3.3v 1209.495n 3.3v 1209.505n 0.0v 1219.495n 0.0v 1219.505n 0.0v 1229.495n 0.0v 1229.505n 0.0v 1239.495n 0.0v 1239.505n 0.0v 1249.495n 0.0v 1249.505n 3.3v 1259.495n 3.3v 1259.505n 3.3v 1269.495n 3.3v 1269.505n 3.3v 1279.495n 3.3v 1279.505n 3.3v 1289.495n 3.3v 1289.505n 3.3v 1299.495n 3.3v 1299.505n 3.3v 1309.495n 3.3v 1309.505n 3.3v 1319.495n 3.3v 1319.505n 3.3v 1329.495n 3.3v 1329.505n 3.3v 1339.495n 3.3v 1339.505n 3.3v 1349.495n 3.3v 1349.505n 3.3v 1359.495n 3.3v 1359.505n 3.3v 1369.495n 3.3v 1369.505n 3.3v 1379.495n 3.3v 1379.505n 3.3v 1389.495n 3.3v 1389.505n 3.3v 1399.495n 3.3v 1399.505n 3.3v 1409.495n 3.3v 1409.505n 3.3v 1419.495n 3.3v 1419.505n 3.3v 1429.495n 3.3v 1429.505n 3.3v 1439.495n 3.3v 1439.505n 3.3v 1449.495n 3.3v 1449.505n 3.3v 1459.495n 3.3v 1459.505n 3.3v 1469.495n 3.3v 1469.505n 3.3v 1479.495n 3.3v 1479.505n 3.3v 1489.495n 3.3v 1489.505n 3.3v 1499.495n 3.3v 1499.505n 3.3v 1509.495n 3.3v 1509.505n 3.3v 1519.495n 3.3v 1519.505n 3.3v 1529.495n 3.3v 1529.505n 3.3v 1539.495n 3.3v 1539.505n 3.3v 1549.495n 3.3v 1549.505n 0.0v 1559.495n 0.0v 1559.505n 3.3v 1569.495n 3.3v 1569.505n 3.3v 1579.495n 3.3v 1579.505n 3.3v 1589.495n 3.3v 1589.505n 3.3v 1599.495n 3.3v 1599.505n 3.3v 1609.495n 3.3v 1609.505n 3.3v 1619.495n 3.3v 1619.505n 3.3v 1629.495n 3.3v 1629.505n 3.3v 1639.495n 3.3v 1639.505n 3.3v 1649.495n 3.3v 1649.505n 3.3v 1659.495n 3.3v 1659.505n 3.3v 1669.495n 3.3v 1669.505n 3.3v 1679.495n 3.3v 1679.505n 3.3v 1689.495n 3.3v 1689.505n 3.3v 1699.495n 3.3v 1699.505n 3.3v 1709.495n 3.3v 1709.505n 3.3v 1719.495n 3.3v 1719.505n 3.3v 1729.495n 3.3v 1729.505n 0.0v 1739.495n 0.0v 1739.505n 0.0v 1749.495n 0.0v 1749.505n 3.3v 1759.495n 3.3v 1759.505n 3.3v 1769.495n 3.3v 1769.505n 3.3v 1779.495n 3.3v 1779.505n 3.3v 1789.495n 3.3v 1789.505n 3.3v 1799.495n 3.3v 1799.505n 3.3v 1809.495n 3.3v 1809.505n 3.3v 1819.495n 3.3v 1819.505n 3.3v 1829.495n 3.3v 1829.505n 3.3v 1839.495n 3.3v 1839.505n 3.3v 1849.495n 3.3v 1849.505n 3.3v 1859.495n 3.3v 1859.505n 0.0v 1869.495n 0.0v 1869.505n 0.0v 1879.495n 0.0v 1879.505n 3.3v 1889.495n 3.3v 1889.505n 3.3v 1899.495n 3.3v 1899.505n 3.3v 1909.495n 3.3v 1909.505n 0.0v 1919.495n 0.0v 1919.505n 0.0v 1929.495n 0.0v 1929.505n 0.0v 1939.495n 0.0v 1939.505n 0.0v 1949.495n 0.0v 1949.505n 0.0v 1959.495n 0.0v 1959.505n 0.0v 1969.495n 0.0v 1969.505n 0.0v 1979.495n 0.0v 1979.505n 3.3v 1989.495n 3.3v 1989.505n 3.3v 1999.495n 3.3v 1999.505n 3.3v 2009.495n 3.3v 2009.505n 3.3v 2019.495n 3.3v 2019.505n 0.0v 2029.495n 0.0v 2029.505n 3.3v 2039.495n 3.3v 2039.505n 3.3v 2049.495n 3.3v 2049.505n 3.3v )
* (time, data): [(0, 0), (10, 0), (20, 0), (30, 0), (40, 0), (50, 0), (60, 0), (70, 0), (80, 1), (90, 1), (100, 1), (110, 1), (120, 1), (130, 1), (140, 1), (150, 1), (160, 1), (170, 0), (180, 0), (190, 0), (200, 0), (210, 0), (220, 0), (230, 0), (240, 0), (250, 0), (260, 0), (270, 0), (280, 0), (290, 0), (300, 0), (310, 0), (320, 0), (330, 0), (340, 0), (350, 0), (360, 0), (370, 0), (380, 1), (390, 1), (400, 0), (410, 0), (420, 0), (430, 0), (440, 0), (450, 0), (460, 0), (470, 0), (480, 0), (490, 0), (500, 0), (510, 0), (520, 0), (530, 0), (540, 0), (550, 0), (560, 0), (570, 0), (580, 0), (590, 0), (600, 0), (610, 0), (620, 0), (630, 0), (640, 0), (650, 0), (660, 1), (670, 1), (680, 0), (690, 0), (700, 0), (710, 0), (720, 1), (730, 1), (740, 1), (750, 1), (760, 1), (770, 1), (780, 1), (790, 1), (800, 1), (810, 1), (820, 1), (830, 1), (840, 1), (850, 1), (860, 0), (870, 0), (880, 0), (890, 0), (900, 0), (910, 0), (920, 0), (930, 0), (940, 1), (950, 0), (960, 0), (970, 0), (980, 0), (990, 0), (1000, 0), (1010, 0), (1020, 0), (1030, 0), (1040, 0), (1050, 1), (1060, 1), (1070, 1), (1080, 1), (1090, 1), (1100, 1), (1110, 1), (1120, 1), (1130, 1), (1140, 1), (1150, 1), (1160, 1), (1170, 1), (1180, 1), (1190, 1), (1200, 1), (1210, 0), (1220, 0), (1230, 0), (1240, 0), (1250, 1), (1260, 1), (1270, 1), (1280, 1), (1290, 1), (1300, 1), (1310, 1), (1320, 1), (1330, 1), (1340, 1), (1350, 1), (1360, 1), (1370, 1), (1380, 1), (1390, 1), (1400, 1), (1410, 1), (1420, 1), (1430, 1), (1440, 1), (1450, 1), (1460, 1), (1470, 1), (1480, 1), (1490, 0), (1500, 0), (1510, 0), (1520, 0), (1530, 0), (1540, 0), (1550, 0), (1560, 1), (1570, 1), (1580, 1), (1590, 1), (1600, 1), (1610, 1), (1620, 1), (1630, 1), (1640, 1), (1650, 1), (1660, 1), (1670, 1), (1680, 1), (1690, 1), (1700, 1), (1710, 1), (1720, 1), (1730, 1), (1740, 1), (1750, 0), (1760, 0), (1770, 1), (1780, 1), (1790, 1), (1800, 1), (1810, 1), (1820, 1), (1830, 1), (1840, 1), (1850, 1), (1860, 0), (1870, 0), (1880, 0), (1890, 0), (1900, 0), (1910, 1), (1920, 1), (1930, 1), (1940, 1), (1950, 1), (1960, 1), (1970, 1), (1980, 0), (1990, 0), (2000, 1), (2010, 1), (2020, 1), (2030, 1), (2040, 1), (2050, 1)]
Vdin1_7  din1_7  0 PWL (0n 0.0v 9.495n 0.0v 9.505n 0.0v 19.495n 0.0v 19.505n 0.0v 29.495n 0.0v 29.505n 0.0v 39.495n 0.0v 39.505n 0.0v 49.495n 0.0v 49.505n 0.0v 59.495n 0.0v 59.505n 0.0v 69.495n 0.0v 69.505n 0.0v 79.495n 0.0v 79.505n 3.3v 89.495n 3.3v 89.505n 3.3v 99.495n 3.3v 99.505n 3.3v 109.495n 3.3v 109.505n 3.3v 119.495n 3.3v 119.505n 3.3v 129.495n 3.3v 129.505n 3.3v 139.495n 3.3v 139.505n 3.3v 149.495n 3.3v 149.505n 3.3v 159.495n 3.3v 159.505n 3.3v 169.495n 3.3v 169.505n 0.0v 179.495n 0.0v 179.505n 0.0v 189.495n 0.0v 189.505n 0.0v 199.495n 0.0v 199.505n 0.0v 209.495n 0.0v 209.505n 0.0v 219.495n 0.0v 219.505n 0.0v 229.495n 0.0v 229.505n 0.0v 239.495n 0.0v 239.505n 0.0v 249.495n 0.0v 249.505n 0.0v 259.495n 0.0v 259.505n 0.0v 269.495n 0.0v 269.505n 0.0v 279.495n 0.0v 279.505n 0.0v 289.495n 0.0v 289.505n 0.0v 299.495n 0.0v 299.505n 0.0v 309.495n 0.0v 309.505n 0.0v 319.495n 0.0v 319.505n 0.0v 329.495n 0.0v 329.505n 0.0v 339.495n 0.0v 339.505n 0.0v 349.495n 0.0v 349.505n 0.0v 359.495n 0.0v 359.505n 0.0v 369.495n 0.0v 369.505n 0.0v 379.495n 0.0v 379.505n 3.3v 389.495n 3.3v 389.505n 3.3v 399.495n 3.3v 399.505n 0.0v 409.495n 0.0v 409.505n 0.0v 419.495n 0.0v 419.505n 0.0v 429.495n 0.0v 429.505n 0.0v 439.495n 0.0v 439.505n 0.0v 449.495n 0.0v 449.505n 0.0v 459.495n 0.0v 459.505n 0.0v 469.495n 0.0v 469.505n 0.0v 479.495n 0.0v 479.505n 0.0v 489.495n 0.0v 489.505n 0.0v 499.495n 0.0v 499.505n 0.0v 509.495n 0.0v 509.505n 0.0v 519.495n 0.0v 519.505n 0.0v 529.495n 0.0v 529.505n 0.0v 539.495n 0.0v 539.505n 0.0v 549.495n 0.0v 549.505n 0.0v 559.495n 0.0v 559.505n 0.0v 569.495n 0.0v 569.505n 0.0v 579.495n 0.0v 579.505n 0.0v 589.495n 0.0v 589.505n 0.0v 599.495n 0.0v 599.505n 0.0v 609.495n 0.0v 609.505n 0.0v 619.495n 0.0v 619.505n 0.0v 629.495n 0.0v 629.505n 0.0v 639.495n 0.0v 639.505n 0.0v 649.495n 0.0v 649.505n 0.0v 659.495n 0.0v 659.505n 3.3v 669.495n 3.3v 669.505n 3.3v 679.495n 3.3v 679.505n 0.0v 689.495n 0.0v 689.505n 0.0v 699.495n 0.0v 699.505n 0.0v 709.495n 0.0v 709.505n 0.0v 719.495n 0.0v 719.505n 3.3v 729.495n 3.3v 729.505n 3.3v 739.495n 3.3v 739.505n 3.3v 749.495n 3.3v 749.505n 3.3v 759.495n 3.3v 759.505n 3.3v 769.495n 3.3v 769.505n 3.3v 779.495n 3.3v 779.505n 3.3v 789.495n 3.3v 789.505n 3.3v 799.495n 3.3v 799.505n 3.3v 809.495n 3.3v 809.505n 3.3v 819.495n 3.3v 819.505n 3.3v 829.495n 3.3v 829.505n 3.3v 839.495n 3.3v 839.505n 3.3v 849.495n 3.3v 849.505n 3.3v 859.495n 3.3v 859.505n 0.0v 869.495n 0.0v 869.505n 0.0v 879.495n 0.0v 879.505n 0.0v 889.495n 0.0v 889.505n 0.0v 899.495n 0.0v 899.505n 0.0v 909.495n 0.0v 909.505n 0.0v 919.495n 0.0v 919.505n 0.0v 929.495n 0.0v 929.505n 0.0v 939.495n 0.0v 939.505n 3.3v 949.495n 3.3v 949.505n 0.0v 959.495n 0.0v 959.505n 0.0v 969.495n 0.0v 969.505n 0.0v 979.495n 0.0v 979.505n 0.0v 989.495n 0.0v 989.505n 0.0v 999.495n 0.0v 999.505n 0.0v 1009.495n 0.0v 1009.505n 0.0v 1019.495n 0.0v 1019.505n 0.0v 1029.495n 0.0v 1029.505n 0.0v 1039.495n 0.0v 1039.505n 0.0v 1049.495n 0.0v 1049.505n 3.3v 1059.495n 3.3v 1059.505n 3.3v 1069.495n 3.3v 1069.505n 3.3v 1079.495n 3.3v 1079.505n 3.3v 1089.495n 3.3v 1089.505n 3.3v 1099.495n 3.3v 1099.505n 3.3v 1109.495n 3.3v 1109.505n 3.3v 1119.495n 3.3v 1119.505n 3.3v 1129.495n 3.3v 1129.505n 3.3v 1139.495n 3.3v 1139.505n 3.3v 1149.495n 3.3v 1149.505n 3.3v 1159.495n 3.3v 1159.505n 3.3v 1169.495n 3.3v 1169.505n 3.3v 1179.495n 3.3v 1179.505n 3.3v 1189.495n 3.3v 1189.505n 3.3v 1199.495n 3.3v 1199.505n 3.3v 1209.495n 3.3v 1209.505n 0.0v 1219.495n 0.0v 1219.505n 0.0v 1229.495n 0.0v 1229.505n 0.0v 1239.495n 0.0v 1239.505n 0.0v 1249.495n 0.0v 1249.505n 3.3v 1259.495n 3.3v 1259.505n 3.3v 1269.495n 3.3v 1269.505n 3.3v 1279.495n 3.3v 1279.505n 3.3v 1289.495n 3.3v 1289.505n 3.3v 1299.495n 3.3v 1299.505n 3.3v 1309.495n 3.3v 1309.505n 3.3v 1319.495n 3.3v 1319.505n 3.3v 1329.495n 3.3v 1329.505n 3.3v 1339.495n 3.3v 1339.505n 3.3v 1349.495n 3.3v 1349.505n 3.3v 1359.495n 3.3v 1359.505n 3.3v 1369.495n 3.3v 1369.505n 3.3v 1379.495n 3.3v 1379.505n 3.3v 1389.495n 3.3v 1389.505n 3.3v 1399.495n 3.3v 1399.505n 3.3v 1409.495n 3.3v 1409.505n 3.3v 1419.495n 3.3v 1419.505n 3.3v 1429.495n 3.3v 1429.505n 3.3v 1439.495n 3.3v 1439.505n 3.3v 1449.495n 3.3v 1449.505n 3.3v 1459.495n 3.3v 1459.505n 3.3v 1469.495n 3.3v 1469.505n 3.3v 1479.495n 3.3v 1479.505n 3.3v 1489.495n 3.3v 1489.505n 0.0v 1499.495n 0.0v 1499.505n 0.0v 1509.495n 0.0v 1509.505n 0.0v 1519.495n 0.0v 1519.505n 0.0v 1529.495n 0.0v 1529.505n 0.0v 1539.495n 0.0v 1539.505n 0.0v 1549.495n 0.0v 1549.505n 0.0v 1559.495n 0.0v 1559.505n 3.3v 1569.495n 3.3v 1569.505n 3.3v 1579.495n 3.3v 1579.505n 3.3v 1589.495n 3.3v 1589.505n 3.3v 1599.495n 3.3v 1599.505n 3.3v 1609.495n 3.3v 1609.505n 3.3v 1619.495n 3.3v 1619.505n 3.3v 1629.495n 3.3v 1629.505n 3.3v 1639.495n 3.3v 1639.505n 3.3v 1649.495n 3.3v 1649.505n 3.3v 1659.495n 3.3v 1659.505n 3.3v 1669.495n 3.3v 1669.505n 3.3v 1679.495n 3.3v 1679.505n 3.3v 1689.495n 3.3v 1689.505n 3.3v 1699.495n 3.3v 1699.505n 3.3v 1709.495n 3.3v 1709.505n 3.3v 1719.495n 3.3v 1719.505n 3.3v 1729.495n 3.3v 1729.505n 3.3v 1739.495n 3.3v 1739.505n 3.3v 1749.495n 3.3v 1749.505n 0.0v 1759.495n 0.0v 1759.505n 0.0v 1769.495n 0.0v 1769.505n 3.3v 1779.495n 3.3v 1779.505n 3.3v 1789.495n 3.3v 1789.505n 3.3v 1799.495n 3.3v 1799.505n 3.3v 1809.495n 3.3v 1809.505n 3.3v 1819.495n 3.3v 1819.505n 3.3v 1829.495n 3.3v 1829.505n 3.3v 1839.495n 3.3v 1839.505n 3.3v 1849.495n 3.3v 1849.505n 3.3v 1859.495n 3.3v 1859.505n 0.0v 1869.495n 0.0v 1869.505n 0.0v 1879.495n 0.0v 1879.505n 0.0v 1889.495n 0.0v 1889.505n 0.0v 1899.495n 0.0v 1899.505n 0.0v 1909.495n 0.0v 1909.505n 3.3v 1919.495n 3.3v 1919.505n 3.3v 1929.495n 3.3v 1929.505n 3.3v 1939.495n 3.3v 1939.505n 3.3v 1949.495n 3.3v 1949.505n 3.3v 1959.495n 3.3v 1959.505n 3.3v 1969.495n 3.3v 1969.505n 3.3v 1979.495n 3.3v 1979.505n 0.0v 1989.495n 0.0v 1989.505n 0.0v 1999.495n 0.0v 1999.505n 3.3v 2009.495n 3.3v 2009.505n 3.3v 2019.495n 3.3v 2019.505n 3.3v 2029.495n 3.3v 2029.505n 3.3v 2039.495n 3.3v 2039.505n 3.3v 2049.495n 3.3v 2049.505n 3.3v )
* (time, data): [(0, 0), (10, 0), (20, 0), (30, 0), (40, 0), (50, 0), (60, 0), (70, 1), (80, 0), (90, 0), (100, 0), (110, 0), (120, 1), (130, 1), (140, 1), (150, 1), (160, 1), (170, 1), (180, 1), (190, 1), (200, 1), (210, 1), (220, 1), (230, 1), (240, 1), (250, 1), (260, 1), (270, 1), (280, 1), (290, 1), (300, 1), (310, 1), (320, 1), (330, 1), (340, 1), (350, 1), (360, 1), (370, 0), (380, 1), (390, 1), (400, 0), (410, 0), (420, 0), (430, 0), (440, 0), (450, 0), (460, 0), (470, 0), (480, 0), (490, 0), (500, 1), (510, 1), (520, 1), (530, 1), (540, 1), (550, 1), (560, 1), (570, 1), (580, 1), (590, 1), (600, 1), (610, 1), (620, 1), (630, 1), (640, 1), (650, 1), (660, 0), (670, 0), (680, 1), (690, 1), (700, 1), (710, 0), (720, 0), (730, 0), (740, 0), (750, 0), (760, 0), (770, 0), (780, 0), (790, 0), (800, 0), (810, 0), (820, 0), (830, 0), (840, 0), (850, 0), (860, 0), (870, 1), (880, 1), (890, 1), (900, 1), (910, 1), (920, 1), (930, 1), (940, 0), (950, 1), (960, 1), (970, 1), (980, 1), (990, 1), (1000, 1), (1010, 1), (1020, 1), (1030, 1), (1040, 0), (1050, 1), (1060, 1), (1070, 1), (1080, 1), (1090, 1), (1100, 0), (1110, 0), (1120, 0), (1130, 0), (1140, 1), (1150, 1), (1160, 1), (1170, 1), (1180, 1), (1190, 1), (1200, 1), (1210, 0), (1220, 0), (1230, 0), (1240, 0), (1250, 0), (1260, 0), (1270, 0), (1280, 0), (1290, 0), (1300, 0), (1310, 0), (1320, 0), (1330, 0), (1340, 0), (1350, 0), (1360, 0), (1370, 0), (1380, 0), (1390, 0), (1400, 0), (1410, 0), (1420, 0), (1430, 0), (1440, 0), (1450, 0), (1460, 0), (1470, 0), (1480, 0), (1490, 0), (1500, 0), (1510, 0), (1520, 0), (1530, 0), (1540, 0), (1550, 1), (1560, 0), (1570, 0), (1580, 0), (1590, 0), (1600, 1), (1610, 1), (1620, 1), (1630, 1), (1640, 1), (1650, 1), (1660, 1), (1670, 1), (1680, 1), (1690, 1), (1700, 1), (1710, 1), (1720, 1), (1730, 1), (1740, 1), (1750, 1), (1760, 1), (1770, 0), (1780, 0), (1790, 0), (1800, 0), (1810, 0), (1820, 0), (1830, 0), (1840, 0), (1850, 0), (1860, 0), (1870, 0), (1880, 0), (1890, 0), (1900, 0), (1910, 0), (1920, 0), (1930, 0), (1940, 1), (1950, 1), (1960, 1), (1970, 1), (1980, 0), (1990, 0), (2000, 0), (2010, 0), (2020, 0), (2030, 0), (2040, 0), (2050, 0)]
Vdin1_8  din1_8  0 PWL (0n 0.0v 9.495n 0.0v 9.505n 0.0v 19.495n 0.0v 19.505n 0.0v 29.495n 0.0v 29.505n 0.0v 39.495n 0.0v 39.505n 0.0v 49.495n 0.0v 49.505n 0.0v 59.495n 0.0v 59.505n 0.0v 69.495n 0.0v 69.505n 3.3v 79.495n 3.3v 79.505n 0.0v 89.495n 0.0v 89.505n 0.0v 99.495n 0.0v 99.505n 0.0v 109.495n 0.0v 109.505n 0.0v 119.495n 0.0v 119.505n 3.3v 129.495n 3.3v 129.505n 3.3v 139.495n 3.3v 139.505n 3.3v 149.495n 3.3v 149.505n 3.3v 159.495n 3.3v 159.505n 3.3v 169.495n 3.3v 169.505n 3.3v 179.495n 3.3v 179.505n 3.3v 189.495n 3.3v 189.505n 3.3v 199.495n 3.3v 199.505n 3.3v 209.495n 3.3v 209.505n 3.3v 219.495n 3.3v 219.505n 3.3v 229.495n 3.3v 229.505n 3.3v 239.495n 3.3v 239.505n 3.3v 249.495n 3.3v 249.505n 3.3v 259.495n 3.3v 259.505n 3.3v 269.495n 3.3v 269.505n 3.3v 279.495n 3.3v 279.505n 3.3v 289.495n 3.3v 289.505n 3.3v 299.495n 3.3v 299.505n 3.3v 309.495n 3.3v 309.505n 3.3v 319.495n 3.3v 319.505n 3.3v 329.495n 3.3v 329.505n 3.3v 339.495n 3.3v 339.505n 3.3v 349.495n 3.3v 349.505n 3.3v 359.495n 3.3v 359.505n 3.3v 369.495n 3.3v 369.505n 0.0v 379.495n 0.0v 379.505n 3.3v 389.495n 3.3v 389.505n 3.3v 399.495n 3.3v 399.505n 0.0v 409.495n 0.0v 409.505n 0.0v 419.495n 0.0v 419.505n 0.0v 429.495n 0.0v 429.505n 0.0v 439.495n 0.0v 439.505n 0.0v 449.495n 0.0v 449.505n 0.0v 459.495n 0.0v 459.505n 0.0v 469.495n 0.0v 469.505n 0.0v 479.495n 0.0v 479.505n 0.0v 489.495n 0.0v 489.505n 0.0v 499.495n 0.0v 499.505n 3.3v 509.495n 3.3v 509.505n 3.3v 519.495n 3.3v 519.505n 3.3v 529.495n 3.3v 529.505n 3.3v 539.495n 3.3v 539.505n 3.3v 549.495n 3.3v 549.505n 3.3v 559.495n 3.3v 559.505n 3.3v 569.495n 3.3v 569.505n 3.3v 579.495n 3.3v 579.505n 3.3v 589.495n 3.3v 589.505n 3.3v 599.495n 3.3v 599.505n 3.3v 609.495n 3.3v 609.505n 3.3v 619.495n 3.3v 619.505n 3.3v 629.495n 3.3v 629.505n 3.3v 639.495n 3.3v 639.505n 3.3v 649.495n 3.3v 649.505n 3.3v 659.495n 3.3v 659.505n 0.0v 669.495n 0.0v 669.505n 0.0v 679.495n 0.0v 679.505n 3.3v 689.495n 3.3v 689.505n 3.3v 699.495n 3.3v 699.505n 3.3v 709.495n 3.3v 709.505n 0.0v 719.495n 0.0v 719.505n 0.0v 729.495n 0.0v 729.505n 0.0v 739.495n 0.0v 739.505n 0.0v 749.495n 0.0v 749.505n 0.0v 759.495n 0.0v 759.505n 0.0v 769.495n 0.0v 769.505n 0.0v 779.495n 0.0v 779.505n 0.0v 789.495n 0.0v 789.505n 0.0v 799.495n 0.0v 799.505n 0.0v 809.495n 0.0v 809.505n 0.0v 819.495n 0.0v 819.505n 0.0v 829.495n 0.0v 829.505n 0.0v 839.495n 0.0v 839.505n 0.0v 849.495n 0.0v 849.505n 0.0v 859.495n 0.0v 859.505n 0.0v 869.495n 0.0v 869.505n 3.3v 879.495n 3.3v 879.505n 3.3v 889.495n 3.3v 889.505n 3.3v 899.495n 3.3v 899.505n 3.3v 909.495n 3.3v 909.505n 3.3v 919.495n 3.3v 919.505n 3.3v 929.495n 3.3v 929.505n 3.3v 939.495n 3.3v 939.505n 0.0v 949.495n 0.0v 949.505n 3.3v 959.495n 3.3v 959.505n 3.3v 969.495n 3.3v 969.505n 3.3v 979.495n 3.3v 979.505n 3.3v 989.495n 3.3v 989.505n 3.3v 999.495n 3.3v 999.505n 3.3v 1009.495n 3.3v 1009.505n 3.3v 1019.495n 3.3v 1019.505n 3.3v 1029.495n 3.3v 1029.505n 3.3v 1039.495n 3.3v 1039.505n 0.0v 1049.495n 0.0v 1049.505n 3.3v 1059.495n 3.3v 1059.505n 3.3v 1069.495n 3.3v 1069.505n 3.3v 1079.495n 3.3v 1079.505n 3.3v 1089.495n 3.3v 1089.505n 3.3v 1099.495n 3.3v 1099.505n 0.0v 1109.495n 0.0v 1109.505n 0.0v 1119.495n 0.0v 1119.505n 0.0v 1129.495n 0.0v 1129.505n 0.0v 1139.495n 0.0v 1139.505n 3.3v 1149.495n 3.3v 1149.505n 3.3v 1159.495n 3.3v 1159.505n 3.3v 1169.495n 3.3v 1169.505n 3.3v 1179.495n 3.3v 1179.505n 3.3v 1189.495n 3.3v 1189.505n 3.3v 1199.495n 3.3v 1199.505n 3.3v 1209.495n 3.3v 1209.505n 0.0v 1219.495n 0.0v 1219.505n 0.0v 1229.495n 0.0v 1229.505n 0.0v 1239.495n 0.0v 1239.505n 0.0v 1249.495n 0.0v 1249.505n 0.0v 1259.495n 0.0v 1259.505n 0.0v 1269.495n 0.0v 1269.505n 0.0v 1279.495n 0.0v 1279.505n 0.0v 1289.495n 0.0v 1289.505n 0.0v 1299.495n 0.0v 1299.505n 0.0v 1309.495n 0.0v 1309.505n 0.0v 1319.495n 0.0v 1319.505n 0.0v 1329.495n 0.0v 1329.505n 0.0v 1339.495n 0.0v 1339.505n 0.0v 1349.495n 0.0v 1349.505n 0.0v 1359.495n 0.0v 1359.505n 0.0v 1369.495n 0.0v 1369.505n 0.0v 1379.495n 0.0v 1379.505n 0.0v 1389.495n 0.0v 1389.505n 0.0v 1399.495n 0.0v 1399.505n 0.0v 1409.495n 0.0v 1409.505n 0.0v 1419.495n 0.0v 1419.505n 0.0v 1429.495n 0.0v 1429.505n 0.0v 1439.495n 0.0v 1439.505n 0.0v 1449.495n 0.0v 1449.505n 0.0v 1459.495n 0.0v 1459.505n 0.0v 1469.495n 0.0v 1469.505n 0.0v 1479.495n 0.0v 1479.505n 0.0v 1489.495n 0.0v 1489.505n 0.0v 1499.495n 0.0v 1499.505n 0.0v 1509.495n 0.0v 1509.505n 0.0v 1519.495n 0.0v 1519.505n 0.0v 1529.495n 0.0v 1529.505n 0.0v 1539.495n 0.0v 1539.505n 0.0v 1549.495n 0.0v 1549.505n 3.3v 1559.495n 3.3v 1559.505n 0.0v 1569.495n 0.0v 1569.505n 0.0v 1579.495n 0.0v 1579.505n 0.0v 1589.495n 0.0v 1589.505n 0.0v 1599.495n 0.0v 1599.505n 3.3v 1609.495n 3.3v 1609.505n 3.3v 1619.495n 3.3v 1619.505n 3.3v 1629.495n 3.3v 1629.505n 3.3v 1639.495n 3.3v 1639.505n 3.3v 1649.495n 3.3v 1649.505n 3.3v 1659.495n 3.3v 1659.505n 3.3v 1669.495n 3.3v 1669.505n 3.3v 1679.495n 3.3v 1679.505n 3.3v 1689.495n 3.3v 1689.505n 3.3v 1699.495n 3.3v 1699.505n 3.3v 1709.495n 3.3v 1709.505n 3.3v 1719.495n 3.3v 1719.505n 3.3v 1729.495n 3.3v 1729.505n 3.3v 1739.495n 3.3v 1739.505n 3.3v 1749.495n 3.3v 1749.505n 3.3v 1759.495n 3.3v 1759.505n 3.3v 1769.495n 3.3v 1769.505n 0.0v 1779.495n 0.0v 1779.505n 0.0v 1789.495n 0.0v 1789.505n 0.0v 1799.495n 0.0v 1799.505n 0.0v 1809.495n 0.0v 1809.505n 0.0v 1819.495n 0.0v 1819.505n 0.0v 1829.495n 0.0v 1829.505n 0.0v 1839.495n 0.0v 1839.505n 0.0v 1849.495n 0.0v 1849.505n 0.0v 1859.495n 0.0v 1859.505n 0.0v 1869.495n 0.0v 1869.505n 0.0v 1879.495n 0.0v 1879.505n 0.0v 1889.495n 0.0v 1889.505n 0.0v 1899.495n 0.0v 1899.505n 0.0v 1909.495n 0.0v 1909.505n 0.0v 1919.495n 0.0v 1919.505n 0.0v 1929.495n 0.0v 1929.505n 0.0v 1939.495n 0.0v 1939.505n 3.3v 1949.495n 3.3v 1949.505n 3.3v 1959.495n 3.3v 1959.505n 3.3v 1969.495n 3.3v 1969.505n 3.3v 1979.495n 3.3v 1979.505n 0.0v 1989.495n 0.0v 1989.505n 0.0v 1999.495n 0.0v 1999.505n 0.0v 2009.495n 0.0v 2009.505n 0.0v 2019.495n 0.0v 2019.505n 0.0v 2029.495n 0.0v 2029.505n 0.0v 2039.495n 0.0v 2039.505n 0.0v 2049.495n 0.0v 2049.505n 0.0v )
* (time, data): [(0, 0), (10, 1), (20, 1), (30, 1), (40, 1), (50, 1), (60, 1), (70, 1), (80, 1), (90, 1), (100, 1), (110, 1), (120, 0), (130, 0), (140, 1), (150, 1), (160, 1), (170, 0), (180, 0), (190, 0), (200, 0), (210, 0), (220, 0), (230, 0), (240, 1), (250, 1), (260, 1), (270, 1), (280, 1), (290, 1), (300, 1), (310, 1), (320, 1), (330, 1), (340, 1), (350, 1), (360, 1), (370, 0), (380, 1), (390, 1), (400, 1), (410, 1), (420, 1), (430, 1), (440, 1), (450, 1), (460, 1), (470, 1), (480, 1), (490, 1), (500, 0), (510, 0), (520, 0), (530, 0), (540, 0), (550, 0), (560, 0), (570, 0), (580, 0), (590, 0), (600, 0), (610, 0), (620, 0), (630, 0), (640, 0), (650, 0), (660, 1), (670, 1), (680, 0), (690, 0), (700, 0), (710, 0), (720, 1), (730, 1), (740, 1), (750, 1), (760, 1), (770, 1), (780, 1), (790, 1), (800, 1), (810, 1), (820, 1), (830, 1), (840, 1), (850, 1), (860, 1), (870, 0), (880, 0), (890, 0), (900, 0), (910, 0), (920, 0), (930, 0), (940, 0), (950, 1), (960, 1), (970, 1), (980, 1), (990, 1), (1000, 1), (1010, 1), (1020, 1), (1030, 1), (1040, 1), (1050, 1), (1060, 1), (1070, 1), (1080, 1), (1090, 1), (1100, 1), (1110, 0), (1120, 0), (1130, 0), (1140, 1), (1150, 1), (1160, 1), (1170, 1), (1180, 1), (1190, 1), (1200, 1), (1210, 1), (1220, 1), (1230, 1), (1240, 1), (1250, 1), (1260, 1), (1270, 1), (1280, 1), (1290, 1), (1300, 1), (1310, 0), (1320, 0), (1330, 0), (1340, 0), (1350, 0), (1360, 0), (1370, 0), (1380, 0), (1390, 0), (1400, 0), (1410, 0), (1420, 0), (1430, 0), (1440, 0), (1450, 0), (1460, 0), (1470, 0), (1480, 0), (1490, 1), (1500, 1), (1510, 1), (1520, 1), (1530, 1), (1540, 1), (1550, 0), (1560, 0), (1570, 0), (1580, 0), (1590, 0), (1600, 1), (1610, 1), (1620, 1), (1630, 1), (1640, 1), (1650, 1), (1660, 1), (1670, 1), (1680, 1), (1690, 1), (1700, 1), (1710, 1), (1720, 1), (1730, 0), (1740, 0), (1750, 1), (1760, 1), (1770, 1), (1780, 1), (1790, 1), (1800, 1), (1810, 1), (1820, 0), (1830, 0), (1840, 0), (1850, 0), (1860, 1), (1870, 1), (1880, 1), (1890, 1), (1900, 1), (1910, 1), (1920, 1), (1930, 1), (1940, 0), (1950, 0), (1960, 0), (1970, 0), (1980, 0), (1990, 0), (2000, 1), (2010, 1), (2020, 0), (2030, 1), (2040, 1), (2050, 1)]
Vdin1_9  din1_9  0 PWL (0n 0.0v 9.495n 0.0v 9.505n 3.3v 19.495n 3.3v 19.505n 3.3v 29.495n 3.3v 29.505n 3.3v 39.495n 3.3v 39.505n 3.3v 49.495n 3.3v 49.505n 3.3v 59.495n 3.3v 59.505n 3.3v 69.495n 3.3v 69.505n 3.3v 79.495n 3.3v 79.505n 3.3v 89.495n 3.3v 89.505n 3.3v 99.495n 3.3v 99.505n 3.3v 109.495n 3.3v 109.505n 3.3v 119.495n 3.3v 119.505n 0.0v 129.495n 0.0v 129.505n 0.0v 139.495n 0.0v 139.505n 3.3v 149.495n 3.3v 149.505n 3.3v 159.495n 3.3v 159.505n 3.3v 169.495n 3.3v 169.505n 0.0v 179.495n 0.0v 179.505n 0.0v 189.495n 0.0v 189.505n 0.0v 199.495n 0.0v 199.505n 0.0v 209.495n 0.0v 209.505n 0.0v 219.495n 0.0v 219.505n 0.0v 229.495n 0.0v 229.505n 0.0v 239.495n 0.0v 239.505n 3.3v 249.495n 3.3v 249.505n 3.3v 259.495n 3.3v 259.505n 3.3v 269.495n 3.3v 269.505n 3.3v 279.495n 3.3v 279.505n 3.3v 289.495n 3.3v 289.505n 3.3v 299.495n 3.3v 299.505n 3.3v 309.495n 3.3v 309.505n 3.3v 319.495n 3.3v 319.505n 3.3v 329.495n 3.3v 329.505n 3.3v 339.495n 3.3v 339.505n 3.3v 349.495n 3.3v 349.505n 3.3v 359.495n 3.3v 359.505n 3.3v 369.495n 3.3v 369.505n 0.0v 379.495n 0.0v 379.505n 3.3v 389.495n 3.3v 389.505n 3.3v 399.495n 3.3v 399.505n 3.3v 409.495n 3.3v 409.505n 3.3v 419.495n 3.3v 419.505n 3.3v 429.495n 3.3v 429.505n 3.3v 439.495n 3.3v 439.505n 3.3v 449.495n 3.3v 449.505n 3.3v 459.495n 3.3v 459.505n 3.3v 469.495n 3.3v 469.505n 3.3v 479.495n 3.3v 479.505n 3.3v 489.495n 3.3v 489.505n 3.3v 499.495n 3.3v 499.505n 0.0v 509.495n 0.0v 509.505n 0.0v 519.495n 0.0v 519.505n 0.0v 529.495n 0.0v 529.505n 0.0v 539.495n 0.0v 539.505n 0.0v 549.495n 0.0v 549.505n 0.0v 559.495n 0.0v 559.505n 0.0v 569.495n 0.0v 569.505n 0.0v 579.495n 0.0v 579.505n 0.0v 589.495n 0.0v 589.505n 0.0v 599.495n 0.0v 599.505n 0.0v 609.495n 0.0v 609.505n 0.0v 619.495n 0.0v 619.505n 0.0v 629.495n 0.0v 629.505n 0.0v 639.495n 0.0v 639.505n 0.0v 649.495n 0.0v 649.505n 0.0v 659.495n 0.0v 659.505n 3.3v 669.495n 3.3v 669.505n 3.3v 679.495n 3.3v 679.505n 0.0v 689.495n 0.0v 689.505n 0.0v 699.495n 0.0v 699.505n 0.0v 709.495n 0.0v 709.505n 0.0v 719.495n 0.0v 719.505n 3.3v 729.495n 3.3v 729.505n 3.3v 739.495n 3.3v 739.505n 3.3v 749.495n 3.3v 749.505n 3.3v 759.495n 3.3v 759.505n 3.3v 769.495n 3.3v 769.505n 3.3v 779.495n 3.3v 779.505n 3.3v 789.495n 3.3v 789.505n 3.3v 799.495n 3.3v 799.505n 3.3v 809.495n 3.3v 809.505n 3.3v 819.495n 3.3v 819.505n 3.3v 829.495n 3.3v 829.505n 3.3v 839.495n 3.3v 839.505n 3.3v 849.495n 3.3v 849.505n 3.3v 859.495n 3.3v 859.505n 3.3v 869.495n 3.3v 869.505n 0.0v 879.495n 0.0v 879.505n 0.0v 889.495n 0.0v 889.505n 0.0v 899.495n 0.0v 899.505n 0.0v 909.495n 0.0v 909.505n 0.0v 919.495n 0.0v 919.505n 0.0v 929.495n 0.0v 929.505n 0.0v 939.495n 0.0v 939.505n 0.0v 949.495n 0.0v 949.505n 3.3v 959.495n 3.3v 959.505n 3.3v 969.495n 3.3v 969.505n 3.3v 979.495n 3.3v 979.505n 3.3v 989.495n 3.3v 989.505n 3.3v 999.495n 3.3v 999.505n 3.3v 1009.495n 3.3v 1009.505n 3.3v 1019.495n 3.3v 1019.505n 3.3v 1029.495n 3.3v 1029.505n 3.3v 1039.495n 3.3v 1039.505n 3.3v 1049.495n 3.3v 1049.505n 3.3v 1059.495n 3.3v 1059.505n 3.3v 1069.495n 3.3v 1069.505n 3.3v 1079.495n 3.3v 1079.505n 3.3v 1089.495n 3.3v 1089.505n 3.3v 1099.495n 3.3v 1099.505n 3.3v 1109.495n 3.3v 1109.505n 0.0v 1119.495n 0.0v 1119.505n 0.0v 1129.495n 0.0v 1129.505n 0.0v 1139.495n 0.0v 1139.505n 3.3v 1149.495n 3.3v 1149.505n 3.3v 1159.495n 3.3v 1159.505n 3.3v 1169.495n 3.3v 1169.505n 3.3v 1179.495n 3.3v 1179.505n 3.3v 1189.495n 3.3v 1189.505n 3.3v 1199.495n 3.3v 1199.505n 3.3v 1209.495n 3.3v 1209.505n 3.3v 1219.495n 3.3v 1219.505n 3.3v 1229.495n 3.3v 1229.505n 3.3v 1239.495n 3.3v 1239.505n 3.3v 1249.495n 3.3v 1249.505n 3.3v 1259.495n 3.3v 1259.505n 3.3v 1269.495n 3.3v 1269.505n 3.3v 1279.495n 3.3v 1279.505n 3.3v 1289.495n 3.3v 1289.505n 3.3v 1299.495n 3.3v 1299.505n 3.3v 1309.495n 3.3v 1309.505n 0.0v 1319.495n 0.0v 1319.505n 0.0v 1329.495n 0.0v 1329.505n 0.0v 1339.495n 0.0v 1339.505n 0.0v 1349.495n 0.0v 1349.505n 0.0v 1359.495n 0.0v 1359.505n 0.0v 1369.495n 0.0v 1369.505n 0.0v 1379.495n 0.0v 1379.505n 0.0v 1389.495n 0.0v 1389.505n 0.0v 1399.495n 0.0v 1399.505n 0.0v 1409.495n 0.0v 1409.505n 0.0v 1419.495n 0.0v 1419.505n 0.0v 1429.495n 0.0v 1429.505n 0.0v 1439.495n 0.0v 1439.505n 0.0v 1449.495n 0.0v 1449.505n 0.0v 1459.495n 0.0v 1459.505n 0.0v 1469.495n 0.0v 1469.505n 0.0v 1479.495n 0.0v 1479.505n 0.0v 1489.495n 0.0v 1489.505n 3.3v 1499.495n 3.3v 1499.505n 3.3v 1509.495n 3.3v 1509.505n 3.3v 1519.495n 3.3v 1519.505n 3.3v 1529.495n 3.3v 1529.505n 3.3v 1539.495n 3.3v 1539.505n 3.3v 1549.495n 3.3v 1549.505n 0.0v 1559.495n 0.0v 1559.505n 0.0v 1569.495n 0.0v 1569.505n 0.0v 1579.495n 0.0v 1579.505n 0.0v 1589.495n 0.0v 1589.505n 0.0v 1599.495n 0.0v 1599.505n 3.3v 1609.495n 3.3v 1609.505n 3.3v 1619.495n 3.3v 1619.505n 3.3v 1629.495n 3.3v 1629.505n 3.3v 1639.495n 3.3v 1639.505n 3.3v 1649.495n 3.3v 1649.505n 3.3v 1659.495n 3.3v 1659.505n 3.3v 1669.495n 3.3v 1669.505n 3.3v 1679.495n 3.3v 1679.505n 3.3v 1689.495n 3.3v 1689.505n 3.3v 1699.495n 3.3v 1699.505n 3.3v 1709.495n 3.3v 1709.505n 3.3v 1719.495n 3.3v 1719.505n 3.3v 1729.495n 3.3v 1729.505n 0.0v 1739.495n 0.0v 1739.505n 0.0v 1749.495n 0.0v 1749.505n 3.3v 1759.495n 3.3v 1759.505n 3.3v 1769.495n 3.3v 1769.505n 3.3v 1779.495n 3.3v 1779.505n 3.3v 1789.495n 3.3v 1789.505n 3.3v 1799.495n 3.3v 1799.505n 3.3v 1809.495n 3.3v 1809.505n 3.3v 1819.495n 3.3v 1819.505n 0.0v 1829.495n 0.0v 1829.505n 0.0v 1839.495n 0.0v 1839.505n 0.0v 1849.495n 0.0v 1849.505n 0.0v 1859.495n 0.0v 1859.505n 3.3v 1869.495n 3.3v 1869.505n 3.3v 1879.495n 3.3v 1879.505n 3.3v 1889.495n 3.3v 1889.505n 3.3v 1899.495n 3.3v 1899.505n 3.3v 1909.495n 3.3v 1909.505n 3.3v 1919.495n 3.3v 1919.505n 3.3v 1929.495n 3.3v 1929.505n 3.3v 1939.495n 3.3v 1939.505n 0.0v 1949.495n 0.0v 1949.505n 0.0v 1959.495n 0.0v 1959.505n 0.0v 1969.495n 0.0v 1969.505n 0.0v 1979.495n 0.0v 1979.505n 0.0v 1989.495n 0.0v 1989.505n 0.0v 1999.495n 0.0v 1999.505n 3.3v 2009.495n 3.3v 2009.505n 3.3v 2019.495n 3.3v 2019.505n 0.0v 2029.495n 0.0v 2029.505n 3.3v 2039.495n 3.3v 2039.505n 3.3v 2049.495n 3.3v 2049.505n 3.3v )
* (time, data): [(0, 0), (10, 1), (20, 1), (30, 0), (40, 0), (50, 0), (60, 0), (70, 0), (80, 0), (90, 0), (100, 0), (110, 0), (120, 1), (130, 1), (140, 0), (150, 0), (160, 0), (170, 0), (180, 0), (190, 0), (200, 0), (210, 0), (220, 0), (230, 0), (240, 1), (250, 1), (260, 1), (270, 1), (280, 1), (290, 1), (300, 1), (310, 1), (320, 1), (330, 1), (340, 1), (350, 1), (360, 1), (370, 0), (380, 0), (390, 0), (400, 1), (410, 1), (420, 1), (430, 1), (440, 1), (450, 1), (460, 1), (470, 1), (480, 1), (490, 1), (500, 0), (510, 0), (520, 0), (530, 0), (540, 0), (550, 0), (560, 0), (570, 0), (580, 0), (590, 0), (600, 0), (610, 0), (620, 0), (630, 0), (640, 0), (650, 0), (660, 0), (670, 0), (680, 0), (690, 0), (700, 0), (710, 0), (720, 1), (730, 1), (740, 1), (750, 1), (760, 1), (770, 1), (780, 1), (790, 1), (800, 1), (810, 1), (820, 1), (830, 1), (840, 1), (850, 1), (860, 1), (870, 0), (880, 0), (890, 0), (900, 0), (910, 0), (920, 0), (930, 0), (940, 1), (950, 0), (960, 0), (970, 0), (980, 0), (990, 0), (1000, 0), (1010, 0), (1020, 0), (1030, 0), (1040, 1), (1050, 0), (1060, 0), (1070, 0), (1080, 0), (1090, 0), (1100, 1), (1110, 0), (1120, 0), (1130, 0), (1140, 0), (1150, 0), (1160, 0), (1170, 0), (1180, 0), (1190, 0), (1200, 0), (1210, 0), (1220, 0), (1230, 0), (1240, 0), (1250, 1), (1260, 1), (1270, 1), (1280, 1), (1290, 1), (1300, 1), (1310, 1), (1320, 1), (1330, 1), (1340, 1), (1350, 1), (1360, 1), (1370, 1), (1380, 1), (1390, 1), (1400, 1), (1410, 1), (1420, 1), (1430, 1), (1440, 0), (1450, 0), (1460, 0), (1470, 0), (1480, 0), (1490, 1), (1500, 1), (1510, 1), (1520, 1), (1530, 1), (1540, 1), (1550, 1), (1560, 0), (1570, 0), (1580, 0), (1590, 0), (1600, 0), (1610, 0), (1620, 0), (1630, 0), (1640, 0), (1650, 0), (1660, 0), (1670, 0), (1680, 0), (1690, 0), (1700, 0), (1710, 0), (1720, 0), (1730, 1), (1740, 1), (1750, 0), (1760, 0), (1770, 0), (1780, 0), (1790, 0), (1800, 0), (1810, 0), (1820, 0), (1830, 0), (1840, 0), (1850, 0), (1860, 1), (1870, 1), (1880, 0), (1890, 0), (1900, 0), (1910, 1), (1920, 1), (1930, 1), (1940, 0), (1950, 0), (1960, 0), (1970, 0), (1980, 1), (1990, 1), (2000, 1), (2010, 1), (2020, 1), (2030, 0), (2040, 0), (2050, 0)]
Vdin1_10  din1_10  0 PWL (0n 0.0v 9.495n 0.0v 9.505n 3.3v 19.495n 3.3v 19.505n 3.3v 29.495n 3.3v 29.505n 0.0v 39.495n 0.0v 39.505n 0.0v 49.495n 0.0v 49.505n 0.0v 59.495n 0.0v 59.505n 0.0v 69.495n 0.0v 69.505n 0.0v 79.495n 0.0v 79.505n 0.0v 89.495n 0.0v 89.505n 0.0v 99.495n 0.0v 99.505n 0.0v 109.495n 0.0v 109.505n 0.0v 119.495n 0.0v 119.505n 3.3v 129.495n 3.3v 129.505n 3.3v 139.495n 3.3v 139.505n 0.0v 149.495n 0.0v 149.505n 0.0v 159.495n 0.0v 159.505n 0.0v 169.495n 0.0v 169.505n 0.0v 179.495n 0.0v 179.505n 0.0v 189.495n 0.0v 189.505n 0.0v 199.495n 0.0v 199.505n 0.0v 209.495n 0.0v 209.505n 0.0v 219.495n 0.0v 219.505n 0.0v 229.495n 0.0v 229.505n 0.0v 239.495n 0.0v 239.505n 3.3v 249.495n 3.3v 249.505n 3.3v 259.495n 3.3v 259.505n 3.3v 269.495n 3.3v 269.505n 3.3v 279.495n 3.3v 279.505n 3.3v 289.495n 3.3v 289.505n 3.3v 299.495n 3.3v 299.505n 3.3v 309.495n 3.3v 309.505n 3.3v 319.495n 3.3v 319.505n 3.3v 329.495n 3.3v 329.505n 3.3v 339.495n 3.3v 339.505n 3.3v 349.495n 3.3v 349.505n 3.3v 359.495n 3.3v 359.505n 3.3v 369.495n 3.3v 369.505n 0.0v 379.495n 0.0v 379.505n 0.0v 389.495n 0.0v 389.505n 0.0v 399.495n 0.0v 399.505n 3.3v 409.495n 3.3v 409.505n 3.3v 419.495n 3.3v 419.505n 3.3v 429.495n 3.3v 429.505n 3.3v 439.495n 3.3v 439.505n 3.3v 449.495n 3.3v 449.505n 3.3v 459.495n 3.3v 459.505n 3.3v 469.495n 3.3v 469.505n 3.3v 479.495n 3.3v 479.505n 3.3v 489.495n 3.3v 489.505n 3.3v 499.495n 3.3v 499.505n 0.0v 509.495n 0.0v 509.505n 0.0v 519.495n 0.0v 519.505n 0.0v 529.495n 0.0v 529.505n 0.0v 539.495n 0.0v 539.505n 0.0v 549.495n 0.0v 549.505n 0.0v 559.495n 0.0v 559.505n 0.0v 569.495n 0.0v 569.505n 0.0v 579.495n 0.0v 579.505n 0.0v 589.495n 0.0v 589.505n 0.0v 599.495n 0.0v 599.505n 0.0v 609.495n 0.0v 609.505n 0.0v 619.495n 0.0v 619.505n 0.0v 629.495n 0.0v 629.505n 0.0v 639.495n 0.0v 639.505n 0.0v 649.495n 0.0v 649.505n 0.0v 659.495n 0.0v 659.505n 0.0v 669.495n 0.0v 669.505n 0.0v 679.495n 0.0v 679.505n 0.0v 689.495n 0.0v 689.505n 0.0v 699.495n 0.0v 699.505n 0.0v 709.495n 0.0v 709.505n 0.0v 719.495n 0.0v 719.505n 3.3v 729.495n 3.3v 729.505n 3.3v 739.495n 3.3v 739.505n 3.3v 749.495n 3.3v 749.505n 3.3v 759.495n 3.3v 759.505n 3.3v 769.495n 3.3v 769.505n 3.3v 779.495n 3.3v 779.505n 3.3v 789.495n 3.3v 789.505n 3.3v 799.495n 3.3v 799.505n 3.3v 809.495n 3.3v 809.505n 3.3v 819.495n 3.3v 819.505n 3.3v 829.495n 3.3v 829.505n 3.3v 839.495n 3.3v 839.505n 3.3v 849.495n 3.3v 849.505n 3.3v 859.495n 3.3v 859.505n 3.3v 869.495n 3.3v 869.505n 0.0v 879.495n 0.0v 879.505n 0.0v 889.495n 0.0v 889.505n 0.0v 899.495n 0.0v 899.505n 0.0v 909.495n 0.0v 909.505n 0.0v 919.495n 0.0v 919.505n 0.0v 929.495n 0.0v 929.505n 0.0v 939.495n 0.0v 939.505n 3.3v 949.495n 3.3v 949.505n 0.0v 959.495n 0.0v 959.505n 0.0v 969.495n 0.0v 969.505n 0.0v 979.495n 0.0v 979.505n 0.0v 989.495n 0.0v 989.505n 0.0v 999.495n 0.0v 999.505n 0.0v 1009.495n 0.0v 1009.505n 0.0v 1019.495n 0.0v 1019.505n 0.0v 1029.495n 0.0v 1029.505n 0.0v 1039.495n 0.0v 1039.505n 3.3v 1049.495n 3.3v 1049.505n 0.0v 1059.495n 0.0v 1059.505n 0.0v 1069.495n 0.0v 1069.505n 0.0v 1079.495n 0.0v 1079.505n 0.0v 1089.495n 0.0v 1089.505n 0.0v 1099.495n 0.0v 1099.505n 3.3v 1109.495n 3.3v 1109.505n 0.0v 1119.495n 0.0v 1119.505n 0.0v 1129.495n 0.0v 1129.505n 0.0v 1139.495n 0.0v 1139.505n 0.0v 1149.495n 0.0v 1149.505n 0.0v 1159.495n 0.0v 1159.505n 0.0v 1169.495n 0.0v 1169.505n 0.0v 1179.495n 0.0v 1179.505n 0.0v 1189.495n 0.0v 1189.505n 0.0v 1199.495n 0.0v 1199.505n 0.0v 1209.495n 0.0v 1209.505n 0.0v 1219.495n 0.0v 1219.505n 0.0v 1229.495n 0.0v 1229.505n 0.0v 1239.495n 0.0v 1239.505n 0.0v 1249.495n 0.0v 1249.505n 3.3v 1259.495n 3.3v 1259.505n 3.3v 1269.495n 3.3v 1269.505n 3.3v 1279.495n 3.3v 1279.505n 3.3v 1289.495n 3.3v 1289.505n 3.3v 1299.495n 3.3v 1299.505n 3.3v 1309.495n 3.3v 1309.505n 3.3v 1319.495n 3.3v 1319.505n 3.3v 1329.495n 3.3v 1329.505n 3.3v 1339.495n 3.3v 1339.505n 3.3v 1349.495n 3.3v 1349.505n 3.3v 1359.495n 3.3v 1359.505n 3.3v 1369.495n 3.3v 1369.505n 3.3v 1379.495n 3.3v 1379.505n 3.3v 1389.495n 3.3v 1389.505n 3.3v 1399.495n 3.3v 1399.505n 3.3v 1409.495n 3.3v 1409.505n 3.3v 1419.495n 3.3v 1419.505n 3.3v 1429.495n 3.3v 1429.505n 3.3v 1439.495n 3.3v 1439.505n 0.0v 1449.495n 0.0v 1449.505n 0.0v 1459.495n 0.0v 1459.505n 0.0v 1469.495n 0.0v 1469.505n 0.0v 1479.495n 0.0v 1479.505n 0.0v 1489.495n 0.0v 1489.505n 3.3v 1499.495n 3.3v 1499.505n 3.3v 1509.495n 3.3v 1509.505n 3.3v 1519.495n 3.3v 1519.505n 3.3v 1529.495n 3.3v 1529.505n 3.3v 1539.495n 3.3v 1539.505n 3.3v 1549.495n 3.3v 1549.505n 3.3v 1559.495n 3.3v 1559.505n 0.0v 1569.495n 0.0v 1569.505n 0.0v 1579.495n 0.0v 1579.505n 0.0v 1589.495n 0.0v 1589.505n 0.0v 1599.495n 0.0v 1599.505n 0.0v 1609.495n 0.0v 1609.505n 0.0v 1619.495n 0.0v 1619.505n 0.0v 1629.495n 0.0v 1629.505n 0.0v 1639.495n 0.0v 1639.505n 0.0v 1649.495n 0.0v 1649.505n 0.0v 1659.495n 0.0v 1659.505n 0.0v 1669.495n 0.0v 1669.505n 0.0v 1679.495n 0.0v 1679.505n 0.0v 1689.495n 0.0v 1689.505n 0.0v 1699.495n 0.0v 1699.505n 0.0v 1709.495n 0.0v 1709.505n 0.0v 1719.495n 0.0v 1719.505n 0.0v 1729.495n 0.0v 1729.505n 3.3v 1739.495n 3.3v 1739.505n 3.3v 1749.495n 3.3v 1749.505n 0.0v 1759.495n 0.0v 1759.505n 0.0v 1769.495n 0.0v 1769.505n 0.0v 1779.495n 0.0v 1779.505n 0.0v 1789.495n 0.0v 1789.505n 0.0v 1799.495n 0.0v 1799.505n 0.0v 1809.495n 0.0v 1809.505n 0.0v 1819.495n 0.0v 1819.505n 0.0v 1829.495n 0.0v 1829.505n 0.0v 1839.495n 0.0v 1839.505n 0.0v 1849.495n 0.0v 1849.505n 0.0v 1859.495n 0.0v 1859.505n 3.3v 1869.495n 3.3v 1869.505n 3.3v 1879.495n 3.3v 1879.505n 0.0v 1889.495n 0.0v 1889.505n 0.0v 1899.495n 0.0v 1899.505n 0.0v 1909.495n 0.0v 1909.505n 3.3v 1919.495n 3.3v 1919.505n 3.3v 1929.495n 3.3v 1929.505n 3.3v 1939.495n 3.3v 1939.505n 0.0v 1949.495n 0.0v 1949.505n 0.0v 1959.495n 0.0v 1959.505n 0.0v 1969.495n 0.0v 1969.505n 0.0v 1979.495n 0.0v 1979.505n 3.3v 1989.495n 3.3v 1989.505n 3.3v 1999.495n 3.3v 1999.505n 3.3v 2009.495n 3.3v 2009.505n 3.3v 2019.495n 3.3v 2019.505n 3.3v 2029.495n 3.3v 2029.505n 0.0v 2039.495n 0.0v 2039.505n 0.0v 2049.495n 0.0v 2049.505n 0.0v )
* (time, data): [(0, 0), (10, 1), (20, 1), (30, 0), (40, 0), (50, 0), (60, 0), (70, 1), (80, 1), (90, 1), (100, 1), (110, 1), (120, 0), (130, 0), (140, 1), (150, 1), (160, 1), (170, 1), (180, 1), (190, 1), (200, 1), (210, 1), (220, 1), (230, 1), (240, 0), (250, 0), (260, 0), (270, 0), (280, 0), (290, 0), (300, 0), (310, 0), (320, 0), (330, 0), (340, 0), (350, 0), (360, 0), (370, 0), (380, 1), (390, 1), (400, 0), (410, 0), (420, 0), (430, 0), (440, 0), (450, 0), (460, 0), (470, 0), (480, 0), (490, 0), (500, 0), (510, 0), (520, 0), (530, 0), (540, 0), (550, 0), (560, 0), (570, 0), (580, 0), (590, 0), (600, 0), (610, 0), (620, 0), (630, 0), (640, 0), (650, 0), (660, 1), (670, 1), (680, 1), (690, 1), (700, 1), (710, 0), (720, 1), (730, 1), (740, 1), (750, 1), (760, 1), (770, 1), (780, 1), (790, 1), (800, 1), (810, 1), (820, 1), (830, 1), (840, 1), (850, 1), (860, 1), (870, 0), (880, 0), (890, 0), (900, 0), (910, 0), (920, 0), (930, 0), (940, 0), (950, 0), (960, 0), (970, 0), (980, 0), (990, 0), (1000, 0), (1010, 0), (1020, 0), (1030, 0), (1040, 1), (1050, 1), (1060, 1), (1070, 1), (1080, 1), (1090, 1), (1100, 1), (1110, 0), (1120, 0), (1130, 0), (1140, 1), (1150, 1), (1160, 1), (1170, 1), (1180, 1), (1190, 1), (1200, 1), (1210, 0), (1220, 0), (1230, 0), (1240, 0), (1250, 1), (1260, 1), (1270, 1), (1280, 1), (1290, 1), (1300, 1), (1310, 0), (1320, 0), (1330, 0), (1340, 0), (1350, 0), (1360, 0), (1370, 0), (1380, 0), (1390, 0), (1400, 0), (1410, 0), (1420, 0), (1430, 0), (1440, 0), (1450, 0), (1460, 0), (1470, 0), (1480, 0), (1490, 1), (1500, 1), (1510, 1), (1520, 1), (1530, 1), (1540, 1), (1550, 1), (1560, 0), (1570, 0), (1580, 0), (1590, 0), (1600, 0), (1610, 0), (1620, 0), (1630, 0), (1640, 0), (1650, 0), (1660, 0), (1670, 0), (1680, 0), (1690, 0), (1700, 0), (1710, 0), (1720, 0), (1730, 1), (1740, 1), (1750, 1), (1760, 1), (1770, 0), (1780, 0), (1790, 0), (1800, 0), (1810, 0), (1820, 0), (1830, 0), (1840, 0), (1850, 0), (1860, 0), (1870, 0), (1880, 0), (1890, 0), (1900, 0), (1910, 0), (1920, 0), (1930, 0), (1940, 1), (1950, 1), (1960, 1), (1970, 1), (1980, 1), (1990, 1), (2000, 1), (2010, 1), (2020, 0), (2030, 1), (2040, 1), (2050, 1)]
Vdin1_11  din1_11  0 PWL (0n 0.0v 9.495n 0.0v 9.505n 3.3v 19.495n 3.3v 19.505n 3.3v 29.495n 3.3v 29.505n 0.0v 39.495n 0.0v 39.505n 0.0v 49.495n 0.0v 49.505n 0.0v 59.495n 0.0v 59.505n 0.0v 69.495n 0.0v 69.505n 3.3v 79.495n 3.3v 79.505n 3.3v 89.495n 3.3v 89.505n 3.3v 99.495n 3.3v 99.505n 3.3v 109.495n 3.3v 109.505n 3.3v 119.495n 3.3v 119.505n 0.0v 129.495n 0.0v 129.505n 0.0v 139.495n 0.0v 139.505n 3.3v 149.495n 3.3v 149.505n 3.3v 159.495n 3.3v 159.505n 3.3v 169.495n 3.3v 169.505n 3.3v 179.495n 3.3v 179.505n 3.3v 189.495n 3.3v 189.505n 3.3v 199.495n 3.3v 199.505n 3.3v 209.495n 3.3v 209.505n 3.3v 219.495n 3.3v 219.505n 3.3v 229.495n 3.3v 229.505n 3.3v 239.495n 3.3v 239.505n 0.0v 249.495n 0.0v 249.505n 0.0v 259.495n 0.0v 259.505n 0.0v 269.495n 0.0v 269.505n 0.0v 279.495n 0.0v 279.505n 0.0v 289.495n 0.0v 289.505n 0.0v 299.495n 0.0v 299.505n 0.0v 309.495n 0.0v 309.505n 0.0v 319.495n 0.0v 319.505n 0.0v 329.495n 0.0v 329.505n 0.0v 339.495n 0.0v 339.505n 0.0v 349.495n 0.0v 349.505n 0.0v 359.495n 0.0v 359.505n 0.0v 369.495n 0.0v 369.505n 0.0v 379.495n 0.0v 379.505n 3.3v 389.495n 3.3v 389.505n 3.3v 399.495n 3.3v 399.505n 0.0v 409.495n 0.0v 409.505n 0.0v 419.495n 0.0v 419.505n 0.0v 429.495n 0.0v 429.505n 0.0v 439.495n 0.0v 439.505n 0.0v 449.495n 0.0v 449.505n 0.0v 459.495n 0.0v 459.505n 0.0v 469.495n 0.0v 469.505n 0.0v 479.495n 0.0v 479.505n 0.0v 489.495n 0.0v 489.505n 0.0v 499.495n 0.0v 499.505n 0.0v 509.495n 0.0v 509.505n 0.0v 519.495n 0.0v 519.505n 0.0v 529.495n 0.0v 529.505n 0.0v 539.495n 0.0v 539.505n 0.0v 549.495n 0.0v 549.505n 0.0v 559.495n 0.0v 559.505n 0.0v 569.495n 0.0v 569.505n 0.0v 579.495n 0.0v 579.505n 0.0v 589.495n 0.0v 589.505n 0.0v 599.495n 0.0v 599.505n 0.0v 609.495n 0.0v 609.505n 0.0v 619.495n 0.0v 619.505n 0.0v 629.495n 0.0v 629.505n 0.0v 639.495n 0.0v 639.505n 0.0v 649.495n 0.0v 649.505n 0.0v 659.495n 0.0v 659.505n 3.3v 669.495n 3.3v 669.505n 3.3v 679.495n 3.3v 679.505n 3.3v 689.495n 3.3v 689.505n 3.3v 699.495n 3.3v 699.505n 3.3v 709.495n 3.3v 709.505n 0.0v 719.495n 0.0v 719.505n 3.3v 729.495n 3.3v 729.505n 3.3v 739.495n 3.3v 739.505n 3.3v 749.495n 3.3v 749.505n 3.3v 759.495n 3.3v 759.505n 3.3v 769.495n 3.3v 769.505n 3.3v 779.495n 3.3v 779.505n 3.3v 789.495n 3.3v 789.505n 3.3v 799.495n 3.3v 799.505n 3.3v 809.495n 3.3v 809.505n 3.3v 819.495n 3.3v 819.505n 3.3v 829.495n 3.3v 829.505n 3.3v 839.495n 3.3v 839.505n 3.3v 849.495n 3.3v 849.505n 3.3v 859.495n 3.3v 859.505n 3.3v 869.495n 3.3v 869.505n 0.0v 879.495n 0.0v 879.505n 0.0v 889.495n 0.0v 889.505n 0.0v 899.495n 0.0v 899.505n 0.0v 909.495n 0.0v 909.505n 0.0v 919.495n 0.0v 919.505n 0.0v 929.495n 0.0v 929.505n 0.0v 939.495n 0.0v 939.505n 0.0v 949.495n 0.0v 949.505n 0.0v 959.495n 0.0v 959.505n 0.0v 969.495n 0.0v 969.505n 0.0v 979.495n 0.0v 979.505n 0.0v 989.495n 0.0v 989.505n 0.0v 999.495n 0.0v 999.505n 0.0v 1009.495n 0.0v 1009.505n 0.0v 1019.495n 0.0v 1019.505n 0.0v 1029.495n 0.0v 1029.505n 0.0v 1039.495n 0.0v 1039.505n 3.3v 1049.495n 3.3v 1049.505n 3.3v 1059.495n 3.3v 1059.505n 3.3v 1069.495n 3.3v 1069.505n 3.3v 1079.495n 3.3v 1079.505n 3.3v 1089.495n 3.3v 1089.505n 3.3v 1099.495n 3.3v 1099.505n 3.3v 1109.495n 3.3v 1109.505n 0.0v 1119.495n 0.0v 1119.505n 0.0v 1129.495n 0.0v 1129.505n 0.0v 1139.495n 0.0v 1139.505n 3.3v 1149.495n 3.3v 1149.505n 3.3v 1159.495n 3.3v 1159.505n 3.3v 1169.495n 3.3v 1169.505n 3.3v 1179.495n 3.3v 1179.505n 3.3v 1189.495n 3.3v 1189.505n 3.3v 1199.495n 3.3v 1199.505n 3.3v 1209.495n 3.3v 1209.505n 0.0v 1219.495n 0.0v 1219.505n 0.0v 1229.495n 0.0v 1229.505n 0.0v 1239.495n 0.0v 1239.505n 0.0v 1249.495n 0.0v 1249.505n 3.3v 1259.495n 3.3v 1259.505n 3.3v 1269.495n 3.3v 1269.505n 3.3v 1279.495n 3.3v 1279.505n 3.3v 1289.495n 3.3v 1289.505n 3.3v 1299.495n 3.3v 1299.505n 3.3v 1309.495n 3.3v 1309.505n 0.0v 1319.495n 0.0v 1319.505n 0.0v 1329.495n 0.0v 1329.505n 0.0v 1339.495n 0.0v 1339.505n 0.0v 1349.495n 0.0v 1349.505n 0.0v 1359.495n 0.0v 1359.505n 0.0v 1369.495n 0.0v 1369.505n 0.0v 1379.495n 0.0v 1379.505n 0.0v 1389.495n 0.0v 1389.505n 0.0v 1399.495n 0.0v 1399.505n 0.0v 1409.495n 0.0v 1409.505n 0.0v 1419.495n 0.0v 1419.505n 0.0v 1429.495n 0.0v 1429.505n 0.0v 1439.495n 0.0v 1439.505n 0.0v 1449.495n 0.0v 1449.505n 0.0v 1459.495n 0.0v 1459.505n 0.0v 1469.495n 0.0v 1469.505n 0.0v 1479.495n 0.0v 1479.505n 0.0v 1489.495n 0.0v 1489.505n 3.3v 1499.495n 3.3v 1499.505n 3.3v 1509.495n 3.3v 1509.505n 3.3v 1519.495n 3.3v 1519.505n 3.3v 1529.495n 3.3v 1529.505n 3.3v 1539.495n 3.3v 1539.505n 3.3v 1549.495n 3.3v 1549.505n 3.3v 1559.495n 3.3v 1559.505n 0.0v 1569.495n 0.0v 1569.505n 0.0v 1579.495n 0.0v 1579.505n 0.0v 1589.495n 0.0v 1589.505n 0.0v 1599.495n 0.0v 1599.505n 0.0v 1609.495n 0.0v 1609.505n 0.0v 1619.495n 0.0v 1619.505n 0.0v 1629.495n 0.0v 1629.505n 0.0v 1639.495n 0.0v 1639.505n 0.0v 1649.495n 0.0v 1649.505n 0.0v 1659.495n 0.0v 1659.505n 0.0v 1669.495n 0.0v 1669.505n 0.0v 1679.495n 0.0v 1679.505n 0.0v 1689.495n 0.0v 1689.505n 0.0v 1699.495n 0.0v 1699.505n 0.0v 1709.495n 0.0v 1709.505n 0.0v 1719.495n 0.0v 1719.505n 0.0v 1729.495n 0.0v 1729.505n 3.3v 1739.495n 3.3v 1739.505n 3.3v 1749.495n 3.3v 1749.505n 3.3v 1759.495n 3.3v 1759.505n 3.3v 1769.495n 3.3v 1769.505n 0.0v 1779.495n 0.0v 1779.505n 0.0v 1789.495n 0.0v 1789.505n 0.0v 1799.495n 0.0v 1799.505n 0.0v 1809.495n 0.0v 1809.505n 0.0v 1819.495n 0.0v 1819.505n 0.0v 1829.495n 0.0v 1829.505n 0.0v 1839.495n 0.0v 1839.505n 0.0v 1849.495n 0.0v 1849.505n 0.0v 1859.495n 0.0v 1859.505n 0.0v 1869.495n 0.0v 1869.505n 0.0v 1879.495n 0.0v 1879.505n 0.0v 1889.495n 0.0v 1889.505n 0.0v 1899.495n 0.0v 1899.505n 0.0v 1909.495n 0.0v 1909.505n 0.0v 1919.495n 0.0v 1919.505n 0.0v 1929.495n 0.0v 1929.505n 0.0v 1939.495n 0.0v 1939.505n 3.3v 1949.495n 3.3v 1949.505n 3.3v 1959.495n 3.3v 1959.505n 3.3v 1969.495n 3.3v 1969.505n 3.3v 1979.495n 3.3v 1979.505n 3.3v 1989.495n 3.3v 1989.505n 3.3v 1999.495n 3.3v 1999.505n 3.3v 2009.495n 3.3v 2009.505n 3.3v 2019.495n 3.3v 2019.505n 0.0v 2029.495n 0.0v 2029.505n 3.3v 2039.495n 3.3v 2039.505n 3.3v 2049.495n 3.3v 2049.505n 3.3v )
* (time, data): [(0, 0), (10, 0), (20, 0), (30, 1), (40, 1), (50, 1), (60, 1), (70, 0), (80, 1), (90, 1), (100, 1), (110, 1), (120, 0), (130, 0), (140, 1), (150, 1), (160, 1), (170, 1), (180, 1), (190, 1), (200, 1), (210, 1), (220, 1), (230, 1), (240, 1), (250, 1), (260, 1), (270, 1), (280, 1), (290, 1), (300, 1), (310, 1), (320, 1), (330, 1), (340, 1), (350, 1), (360, 1), (370, 1), (380, 0), (390, 0), (400, 1), (410, 1), (420, 1), (430, 1), (440, 1), (450, 1), (460, 1), (470, 1), (480, 1), (490, 1), (500, 0), (510, 0), (520, 0), (530, 0), (540, 0), (550, 0), (560, 0), (570, 0), (580, 0), (590, 0), (600, 0), (610, 0), (620, 0), (630, 0), (640, 0), (650, 0), (660, 0), (670, 0), (680, 0), (690, 0), (700, 0), (710, 1), (720, 0), (730, 0), (740, 0), (750, 0), (760, 0), (770, 0), (780, 0), (790, 0), (800, 0), (810, 0), (820, 0), (830, 0), (840, 0), (850, 0), (860, 0), (870, 0), (880, 0), (890, 0), (900, 0), (910, 0), (920, 0), (930, 0), (940, 0), (950, 1), (960, 1), (970, 1), (980, 1), (990, 1), (1000, 1), (1010, 1), (1020, 1), (1030, 1), (1040, 1), (1050, 0), (1060, 0), (1070, 0), (1080, 0), (1090, 0), (1100, 1), (1110, 1), (1120, 1), (1130, 1), (1140, 1), (1150, 1), (1160, 1), (1170, 1), (1180, 1), (1190, 1), (1200, 1), (1210, 0), (1220, 0), (1230, 0), (1240, 0), (1250, 1), (1260, 1), (1270, 1), (1280, 1), (1290, 1), (1300, 1), (1310, 0), (1320, 0), (1330, 0), (1340, 0), (1350, 0), (1360, 0), (1370, 0), (1380, 0), (1390, 0), (1400, 0), (1410, 0), (1420, 0), (1430, 0), (1440, 1), (1450, 1), (1460, 1), (1470, 1), (1480, 1), (1490, 0), (1500, 0), (1510, 0), (1520, 0), (1530, 0), (1540, 0), (1550, 0), (1560, 1), (1570, 1), (1580, 1), (1590, 1), (1600, 0), (1610, 0), (1620, 0), (1630, 0), (1640, 0), (1650, 0), (1660, 0), (1670, 0), (1680, 0), (1690, 0), (1700, 0), (1710, 0), (1720, 0), (1730, 1), (1740, 1), (1750, 1), (1760, 1), (1770, 0), (1780, 0), (1790, 0), (1800, 0), (1810, 0), (1820, 1), (1830, 1), (1840, 1), (1850, 1), (1860, 0), (1870, 0), (1880, 0), (1890, 0), (1900, 0), (1910, 0), (1920, 0), (1930, 0), (1940, 0), (1950, 0), (1960, 0), (1970, 0), (1980, 1), (1990, 1), (2000, 0), (2010, 0), (2020, 1), (2030, 1), (2040, 1), (2050, 1)]
Vdin1_12  din1_12  0 PWL (0n 0.0v 9.495n 0.0v 9.505n 0.0v 19.495n 0.0v 19.505n 0.0v 29.495n 0.0v 29.505n 3.3v 39.495n 3.3v 39.505n 3.3v 49.495n 3.3v 49.505n 3.3v 59.495n 3.3v 59.505n 3.3v 69.495n 3.3v 69.505n 0.0v 79.495n 0.0v 79.505n 3.3v 89.495n 3.3v 89.505n 3.3v 99.495n 3.3v 99.505n 3.3v 109.495n 3.3v 109.505n 3.3v 119.495n 3.3v 119.505n 0.0v 129.495n 0.0v 129.505n 0.0v 139.495n 0.0v 139.505n 3.3v 149.495n 3.3v 149.505n 3.3v 159.495n 3.3v 159.505n 3.3v 169.495n 3.3v 169.505n 3.3v 179.495n 3.3v 179.505n 3.3v 189.495n 3.3v 189.505n 3.3v 199.495n 3.3v 199.505n 3.3v 209.495n 3.3v 209.505n 3.3v 219.495n 3.3v 219.505n 3.3v 229.495n 3.3v 229.505n 3.3v 239.495n 3.3v 239.505n 3.3v 249.495n 3.3v 249.505n 3.3v 259.495n 3.3v 259.505n 3.3v 269.495n 3.3v 269.505n 3.3v 279.495n 3.3v 279.505n 3.3v 289.495n 3.3v 289.505n 3.3v 299.495n 3.3v 299.505n 3.3v 309.495n 3.3v 309.505n 3.3v 319.495n 3.3v 319.505n 3.3v 329.495n 3.3v 329.505n 3.3v 339.495n 3.3v 339.505n 3.3v 349.495n 3.3v 349.505n 3.3v 359.495n 3.3v 359.505n 3.3v 369.495n 3.3v 369.505n 3.3v 379.495n 3.3v 379.505n 0.0v 389.495n 0.0v 389.505n 0.0v 399.495n 0.0v 399.505n 3.3v 409.495n 3.3v 409.505n 3.3v 419.495n 3.3v 419.505n 3.3v 429.495n 3.3v 429.505n 3.3v 439.495n 3.3v 439.505n 3.3v 449.495n 3.3v 449.505n 3.3v 459.495n 3.3v 459.505n 3.3v 469.495n 3.3v 469.505n 3.3v 479.495n 3.3v 479.505n 3.3v 489.495n 3.3v 489.505n 3.3v 499.495n 3.3v 499.505n 0.0v 509.495n 0.0v 509.505n 0.0v 519.495n 0.0v 519.505n 0.0v 529.495n 0.0v 529.505n 0.0v 539.495n 0.0v 539.505n 0.0v 549.495n 0.0v 549.505n 0.0v 559.495n 0.0v 559.505n 0.0v 569.495n 0.0v 569.505n 0.0v 579.495n 0.0v 579.505n 0.0v 589.495n 0.0v 589.505n 0.0v 599.495n 0.0v 599.505n 0.0v 609.495n 0.0v 609.505n 0.0v 619.495n 0.0v 619.505n 0.0v 629.495n 0.0v 629.505n 0.0v 639.495n 0.0v 639.505n 0.0v 649.495n 0.0v 649.505n 0.0v 659.495n 0.0v 659.505n 0.0v 669.495n 0.0v 669.505n 0.0v 679.495n 0.0v 679.505n 0.0v 689.495n 0.0v 689.505n 0.0v 699.495n 0.0v 699.505n 0.0v 709.495n 0.0v 709.505n 3.3v 719.495n 3.3v 719.505n 0.0v 729.495n 0.0v 729.505n 0.0v 739.495n 0.0v 739.505n 0.0v 749.495n 0.0v 749.505n 0.0v 759.495n 0.0v 759.505n 0.0v 769.495n 0.0v 769.505n 0.0v 779.495n 0.0v 779.505n 0.0v 789.495n 0.0v 789.505n 0.0v 799.495n 0.0v 799.505n 0.0v 809.495n 0.0v 809.505n 0.0v 819.495n 0.0v 819.505n 0.0v 829.495n 0.0v 829.505n 0.0v 839.495n 0.0v 839.505n 0.0v 849.495n 0.0v 849.505n 0.0v 859.495n 0.0v 859.505n 0.0v 869.495n 0.0v 869.505n 0.0v 879.495n 0.0v 879.505n 0.0v 889.495n 0.0v 889.505n 0.0v 899.495n 0.0v 899.505n 0.0v 909.495n 0.0v 909.505n 0.0v 919.495n 0.0v 919.505n 0.0v 929.495n 0.0v 929.505n 0.0v 939.495n 0.0v 939.505n 0.0v 949.495n 0.0v 949.505n 3.3v 959.495n 3.3v 959.505n 3.3v 969.495n 3.3v 969.505n 3.3v 979.495n 3.3v 979.505n 3.3v 989.495n 3.3v 989.505n 3.3v 999.495n 3.3v 999.505n 3.3v 1009.495n 3.3v 1009.505n 3.3v 1019.495n 3.3v 1019.505n 3.3v 1029.495n 3.3v 1029.505n 3.3v 1039.495n 3.3v 1039.505n 3.3v 1049.495n 3.3v 1049.505n 0.0v 1059.495n 0.0v 1059.505n 0.0v 1069.495n 0.0v 1069.505n 0.0v 1079.495n 0.0v 1079.505n 0.0v 1089.495n 0.0v 1089.505n 0.0v 1099.495n 0.0v 1099.505n 3.3v 1109.495n 3.3v 1109.505n 3.3v 1119.495n 3.3v 1119.505n 3.3v 1129.495n 3.3v 1129.505n 3.3v 1139.495n 3.3v 1139.505n 3.3v 1149.495n 3.3v 1149.505n 3.3v 1159.495n 3.3v 1159.505n 3.3v 1169.495n 3.3v 1169.505n 3.3v 1179.495n 3.3v 1179.505n 3.3v 1189.495n 3.3v 1189.505n 3.3v 1199.495n 3.3v 1199.505n 3.3v 1209.495n 3.3v 1209.505n 0.0v 1219.495n 0.0v 1219.505n 0.0v 1229.495n 0.0v 1229.505n 0.0v 1239.495n 0.0v 1239.505n 0.0v 1249.495n 0.0v 1249.505n 3.3v 1259.495n 3.3v 1259.505n 3.3v 1269.495n 3.3v 1269.505n 3.3v 1279.495n 3.3v 1279.505n 3.3v 1289.495n 3.3v 1289.505n 3.3v 1299.495n 3.3v 1299.505n 3.3v 1309.495n 3.3v 1309.505n 0.0v 1319.495n 0.0v 1319.505n 0.0v 1329.495n 0.0v 1329.505n 0.0v 1339.495n 0.0v 1339.505n 0.0v 1349.495n 0.0v 1349.505n 0.0v 1359.495n 0.0v 1359.505n 0.0v 1369.495n 0.0v 1369.505n 0.0v 1379.495n 0.0v 1379.505n 0.0v 1389.495n 0.0v 1389.505n 0.0v 1399.495n 0.0v 1399.505n 0.0v 1409.495n 0.0v 1409.505n 0.0v 1419.495n 0.0v 1419.505n 0.0v 1429.495n 0.0v 1429.505n 0.0v 1439.495n 0.0v 1439.505n 3.3v 1449.495n 3.3v 1449.505n 3.3v 1459.495n 3.3v 1459.505n 3.3v 1469.495n 3.3v 1469.505n 3.3v 1479.495n 3.3v 1479.505n 3.3v 1489.495n 3.3v 1489.505n 0.0v 1499.495n 0.0v 1499.505n 0.0v 1509.495n 0.0v 1509.505n 0.0v 1519.495n 0.0v 1519.505n 0.0v 1529.495n 0.0v 1529.505n 0.0v 1539.495n 0.0v 1539.505n 0.0v 1549.495n 0.0v 1549.505n 0.0v 1559.495n 0.0v 1559.505n 3.3v 1569.495n 3.3v 1569.505n 3.3v 1579.495n 3.3v 1579.505n 3.3v 1589.495n 3.3v 1589.505n 3.3v 1599.495n 3.3v 1599.505n 0.0v 1609.495n 0.0v 1609.505n 0.0v 1619.495n 0.0v 1619.505n 0.0v 1629.495n 0.0v 1629.505n 0.0v 1639.495n 0.0v 1639.505n 0.0v 1649.495n 0.0v 1649.505n 0.0v 1659.495n 0.0v 1659.505n 0.0v 1669.495n 0.0v 1669.505n 0.0v 1679.495n 0.0v 1679.505n 0.0v 1689.495n 0.0v 1689.505n 0.0v 1699.495n 0.0v 1699.505n 0.0v 1709.495n 0.0v 1709.505n 0.0v 1719.495n 0.0v 1719.505n 0.0v 1729.495n 0.0v 1729.505n 3.3v 1739.495n 3.3v 1739.505n 3.3v 1749.495n 3.3v 1749.505n 3.3v 1759.495n 3.3v 1759.505n 3.3v 1769.495n 3.3v 1769.505n 0.0v 1779.495n 0.0v 1779.505n 0.0v 1789.495n 0.0v 1789.505n 0.0v 1799.495n 0.0v 1799.505n 0.0v 1809.495n 0.0v 1809.505n 0.0v 1819.495n 0.0v 1819.505n 3.3v 1829.495n 3.3v 1829.505n 3.3v 1839.495n 3.3v 1839.505n 3.3v 1849.495n 3.3v 1849.505n 3.3v 1859.495n 3.3v 1859.505n 0.0v 1869.495n 0.0v 1869.505n 0.0v 1879.495n 0.0v 1879.505n 0.0v 1889.495n 0.0v 1889.505n 0.0v 1899.495n 0.0v 1899.505n 0.0v 1909.495n 0.0v 1909.505n 0.0v 1919.495n 0.0v 1919.505n 0.0v 1929.495n 0.0v 1929.505n 0.0v 1939.495n 0.0v 1939.505n 0.0v 1949.495n 0.0v 1949.505n 0.0v 1959.495n 0.0v 1959.505n 0.0v 1969.495n 0.0v 1969.505n 0.0v 1979.495n 0.0v 1979.505n 3.3v 1989.495n 3.3v 1989.505n 3.3v 1999.495n 3.3v 1999.505n 0.0v 2009.495n 0.0v 2009.505n 0.0v 2019.495n 0.0v 2019.505n 3.3v 2029.495n 3.3v 2029.505n 3.3v 2039.495n 3.3v 2039.505n 3.3v 2049.495n 3.3v 2049.505n 3.3v )
* (time, data): [(0, 0), (10, 0), (20, 1), (30, 0), (40, 0), (50, 0), (60, 0), (70, 1), (80, 0), (90, 0), (100, 0), (110, 0), (120, 0), (130, 0), (140, 1), (150, 1), (160, 1), (170, 0), (180, 0), (190, 0), (200, 0), (210, 0), (220, 0), (230, 0), (240, 1), (250, 1), (260, 1), (270, 1), (280, 1), (290, 1), (300, 1), (310, 1), (320, 1), (330, 1), (340, 1), (350, 1), (360, 1), (370, 1), (380, 1), (390, 1), (400, 1), (410, 1), (420, 1), (430, 1), (440, 1), (450, 1), (460, 1), (470, 1), (480, 1), (490, 1), (500, 1), (510, 1), (520, 1), (530, 1), (540, 1), (550, 1), (560, 1), (570, 1), (580, 1), (590, 1), (600, 1), (610, 1), (620, 1), (630, 1), (640, 1), (650, 1), (660, 0), (670, 0), (680, 0), (690, 0), (700, 0), (710, 0), (720, 0), (730, 0), (740, 0), (750, 0), (760, 0), (770, 0), (780, 0), (790, 0), (800, 0), (810, 0), (820, 0), (830, 0), (840, 0), (850, 0), (860, 1), (870, 1), (880, 1), (890, 1), (900, 1), (910, 1), (920, 1), (930, 1), (940, 1), (950, 1), (960, 1), (970, 1), (980, 1), (990, 1), (1000, 1), (1010, 1), (1020, 1), (1030, 1), (1040, 0), (1050, 1), (1060, 1), (1070, 1), (1080, 1), (1090, 1), (1100, 1), (1110, 1), (1120, 1), (1130, 1), (1140, 1), (1150, 1), (1160, 1), (1170, 1), (1180, 1), (1190, 1), (1200, 1), (1210, 1), (1220, 1), (1230, 1), (1240, 1), (1250, 1), (1260, 1), (1270, 1), (1280, 1), (1290, 1), (1300, 1), (1310, 0), (1320, 0), (1330, 0), (1340, 0), (1350, 0), (1360, 0), (1370, 0), (1380, 0), (1390, 0), (1400, 0), (1410, 0), (1420, 0), (1430, 0), (1440, 1), (1450, 1), (1460, 1), (1470, 1), (1480, 1), (1490, 1), (1500, 1), (1510, 1), (1520, 1), (1530, 1), (1540, 1), (1550, 0), (1560, 1), (1570, 1), (1580, 1), (1590, 1), (1600, 1), (1610, 1), (1620, 1), (1630, 1), (1640, 1), (1650, 1), (1660, 1), (1670, 1), (1680, 1), (1690, 1), (1700, 1), (1710, 1), (1720, 1), (1730, 1), (1740, 1), (1750, 1), (1760, 1), (1770, 0), (1780, 0), (1790, 0), (1800, 0), (1810, 0), (1820, 1), (1830, 1), (1840, 1), (1850, 1), (1860, 0), (1870, 0), (1880, 1), (1890, 1), (1900, 1), (1910, 1), (1920, 1), (1930, 1), (1940, 1), (1950, 1), (1960, 1), (1970, 1), (1980, 0), (1990, 0), (2000, 0), (2010, 0), (2020, 0), (2030, 1), (2040, 1), (2050, 1)]
Vdin1_13  din1_13  0 PWL (0n 0.0v 9.495n 0.0v 9.505n 0.0v 19.495n 0.0v 19.505n 3.3v 29.495n 3.3v 29.505n 0.0v 39.495n 0.0v 39.505n 0.0v 49.495n 0.0v 49.505n 0.0v 59.495n 0.0v 59.505n 0.0v 69.495n 0.0v 69.505n 3.3v 79.495n 3.3v 79.505n 0.0v 89.495n 0.0v 89.505n 0.0v 99.495n 0.0v 99.505n 0.0v 109.495n 0.0v 109.505n 0.0v 119.495n 0.0v 119.505n 0.0v 129.495n 0.0v 129.505n 0.0v 139.495n 0.0v 139.505n 3.3v 149.495n 3.3v 149.505n 3.3v 159.495n 3.3v 159.505n 3.3v 169.495n 3.3v 169.505n 0.0v 179.495n 0.0v 179.505n 0.0v 189.495n 0.0v 189.505n 0.0v 199.495n 0.0v 199.505n 0.0v 209.495n 0.0v 209.505n 0.0v 219.495n 0.0v 219.505n 0.0v 229.495n 0.0v 229.505n 0.0v 239.495n 0.0v 239.505n 3.3v 249.495n 3.3v 249.505n 3.3v 259.495n 3.3v 259.505n 3.3v 269.495n 3.3v 269.505n 3.3v 279.495n 3.3v 279.505n 3.3v 289.495n 3.3v 289.505n 3.3v 299.495n 3.3v 299.505n 3.3v 309.495n 3.3v 309.505n 3.3v 319.495n 3.3v 319.505n 3.3v 329.495n 3.3v 329.505n 3.3v 339.495n 3.3v 339.505n 3.3v 349.495n 3.3v 349.505n 3.3v 359.495n 3.3v 359.505n 3.3v 369.495n 3.3v 369.505n 3.3v 379.495n 3.3v 379.505n 3.3v 389.495n 3.3v 389.505n 3.3v 399.495n 3.3v 399.505n 3.3v 409.495n 3.3v 409.505n 3.3v 419.495n 3.3v 419.505n 3.3v 429.495n 3.3v 429.505n 3.3v 439.495n 3.3v 439.505n 3.3v 449.495n 3.3v 449.505n 3.3v 459.495n 3.3v 459.505n 3.3v 469.495n 3.3v 469.505n 3.3v 479.495n 3.3v 479.505n 3.3v 489.495n 3.3v 489.505n 3.3v 499.495n 3.3v 499.505n 3.3v 509.495n 3.3v 509.505n 3.3v 519.495n 3.3v 519.505n 3.3v 529.495n 3.3v 529.505n 3.3v 539.495n 3.3v 539.505n 3.3v 549.495n 3.3v 549.505n 3.3v 559.495n 3.3v 559.505n 3.3v 569.495n 3.3v 569.505n 3.3v 579.495n 3.3v 579.505n 3.3v 589.495n 3.3v 589.505n 3.3v 599.495n 3.3v 599.505n 3.3v 609.495n 3.3v 609.505n 3.3v 619.495n 3.3v 619.505n 3.3v 629.495n 3.3v 629.505n 3.3v 639.495n 3.3v 639.505n 3.3v 649.495n 3.3v 649.505n 3.3v 659.495n 3.3v 659.505n 0.0v 669.495n 0.0v 669.505n 0.0v 679.495n 0.0v 679.505n 0.0v 689.495n 0.0v 689.505n 0.0v 699.495n 0.0v 699.505n 0.0v 709.495n 0.0v 709.505n 0.0v 719.495n 0.0v 719.505n 0.0v 729.495n 0.0v 729.505n 0.0v 739.495n 0.0v 739.505n 0.0v 749.495n 0.0v 749.505n 0.0v 759.495n 0.0v 759.505n 0.0v 769.495n 0.0v 769.505n 0.0v 779.495n 0.0v 779.505n 0.0v 789.495n 0.0v 789.505n 0.0v 799.495n 0.0v 799.505n 0.0v 809.495n 0.0v 809.505n 0.0v 819.495n 0.0v 819.505n 0.0v 829.495n 0.0v 829.505n 0.0v 839.495n 0.0v 839.505n 0.0v 849.495n 0.0v 849.505n 0.0v 859.495n 0.0v 859.505n 3.3v 869.495n 3.3v 869.505n 3.3v 879.495n 3.3v 879.505n 3.3v 889.495n 3.3v 889.505n 3.3v 899.495n 3.3v 899.505n 3.3v 909.495n 3.3v 909.505n 3.3v 919.495n 3.3v 919.505n 3.3v 929.495n 3.3v 929.505n 3.3v 939.495n 3.3v 939.505n 3.3v 949.495n 3.3v 949.505n 3.3v 959.495n 3.3v 959.505n 3.3v 969.495n 3.3v 969.505n 3.3v 979.495n 3.3v 979.505n 3.3v 989.495n 3.3v 989.505n 3.3v 999.495n 3.3v 999.505n 3.3v 1009.495n 3.3v 1009.505n 3.3v 1019.495n 3.3v 1019.505n 3.3v 1029.495n 3.3v 1029.505n 3.3v 1039.495n 3.3v 1039.505n 0.0v 1049.495n 0.0v 1049.505n 3.3v 1059.495n 3.3v 1059.505n 3.3v 1069.495n 3.3v 1069.505n 3.3v 1079.495n 3.3v 1079.505n 3.3v 1089.495n 3.3v 1089.505n 3.3v 1099.495n 3.3v 1099.505n 3.3v 1109.495n 3.3v 1109.505n 3.3v 1119.495n 3.3v 1119.505n 3.3v 1129.495n 3.3v 1129.505n 3.3v 1139.495n 3.3v 1139.505n 3.3v 1149.495n 3.3v 1149.505n 3.3v 1159.495n 3.3v 1159.505n 3.3v 1169.495n 3.3v 1169.505n 3.3v 1179.495n 3.3v 1179.505n 3.3v 1189.495n 3.3v 1189.505n 3.3v 1199.495n 3.3v 1199.505n 3.3v 1209.495n 3.3v 1209.505n 3.3v 1219.495n 3.3v 1219.505n 3.3v 1229.495n 3.3v 1229.505n 3.3v 1239.495n 3.3v 1239.505n 3.3v 1249.495n 3.3v 1249.505n 3.3v 1259.495n 3.3v 1259.505n 3.3v 1269.495n 3.3v 1269.505n 3.3v 1279.495n 3.3v 1279.505n 3.3v 1289.495n 3.3v 1289.505n 3.3v 1299.495n 3.3v 1299.505n 3.3v 1309.495n 3.3v 1309.505n 0.0v 1319.495n 0.0v 1319.505n 0.0v 1329.495n 0.0v 1329.505n 0.0v 1339.495n 0.0v 1339.505n 0.0v 1349.495n 0.0v 1349.505n 0.0v 1359.495n 0.0v 1359.505n 0.0v 1369.495n 0.0v 1369.505n 0.0v 1379.495n 0.0v 1379.505n 0.0v 1389.495n 0.0v 1389.505n 0.0v 1399.495n 0.0v 1399.505n 0.0v 1409.495n 0.0v 1409.505n 0.0v 1419.495n 0.0v 1419.505n 0.0v 1429.495n 0.0v 1429.505n 0.0v 1439.495n 0.0v 1439.505n 3.3v 1449.495n 3.3v 1449.505n 3.3v 1459.495n 3.3v 1459.505n 3.3v 1469.495n 3.3v 1469.505n 3.3v 1479.495n 3.3v 1479.505n 3.3v 1489.495n 3.3v 1489.505n 3.3v 1499.495n 3.3v 1499.505n 3.3v 1509.495n 3.3v 1509.505n 3.3v 1519.495n 3.3v 1519.505n 3.3v 1529.495n 3.3v 1529.505n 3.3v 1539.495n 3.3v 1539.505n 3.3v 1549.495n 3.3v 1549.505n 0.0v 1559.495n 0.0v 1559.505n 3.3v 1569.495n 3.3v 1569.505n 3.3v 1579.495n 3.3v 1579.505n 3.3v 1589.495n 3.3v 1589.505n 3.3v 1599.495n 3.3v 1599.505n 3.3v 1609.495n 3.3v 1609.505n 3.3v 1619.495n 3.3v 1619.505n 3.3v 1629.495n 3.3v 1629.505n 3.3v 1639.495n 3.3v 1639.505n 3.3v 1649.495n 3.3v 1649.505n 3.3v 1659.495n 3.3v 1659.505n 3.3v 1669.495n 3.3v 1669.505n 3.3v 1679.495n 3.3v 1679.505n 3.3v 1689.495n 3.3v 1689.505n 3.3v 1699.495n 3.3v 1699.505n 3.3v 1709.495n 3.3v 1709.505n 3.3v 1719.495n 3.3v 1719.505n 3.3v 1729.495n 3.3v 1729.505n 3.3v 1739.495n 3.3v 1739.505n 3.3v 1749.495n 3.3v 1749.505n 3.3v 1759.495n 3.3v 1759.505n 3.3v 1769.495n 3.3v 1769.505n 0.0v 1779.495n 0.0v 1779.505n 0.0v 1789.495n 0.0v 1789.505n 0.0v 1799.495n 0.0v 1799.505n 0.0v 1809.495n 0.0v 1809.505n 0.0v 1819.495n 0.0v 1819.505n 3.3v 1829.495n 3.3v 1829.505n 3.3v 1839.495n 3.3v 1839.505n 3.3v 1849.495n 3.3v 1849.505n 3.3v 1859.495n 3.3v 1859.505n 0.0v 1869.495n 0.0v 1869.505n 0.0v 1879.495n 0.0v 1879.505n 3.3v 1889.495n 3.3v 1889.505n 3.3v 1899.495n 3.3v 1899.505n 3.3v 1909.495n 3.3v 1909.505n 3.3v 1919.495n 3.3v 1919.505n 3.3v 1929.495n 3.3v 1929.505n 3.3v 1939.495n 3.3v 1939.505n 3.3v 1949.495n 3.3v 1949.505n 3.3v 1959.495n 3.3v 1959.505n 3.3v 1969.495n 3.3v 1969.505n 3.3v 1979.495n 3.3v 1979.505n 0.0v 1989.495n 0.0v 1989.505n 0.0v 1999.495n 0.0v 1999.505n 0.0v 2009.495n 0.0v 2009.505n 0.0v 2019.495n 0.0v 2019.505n 0.0v 2029.495n 0.0v 2029.505n 3.3v 2039.495n 3.3v 2039.505n 3.3v 2049.495n 3.3v 2049.505n 3.3v )
* (time, data): [(0, 0), (10, 0), (20, 0), (30, 1), (40, 1), (50, 1), (60, 1), (70, 0), (80, 0), (90, 0), (100, 0), (110, 0), (120, 1), (130, 1), (140, 0), (150, 0), (160, 0), (170, 1), (180, 1), (190, 1), (200, 1), (210, 1), (220, 1), (230, 1), (240, 1), (250, 1), (260, 1), (270, 1), (280, 1), (290, 1), (300, 1), (310, 1), (320, 1), (330, 1), (340, 1), (350, 1), (360, 1), (370, 0), (380, 0), (390, 0), (400, 0), (410, 0), (420, 0), (430, 0), (440, 0), (450, 0), (460, 0), (470, 0), (480, 0), (490, 0), (500, 1), (510, 1), (520, 1), (530, 1), (540, 1), (550, 1), (560, 1), (570, 1), (580, 1), (590, 1), (600, 1), (610, 1), (620, 1), (630, 1), (640, 1), (650, 1), (660, 0), (670, 0), (680, 0), (690, 0), (700, 0), (710, 1), (720, 1), (730, 1), (740, 1), (750, 1), (760, 1), (770, 1), (780, 1), (790, 1), (800, 1), (810, 1), (820, 1), (830, 1), (840, 1), (850, 1), (860, 0), (870, 0), (880, 0), (890, 0), (900, 0), (910, 0), (920, 0), (930, 0), (940, 0), (950, 1), (960, 1), (970, 1), (980, 1), (990, 1), (1000, 1), (1010, 1), (1020, 1), (1030, 1), (1040, 1), (1050, 0), (1060, 0), (1070, 0), (1080, 0), (1090, 0), (1100, 0), (1110, 1), (1120, 1), (1130, 1), (1140, 0), (1150, 0), (1160, 0), (1170, 0), (1180, 0), (1190, 0), (1200, 0), (1210, 1), (1220, 1), (1230, 1), (1240, 1), (1250, 1), (1260, 1), (1270, 1), (1280, 1), (1290, 1), (1300, 1), (1310, 1), (1320, 1), (1330, 1), (1340, 1), (1350, 1), (1360, 1), (1370, 1), (1380, 1), (1390, 1), (1400, 1), (1410, 1), (1420, 1), (1430, 1), (1440, 1), (1450, 1), (1460, 1), (1470, 1), (1480, 1), (1490, 1), (1500, 1), (1510, 1), (1520, 1), (1530, 1), (1540, 1), (1550, 1), (1560, 0), (1570, 0), (1580, 0), (1590, 0), (1600, 0), (1610, 0), (1620, 0), (1630, 0), (1640, 0), (1650, 0), (1660, 0), (1670, 0), (1680, 0), (1690, 0), (1700, 0), (1710, 0), (1720, 0), (1730, 1), (1740, 1), (1750, 1), (1760, 1), (1770, 1), (1780, 1), (1790, 1), (1800, 1), (1810, 1), (1820, 1), (1830, 1), (1840, 1), (1850, 1), (1860, 1), (1870, 1), (1880, 1), (1890, 1), (1900, 1), (1910, 0), (1920, 0), (1930, 0), (1940, 0), (1950, 0), (1960, 0), (1970, 0), (1980, 1), (1990, 1), (2000, 0), (2010, 0), (2020, 1), (2030, 1), (2040, 1), (2050, 1)]
Vdin1_14  din1_14  0 PWL (0n 0.0v 9.495n 0.0v 9.505n 0.0v 19.495n 0.0v 19.505n 0.0v 29.495n 0.0v 29.505n 3.3v 39.495n 3.3v 39.505n 3.3v 49.495n 3.3v 49.505n 3.3v 59.495n 3.3v 59.505n 3.3v 69.495n 3.3v 69.505n 0.0v 79.495n 0.0v 79.505n 0.0v 89.495n 0.0v 89.505n 0.0v 99.495n 0.0v 99.505n 0.0v 109.495n 0.0v 109.505n 0.0v 119.495n 0.0v 119.505n 3.3v 129.495n 3.3v 129.505n 3.3v 139.495n 3.3v 139.505n 0.0v 149.495n 0.0v 149.505n 0.0v 159.495n 0.0v 159.505n 0.0v 169.495n 0.0v 169.505n 3.3v 179.495n 3.3v 179.505n 3.3v 189.495n 3.3v 189.505n 3.3v 199.495n 3.3v 199.505n 3.3v 209.495n 3.3v 209.505n 3.3v 219.495n 3.3v 219.505n 3.3v 229.495n 3.3v 229.505n 3.3v 239.495n 3.3v 239.505n 3.3v 249.495n 3.3v 249.505n 3.3v 259.495n 3.3v 259.505n 3.3v 269.495n 3.3v 269.505n 3.3v 279.495n 3.3v 279.505n 3.3v 289.495n 3.3v 289.505n 3.3v 299.495n 3.3v 299.505n 3.3v 309.495n 3.3v 309.505n 3.3v 319.495n 3.3v 319.505n 3.3v 329.495n 3.3v 329.505n 3.3v 339.495n 3.3v 339.505n 3.3v 349.495n 3.3v 349.505n 3.3v 359.495n 3.3v 359.505n 3.3v 369.495n 3.3v 369.505n 0.0v 379.495n 0.0v 379.505n 0.0v 389.495n 0.0v 389.505n 0.0v 399.495n 0.0v 399.505n 0.0v 409.495n 0.0v 409.505n 0.0v 419.495n 0.0v 419.505n 0.0v 429.495n 0.0v 429.505n 0.0v 439.495n 0.0v 439.505n 0.0v 449.495n 0.0v 449.505n 0.0v 459.495n 0.0v 459.505n 0.0v 469.495n 0.0v 469.505n 0.0v 479.495n 0.0v 479.505n 0.0v 489.495n 0.0v 489.505n 0.0v 499.495n 0.0v 499.505n 3.3v 509.495n 3.3v 509.505n 3.3v 519.495n 3.3v 519.505n 3.3v 529.495n 3.3v 529.505n 3.3v 539.495n 3.3v 539.505n 3.3v 549.495n 3.3v 549.505n 3.3v 559.495n 3.3v 559.505n 3.3v 569.495n 3.3v 569.505n 3.3v 579.495n 3.3v 579.505n 3.3v 589.495n 3.3v 589.505n 3.3v 599.495n 3.3v 599.505n 3.3v 609.495n 3.3v 609.505n 3.3v 619.495n 3.3v 619.505n 3.3v 629.495n 3.3v 629.505n 3.3v 639.495n 3.3v 639.505n 3.3v 649.495n 3.3v 649.505n 3.3v 659.495n 3.3v 659.505n 0.0v 669.495n 0.0v 669.505n 0.0v 679.495n 0.0v 679.505n 0.0v 689.495n 0.0v 689.505n 0.0v 699.495n 0.0v 699.505n 0.0v 709.495n 0.0v 709.505n 3.3v 719.495n 3.3v 719.505n 3.3v 729.495n 3.3v 729.505n 3.3v 739.495n 3.3v 739.505n 3.3v 749.495n 3.3v 749.505n 3.3v 759.495n 3.3v 759.505n 3.3v 769.495n 3.3v 769.505n 3.3v 779.495n 3.3v 779.505n 3.3v 789.495n 3.3v 789.505n 3.3v 799.495n 3.3v 799.505n 3.3v 809.495n 3.3v 809.505n 3.3v 819.495n 3.3v 819.505n 3.3v 829.495n 3.3v 829.505n 3.3v 839.495n 3.3v 839.505n 3.3v 849.495n 3.3v 849.505n 3.3v 859.495n 3.3v 859.505n 0.0v 869.495n 0.0v 869.505n 0.0v 879.495n 0.0v 879.505n 0.0v 889.495n 0.0v 889.505n 0.0v 899.495n 0.0v 899.505n 0.0v 909.495n 0.0v 909.505n 0.0v 919.495n 0.0v 919.505n 0.0v 929.495n 0.0v 929.505n 0.0v 939.495n 0.0v 939.505n 0.0v 949.495n 0.0v 949.505n 3.3v 959.495n 3.3v 959.505n 3.3v 969.495n 3.3v 969.505n 3.3v 979.495n 3.3v 979.505n 3.3v 989.495n 3.3v 989.505n 3.3v 999.495n 3.3v 999.505n 3.3v 1009.495n 3.3v 1009.505n 3.3v 1019.495n 3.3v 1019.505n 3.3v 1029.495n 3.3v 1029.505n 3.3v 1039.495n 3.3v 1039.505n 3.3v 1049.495n 3.3v 1049.505n 0.0v 1059.495n 0.0v 1059.505n 0.0v 1069.495n 0.0v 1069.505n 0.0v 1079.495n 0.0v 1079.505n 0.0v 1089.495n 0.0v 1089.505n 0.0v 1099.495n 0.0v 1099.505n 0.0v 1109.495n 0.0v 1109.505n 3.3v 1119.495n 3.3v 1119.505n 3.3v 1129.495n 3.3v 1129.505n 3.3v 1139.495n 3.3v 1139.505n 0.0v 1149.495n 0.0v 1149.505n 0.0v 1159.495n 0.0v 1159.505n 0.0v 1169.495n 0.0v 1169.505n 0.0v 1179.495n 0.0v 1179.505n 0.0v 1189.495n 0.0v 1189.505n 0.0v 1199.495n 0.0v 1199.505n 0.0v 1209.495n 0.0v 1209.505n 3.3v 1219.495n 3.3v 1219.505n 3.3v 1229.495n 3.3v 1229.505n 3.3v 1239.495n 3.3v 1239.505n 3.3v 1249.495n 3.3v 1249.505n 3.3v 1259.495n 3.3v 1259.505n 3.3v 1269.495n 3.3v 1269.505n 3.3v 1279.495n 3.3v 1279.505n 3.3v 1289.495n 3.3v 1289.505n 3.3v 1299.495n 3.3v 1299.505n 3.3v 1309.495n 3.3v 1309.505n 3.3v 1319.495n 3.3v 1319.505n 3.3v 1329.495n 3.3v 1329.505n 3.3v 1339.495n 3.3v 1339.505n 3.3v 1349.495n 3.3v 1349.505n 3.3v 1359.495n 3.3v 1359.505n 3.3v 1369.495n 3.3v 1369.505n 3.3v 1379.495n 3.3v 1379.505n 3.3v 1389.495n 3.3v 1389.505n 3.3v 1399.495n 3.3v 1399.505n 3.3v 1409.495n 3.3v 1409.505n 3.3v 1419.495n 3.3v 1419.505n 3.3v 1429.495n 3.3v 1429.505n 3.3v 1439.495n 3.3v 1439.505n 3.3v 1449.495n 3.3v 1449.505n 3.3v 1459.495n 3.3v 1459.505n 3.3v 1469.495n 3.3v 1469.505n 3.3v 1479.495n 3.3v 1479.505n 3.3v 1489.495n 3.3v 1489.505n 3.3v 1499.495n 3.3v 1499.505n 3.3v 1509.495n 3.3v 1509.505n 3.3v 1519.495n 3.3v 1519.505n 3.3v 1529.495n 3.3v 1529.505n 3.3v 1539.495n 3.3v 1539.505n 3.3v 1549.495n 3.3v 1549.505n 3.3v 1559.495n 3.3v 1559.505n 0.0v 1569.495n 0.0v 1569.505n 0.0v 1579.495n 0.0v 1579.505n 0.0v 1589.495n 0.0v 1589.505n 0.0v 1599.495n 0.0v 1599.505n 0.0v 1609.495n 0.0v 1609.505n 0.0v 1619.495n 0.0v 1619.505n 0.0v 1629.495n 0.0v 1629.505n 0.0v 1639.495n 0.0v 1639.505n 0.0v 1649.495n 0.0v 1649.505n 0.0v 1659.495n 0.0v 1659.505n 0.0v 1669.495n 0.0v 1669.505n 0.0v 1679.495n 0.0v 1679.505n 0.0v 1689.495n 0.0v 1689.505n 0.0v 1699.495n 0.0v 1699.505n 0.0v 1709.495n 0.0v 1709.505n 0.0v 1719.495n 0.0v 1719.505n 0.0v 1729.495n 0.0v 1729.505n 3.3v 1739.495n 3.3v 1739.505n 3.3v 1749.495n 3.3v 1749.505n 3.3v 1759.495n 3.3v 1759.505n 3.3v 1769.495n 3.3v 1769.505n 3.3v 1779.495n 3.3v 1779.505n 3.3v 1789.495n 3.3v 1789.505n 3.3v 1799.495n 3.3v 1799.505n 3.3v 1809.495n 3.3v 1809.505n 3.3v 1819.495n 3.3v 1819.505n 3.3v 1829.495n 3.3v 1829.505n 3.3v 1839.495n 3.3v 1839.505n 3.3v 1849.495n 3.3v 1849.505n 3.3v 1859.495n 3.3v 1859.505n 3.3v 1869.495n 3.3v 1869.505n 3.3v 1879.495n 3.3v 1879.505n 3.3v 1889.495n 3.3v 1889.505n 3.3v 1899.495n 3.3v 1899.505n 3.3v 1909.495n 3.3v 1909.505n 0.0v 1919.495n 0.0v 1919.505n 0.0v 1929.495n 0.0v 1929.505n 0.0v 1939.495n 0.0v 1939.505n 0.0v 1949.495n 0.0v 1949.505n 0.0v 1959.495n 0.0v 1959.505n 0.0v 1969.495n 0.0v 1969.505n 0.0v 1979.495n 0.0v 1979.505n 3.3v 1989.495n 3.3v 1989.505n 3.3v 1999.495n 3.3v 1999.505n 0.0v 2009.495n 0.0v 2009.505n 0.0v 2019.495n 0.0v 2019.505n 3.3v 2029.495n 3.3v 2029.505n 3.3v 2039.495n 3.3v 2039.505n 3.3v 2049.495n 3.3v 2049.505n 3.3v )
* (time, data): [(0, 0), (10, 1), (20, 1), (30, 0), (40, 0), (50, 0), (60, 0), (70, 1), (80, 0), (90, 0), (100, 0), (110, 0), (120, 1), (130, 1), (140, 1), (150, 1), (160, 1), (170, 1), (180, 1), (190, 1), (200, 1), (210, 1), (220, 1), (230, 1), (240, 1), (250, 1), (260, 1), (270, 1), (280, 1), (290, 1), (300, 1), (310, 1), (320, 1), (330, 1), (340, 1), (350, 1), (360, 1), (370, 1), (380, 1), (390, 1), (400, 1), (410, 1), (420, 1), (430, 1), (440, 1), (450, 1), (460, 1), (470, 1), (480, 1), (490, 1), (500, 1), (510, 1), (520, 1), (530, 1), (540, 1), (550, 1), (560, 1), (570, 1), (580, 1), (590, 1), (600, 1), (610, 1), (620, 1), (630, 1), (640, 1), (650, 1), (660, 1), (670, 1), (680, 1), (690, 1), (700, 1), (710, 1), (720, 0), (730, 0), (740, 0), (750, 0), (760, 0), (770, 0), (780, 0), (790, 0), (800, 0), (810, 0), (820, 0), (830, 0), (840, 0), (850, 0), (860, 0), (870, 0), (880, 0), (890, 0), (900, 0), (910, 0), (920, 0), (930, 0), (940, 0), (950, 1), (960, 1), (970, 1), (980, 1), (990, 1), (1000, 1), (1010, 1), (1020, 1), (1030, 1), (1040, 0), (1050, 1), (1060, 1), (1070, 1), (1080, 1), (1090, 1), (1100, 0), (1110, 0), (1120, 0), (1130, 0), (1140, 0), (1150, 0), (1160, 0), (1170, 0), (1180, 0), (1190, 0), (1200, 0), (1210, 0), (1220, 0), (1230, 0), (1240, 0), (1250, 1), (1260, 1), (1270, 1), (1280, 1), (1290, 1), (1300, 1), (1310, 0), (1320, 0), (1330, 0), (1340, 0), (1350, 0), (1360, 0), (1370, 0), (1380, 0), (1390, 0), (1400, 0), (1410, 0), (1420, 0), (1430, 0), (1440, 1), (1450, 1), (1460, 1), (1470, 1), (1480, 1), (1490, 0), (1500, 0), (1510, 0), (1520, 0), (1530, 0), (1540, 0), (1550, 0), (1560, 1), (1570, 1), (1580, 1), (1590, 1), (1600, 1), (1610, 1), (1620, 1), (1630, 1), (1640, 1), (1650, 1), (1660, 1), (1670, 1), (1680, 1), (1690, 1), (1700, 1), (1710, 1), (1720, 1), (1730, 0), (1740, 0), (1750, 0), (1760, 0), (1770, 1), (1780, 1), (1790, 1), (1800, 1), (1810, 1), (1820, 1), (1830, 1), (1840, 1), (1850, 1), (1860, 0), (1870, 0), (1880, 0), (1890, 0), (1900, 0), (1910, 0), (1920, 0), (1930, 0), (1940, 1), (1950, 1), (1960, 1), (1970, 1), (1980, 0), (1990, 0), (2000, 1), (2010, 1), (2020, 0), (2030, 0), (2040, 0), (2050, 0)]
Vdin1_15  din1_15  0 PWL (0n 0.0v 9.495n 0.0v 9.505n 3.3v 19.495n 3.3v 19.505n 3.3v 29.495n 3.3v 29.505n 0.0v 39.495n 0.0v 39.505n 0.0v 49.495n 0.0v 49.505n 0.0v 59.495n 0.0v 59.505n 0.0v 69.495n 0.0v 69.505n 3.3v 79.495n 3.3v 79.505n 0.0v 89.495n 0.0v 89.505n 0.0v 99.495n 0.0v 99.505n 0.0v 109.495n 0.0v 109.505n 0.0v 119.495n 0.0v 119.505n 3.3v 129.495n 3.3v 129.505n 3.3v 139.495n 3.3v 139.505n 3.3v 149.495n 3.3v 149.505n 3.3v 159.495n 3.3v 159.505n 3.3v 169.495n 3.3v 169.505n 3.3v 179.495n 3.3v 179.505n 3.3v 189.495n 3.3v 189.505n 3.3v 199.495n 3.3v 199.505n 3.3v 209.495n 3.3v 209.505n 3.3v 219.495n 3.3v 219.505n 3.3v 229.495n 3.3v 229.505n 3.3v 239.495n 3.3v 239.505n 3.3v 249.495n 3.3v 249.505n 3.3v 259.495n 3.3v 259.505n 3.3v 269.495n 3.3v 269.505n 3.3v 279.495n 3.3v 279.505n 3.3v 289.495n 3.3v 289.505n 3.3v 299.495n 3.3v 299.505n 3.3v 309.495n 3.3v 309.505n 3.3v 319.495n 3.3v 319.505n 3.3v 329.495n 3.3v 329.505n 3.3v 339.495n 3.3v 339.505n 3.3v 349.495n 3.3v 349.505n 3.3v 359.495n 3.3v 359.505n 3.3v 369.495n 3.3v 369.505n 3.3v 379.495n 3.3v 379.505n 3.3v 389.495n 3.3v 389.505n 3.3v 399.495n 3.3v 399.505n 3.3v 409.495n 3.3v 409.505n 3.3v 419.495n 3.3v 419.505n 3.3v 429.495n 3.3v 429.505n 3.3v 439.495n 3.3v 439.505n 3.3v 449.495n 3.3v 449.505n 3.3v 459.495n 3.3v 459.505n 3.3v 469.495n 3.3v 469.505n 3.3v 479.495n 3.3v 479.505n 3.3v 489.495n 3.3v 489.505n 3.3v 499.495n 3.3v 499.505n 3.3v 509.495n 3.3v 509.505n 3.3v 519.495n 3.3v 519.505n 3.3v 529.495n 3.3v 529.505n 3.3v 539.495n 3.3v 539.505n 3.3v 549.495n 3.3v 549.505n 3.3v 559.495n 3.3v 559.505n 3.3v 569.495n 3.3v 569.505n 3.3v 579.495n 3.3v 579.505n 3.3v 589.495n 3.3v 589.505n 3.3v 599.495n 3.3v 599.505n 3.3v 609.495n 3.3v 609.505n 3.3v 619.495n 3.3v 619.505n 3.3v 629.495n 3.3v 629.505n 3.3v 639.495n 3.3v 639.505n 3.3v 649.495n 3.3v 649.505n 3.3v 659.495n 3.3v 659.505n 3.3v 669.495n 3.3v 669.505n 3.3v 679.495n 3.3v 679.505n 3.3v 689.495n 3.3v 689.505n 3.3v 699.495n 3.3v 699.505n 3.3v 709.495n 3.3v 709.505n 3.3v 719.495n 3.3v 719.505n 0.0v 729.495n 0.0v 729.505n 0.0v 739.495n 0.0v 739.505n 0.0v 749.495n 0.0v 749.505n 0.0v 759.495n 0.0v 759.505n 0.0v 769.495n 0.0v 769.505n 0.0v 779.495n 0.0v 779.505n 0.0v 789.495n 0.0v 789.505n 0.0v 799.495n 0.0v 799.505n 0.0v 809.495n 0.0v 809.505n 0.0v 819.495n 0.0v 819.505n 0.0v 829.495n 0.0v 829.505n 0.0v 839.495n 0.0v 839.505n 0.0v 849.495n 0.0v 849.505n 0.0v 859.495n 0.0v 859.505n 0.0v 869.495n 0.0v 869.505n 0.0v 879.495n 0.0v 879.505n 0.0v 889.495n 0.0v 889.505n 0.0v 899.495n 0.0v 899.505n 0.0v 909.495n 0.0v 909.505n 0.0v 919.495n 0.0v 919.505n 0.0v 929.495n 0.0v 929.505n 0.0v 939.495n 0.0v 939.505n 0.0v 949.495n 0.0v 949.505n 3.3v 959.495n 3.3v 959.505n 3.3v 969.495n 3.3v 969.505n 3.3v 979.495n 3.3v 979.505n 3.3v 989.495n 3.3v 989.505n 3.3v 999.495n 3.3v 999.505n 3.3v 1009.495n 3.3v 1009.505n 3.3v 1019.495n 3.3v 1019.505n 3.3v 1029.495n 3.3v 1029.505n 3.3v 1039.495n 3.3v 1039.505n 0.0v 1049.495n 0.0v 1049.505n 3.3v 1059.495n 3.3v 1059.505n 3.3v 1069.495n 3.3v 1069.505n 3.3v 1079.495n 3.3v 1079.505n 3.3v 1089.495n 3.3v 1089.505n 3.3v 1099.495n 3.3v 1099.505n 0.0v 1109.495n 0.0v 1109.505n 0.0v 1119.495n 0.0v 1119.505n 0.0v 1129.495n 0.0v 1129.505n 0.0v 1139.495n 0.0v 1139.505n 0.0v 1149.495n 0.0v 1149.505n 0.0v 1159.495n 0.0v 1159.505n 0.0v 1169.495n 0.0v 1169.505n 0.0v 1179.495n 0.0v 1179.505n 0.0v 1189.495n 0.0v 1189.505n 0.0v 1199.495n 0.0v 1199.505n 0.0v 1209.495n 0.0v 1209.505n 0.0v 1219.495n 0.0v 1219.505n 0.0v 1229.495n 0.0v 1229.505n 0.0v 1239.495n 0.0v 1239.505n 0.0v 1249.495n 0.0v 1249.505n 3.3v 1259.495n 3.3v 1259.505n 3.3v 1269.495n 3.3v 1269.505n 3.3v 1279.495n 3.3v 1279.505n 3.3v 1289.495n 3.3v 1289.505n 3.3v 1299.495n 3.3v 1299.505n 3.3v 1309.495n 3.3v 1309.505n 0.0v 1319.495n 0.0v 1319.505n 0.0v 1329.495n 0.0v 1329.505n 0.0v 1339.495n 0.0v 1339.505n 0.0v 1349.495n 0.0v 1349.505n 0.0v 1359.495n 0.0v 1359.505n 0.0v 1369.495n 0.0v 1369.505n 0.0v 1379.495n 0.0v 1379.505n 0.0v 1389.495n 0.0v 1389.505n 0.0v 1399.495n 0.0v 1399.505n 0.0v 1409.495n 0.0v 1409.505n 0.0v 1419.495n 0.0v 1419.505n 0.0v 1429.495n 0.0v 1429.505n 0.0v 1439.495n 0.0v 1439.505n 3.3v 1449.495n 3.3v 1449.505n 3.3v 1459.495n 3.3v 1459.505n 3.3v 1469.495n 3.3v 1469.505n 3.3v 1479.495n 3.3v 1479.505n 3.3v 1489.495n 3.3v 1489.505n 0.0v 1499.495n 0.0v 1499.505n 0.0v 1509.495n 0.0v 1509.505n 0.0v 1519.495n 0.0v 1519.505n 0.0v 1529.495n 0.0v 1529.505n 0.0v 1539.495n 0.0v 1539.505n 0.0v 1549.495n 0.0v 1549.505n 0.0v 1559.495n 0.0v 1559.505n 3.3v 1569.495n 3.3v 1569.505n 3.3v 1579.495n 3.3v 1579.505n 3.3v 1589.495n 3.3v 1589.505n 3.3v 1599.495n 3.3v 1599.505n 3.3v 1609.495n 3.3v 1609.505n 3.3v 1619.495n 3.3v 1619.505n 3.3v 1629.495n 3.3v 1629.505n 3.3v 1639.495n 3.3v 1639.505n 3.3v 1649.495n 3.3v 1649.505n 3.3v 1659.495n 3.3v 1659.505n 3.3v 1669.495n 3.3v 1669.505n 3.3v 1679.495n 3.3v 1679.505n 3.3v 1689.495n 3.3v 1689.505n 3.3v 1699.495n 3.3v 1699.505n 3.3v 1709.495n 3.3v 1709.505n 3.3v 1719.495n 3.3v 1719.505n 3.3v 1729.495n 3.3v 1729.505n 0.0v 1739.495n 0.0v 1739.505n 0.0v 1749.495n 0.0v 1749.505n 0.0v 1759.495n 0.0v 1759.505n 0.0v 1769.495n 0.0v 1769.505n 3.3v 1779.495n 3.3v 1779.505n 3.3v 1789.495n 3.3v 1789.505n 3.3v 1799.495n 3.3v 1799.505n 3.3v 1809.495n 3.3v 1809.505n 3.3v 1819.495n 3.3v 1819.505n 3.3v 1829.495n 3.3v 1829.505n 3.3v 1839.495n 3.3v 1839.505n 3.3v 1849.495n 3.3v 1849.505n 3.3v 1859.495n 3.3v 1859.505n 0.0v 1869.495n 0.0v 1869.505n 0.0v 1879.495n 0.0v 1879.505n 0.0v 1889.495n 0.0v 1889.505n 0.0v 1899.495n 0.0v 1899.505n 0.0v 1909.495n 0.0v 1909.505n 0.0v 1919.495n 0.0v 1919.505n 0.0v 1929.495n 0.0v 1929.505n 0.0v 1939.495n 0.0v 1939.505n 3.3v 1949.495n 3.3v 1949.505n 3.3v 1959.495n 3.3v 1959.505n 3.3v 1969.495n 3.3v 1969.505n 3.3v 1979.495n 3.3v 1979.505n 0.0v 1989.495n 0.0v 1989.505n 0.0v 1999.495n 0.0v 1999.505n 3.3v 2009.495n 3.3v 2009.505n 3.3v 2019.495n 3.3v 2019.505n 0.0v 2029.495n 0.0v 2029.505n 0.0v 2039.495n 0.0v 2039.505n 0.0v 2049.495n 0.0v 2049.505n 0.0v )
* (time, data): [(0, 0), (10, 0), (20, 0), (30, 0), (40, 0), (50, 0), (60, 0), (70, 1), (80, 0), (90, 0), (100, 0), (110, 0), (120, 0), (130, 0), (140, 1), (150, 1), (160, 1), (170, 0), (180, 0), (190, 0), (200, 0), (210, 0), (220, 0), (230, 0), (240, 0), (250, 0), (260, 0), (270, 0), (280, 0), (290, 0), (300, 0), (310, 0), (320, 0), (330, 0), (340, 0), (350, 0), (360, 0), (370, 1), (380, 0), (390, 0), (400, 0), (410, 0), (420, 0), (430, 0), (440, 0), (450, 0), (460, 0), (470, 0), (480, 0), (490, 0), (500, 0), (510, 0), (520, 0), (530, 0), (540, 0), (550, 0), (560, 0), (570, 0), (580, 0), (590, 0), (600, 0), (610, 0), (620, 0), (630, 0), (640, 0), (650, 0), (660, 0), (670, 0), (680, 1), (690, 1), (700, 1), (710, 1), (720, 0), (730, 0), (740, 0), (750, 0), (760, 0), (770, 0), (780, 0), (790, 0), (800, 0), (810, 0), (820, 0), (830, 0), (840, 0), (850, 0), (860, 1), (870, 1), (880, 1), (890, 1), (900, 1), (910, 1), (920, 1), (930, 1), (940, 1), (950, 1), (960, 1), (970, 1), (980, 1), (990, 1), (1000, 1), (1010, 1), (1020, 1), (1030, 1), (1040, 1), (1050, 0), (1060, 0), (1070, 0), (1080, 0), (1090, 0), (1100, 1), (1110, 0), (1120, 0), (1130, 0), (1140, 1), (1150, 1), (1160, 1), (1170, 1), (1180, 1), (1190, 1), (1200, 1), (1210, 0), (1220, 0), (1230, 0), (1240, 0), (1250, 0), (1260, 0), (1270, 0), (1280, 0), (1290, 0), (1300, 0), (1310, 0), (1320, 0), (1330, 0), (1340, 0), (1350, 0), (1360, 0), (1370, 0), (1380, 0), (1390, 0), (1400, 0), (1410, 0), (1420, 0), (1430, 0), (1440, 1), (1450, 1), (1460, 1), (1470, 1), (1480, 1), (1490, 0), (1500, 0), (1510, 0), (1520, 0), (1530, 0), (1540, 0), (1550, 1), (1560, 1), (1570, 1), (1580, 1), (1590, 1), (1600, 0), (1610, 0), (1620, 0), (1630, 0), (1640, 0), (1650, 0), (1660, 0), (1670, 0), (1680, 0), (1690, 0), (1700, 0), (1710, 0), (1720, 0), (1730, 0), (1740, 0), (1750, 0), (1760, 0), (1770, 0), (1780, 0), (1790, 0), (1800, 0), (1810, 0), (1820, 0), (1830, 0), (1840, 0), (1850, 0), (1860, 1), (1870, 1), (1880, 0), (1890, 0), (1900, 0), (1910, 1), (1920, 1), (1930, 1), (1940, 0), (1950, 0), (1960, 0), (1970, 0), (1980, 0), (1990, 0), (2000, 0), (2010, 0), (2020, 1), (2030, 0), (2040, 0), (2050, 0)]
Vdin1_16  din1_16  0 PWL (0n 0.0v 9.495n 0.0v 9.505n 0.0v 19.495n 0.0v 19.505n 0.0v 29.495n 0.0v 29.505n 0.0v 39.495n 0.0v 39.505n 0.0v 49.495n 0.0v 49.505n 0.0v 59.495n 0.0v 59.505n 0.0v 69.495n 0.0v 69.505n 3.3v 79.495n 3.3v 79.505n 0.0v 89.495n 0.0v 89.505n 0.0v 99.495n 0.0v 99.505n 0.0v 109.495n 0.0v 109.505n 0.0v 119.495n 0.0v 119.505n 0.0v 129.495n 0.0v 129.505n 0.0v 139.495n 0.0v 139.505n 3.3v 149.495n 3.3v 149.505n 3.3v 159.495n 3.3v 159.505n 3.3v 169.495n 3.3v 169.505n 0.0v 179.495n 0.0v 179.505n 0.0v 189.495n 0.0v 189.505n 0.0v 199.495n 0.0v 199.505n 0.0v 209.495n 0.0v 209.505n 0.0v 219.495n 0.0v 219.505n 0.0v 229.495n 0.0v 229.505n 0.0v 239.495n 0.0v 239.505n 0.0v 249.495n 0.0v 249.505n 0.0v 259.495n 0.0v 259.505n 0.0v 269.495n 0.0v 269.505n 0.0v 279.495n 0.0v 279.505n 0.0v 289.495n 0.0v 289.505n 0.0v 299.495n 0.0v 299.505n 0.0v 309.495n 0.0v 309.505n 0.0v 319.495n 0.0v 319.505n 0.0v 329.495n 0.0v 329.505n 0.0v 339.495n 0.0v 339.505n 0.0v 349.495n 0.0v 349.505n 0.0v 359.495n 0.0v 359.505n 0.0v 369.495n 0.0v 369.505n 3.3v 379.495n 3.3v 379.505n 0.0v 389.495n 0.0v 389.505n 0.0v 399.495n 0.0v 399.505n 0.0v 409.495n 0.0v 409.505n 0.0v 419.495n 0.0v 419.505n 0.0v 429.495n 0.0v 429.505n 0.0v 439.495n 0.0v 439.505n 0.0v 449.495n 0.0v 449.505n 0.0v 459.495n 0.0v 459.505n 0.0v 469.495n 0.0v 469.505n 0.0v 479.495n 0.0v 479.505n 0.0v 489.495n 0.0v 489.505n 0.0v 499.495n 0.0v 499.505n 0.0v 509.495n 0.0v 509.505n 0.0v 519.495n 0.0v 519.505n 0.0v 529.495n 0.0v 529.505n 0.0v 539.495n 0.0v 539.505n 0.0v 549.495n 0.0v 549.505n 0.0v 559.495n 0.0v 559.505n 0.0v 569.495n 0.0v 569.505n 0.0v 579.495n 0.0v 579.505n 0.0v 589.495n 0.0v 589.505n 0.0v 599.495n 0.0v 599.505n 0.0v 609.495n 0.0v 609.505n 0.0v 619.495n 0.0v 619.505n 0.0v 629.495n 0.0v 629.505n 0.0v 639.495n 0.0v 639.505n 0.0v 649.495n 0.0v 649.505n 0.0v 659.495n 0.0v 659.505n 0.0v 669.495n 0.0v 669.505n 0.0v 679.495n 0.0v 679.505n 3.3v 689.495n 3.3v 689.505n 3.3v 699.495n 3.3v 699.505n 3.3v 709.495n 3.3v 709.505n 3.3v 719.495n 3.3v 719.505n 0.0v 729.495n 0.0v 729.505n 0.0v 739.495n 0.0v 739.505n 0.0v 749.495n 0.0v 749.505n 0.0v 759.495n 0.0v 759.505n 0.0v 769.495n 0.0v 769.505n 0.0v 779.495n 0.0v 779.505n 0.0v 789.495n 0.0v 789.505n 0.0v 799.495n 0.0v 799.505n 0.0v 809.495n 0.0v 809.505n 0.0v 819.495n 0.0v 819.505n 0.0v 829.495n 0.0v 829.505n 0.0v 839.495n 0.0v 839.505n 0.0v 849.495n 0.0v 849.505n 0.0v 859.495n 0.0v 859.505n 3.3v 869.495n 3.3v 869.505n 3.3v 879.495n 3.3v 879.505n 3.3v 889.495n 3.3v 889.505n 3.3v 899.495n 3.3v 899.505n 3.3v 909.495n 3.3v 909.505n 3.3v 919.495n 3.3v 919.505n 3.3v 929.495n 3.3v 929.505n 3.3v 939.495n 3.3v 939.505n 3.3v 949.495n 3.3v 949.505n 3.3v 959.495n 3.3v 959.505n 3.3v 969.495n 3.3v 969.505n 3.3v 979.495n 3.3v 979.505n 3.3v 989.495n 3.3v 989.505n 3.3v 999.495n 3.3v 999.505n 3.3v 1009.495n 3.3v 1009.505n 3.3v 1019.495n 3.3v 1019.505n 3.3v 1029.495n 3.3v 1029.505n 3.3v 1039.495n 3.3v 1039.505n 3.3v 1049.495n 3.3v 1049.505n 0.0v 1059.495n 0.0v 1059.505n 0.0v 1069.495n 0.0v 1069.505n 0.0v 1079.495n 0.0v 1079.505n 0.0v 1089.495n 0.0v 1089.505n 0.0v 1099.495n 0.0v 1099.505n 3.3v 1109.495n 3.3v 1109.505n 0.0v 1119.495n 0.0v 1119.505n 0.0v 1129.495n 0.0v 1129.505n 0.0v 1139.495n 0.0v 1139.505n 3.3v 1149.495n 3.3v 1149.505n 3.3v 1159.495n 3.3v 1159.505n 3.3v 1169.495n 3.3v 1169.505n 3.3v 1179.495n 3.3v 1179.505n 3.3v 1189.495n 3.3v 1189.505n 3.3v 1199.495n 3.3v 1199.505n 3.3v 1209.495n 3.3v 1209.505n 0.0v 1219.495n 0.0v 1219.505n 0.0v 1229.495n 0.0v 1229.505n 0.0v 1239.495n 0.0v 1239.505n 0.0v 1249.495n 0.0v 1249.505n 0.0v 1259.495n 0.0v 1259.505n 0.0v 1269.495n 0.0v 1269.505n 0.0v 1279.495n 0.0v 1279.505n 0.0v 1289.495n 0.0v 1289.505n 0.0v 1299.495n 0.0v 1299.505n 0.0v 1309.495n 0.0v 1309.505n 0.0v 1319.495n 0.0v 1319.505n 0.0v 1329.495n 0.0v 1329.505n 0.0v 1339.495n 0.0v 1339.505n 0.0v 1349.495n 0.0v 1349.505n 0.0v 1359.495n 0.0v 1359.505n 0.0v 1369.495n 0.0v 1369.505n 0.0v 1379.495n 0.0v 1379.505n 0.0v 1389.495n 0.0v 1389.505n 0.0v 1399.495n 0.0v 1399.505n 0.0v 1409.495n 0.0v 1409.505n 0.0v 1419.495n 0.0v 1419.505n 0.0v 1429.495n 0.0v 1429.505n 0.0v 1439.495n 0.0v 1439.505n 3.3v 1449.495n 3.3v 1449.505n 3.3v 1459.495n 3.3v 1459.505n 3.3v 1469.495n 3.3v 1469.505n 3.3v 1479.495n 3.3v 1479.505n 3.3v 1489.495n 3.3v 1489.505n 0.0v 1499.495n 0.0v 1499.505n 0.0v 1509.495n 0.0v 1509.505n 0.0v 1519.495n 0.0v 1519.505n 0.0v 1529.495n 0.0v 1529.505n 0.0v 1539.495n 0.0v 1539.505n 0.0v 1549.495n 0.0v 1549.505n 3.3v 1559.495n 3.3v 1559.505n 3.3v 1569.495n 3.3v 1569.505n 3.3v 1579.495n 3.3v 1579.505n 3.3v 1589.495n 3.3v 1589.505n 3.3v 1599.495n 3.3v 1599.505n 0.0v 1609.495n 0.0v 1609.505n 0.0v 1619.495n 0.0v 1619.505n 0.0v 1629.495n 0.0v 1629.505n 0.0v 1639.495n 0.0v 1639.505n 0.0v 1649.495n 0.0v 1649.505n 0.0v 1659.495n 0.0v 1659.505n 0.0v 1669.495n 0.0v 1669.505n 0.0v 1679.495n 0.0v 1679.505n 0.0v 1689.495n 0.0v 1689.505n 0.0v 1699.495n 0.0v 1699.505n 0.0v 1709.495n 0.0v 1709.505n 0.0v 1719.495n 0.0v 1719.505n 0.0v 1729.495n 0.0v 1729.505n 0.0v 1739.495n 0.0v 1739.505n 0.0v 1749.495n 0.0v 1749.505n 0.0v 1759.495n 0.0v 1759.505n 0.0v 1769.495n 0.0v 1769.505n 0.0v 1779.495n 0.0v 1779.505n 0.0v 1789.495n 0.0v 1789.505n 0.0v 1799.495n 0.0v 1799.505n 0.0v 1809.495n 0.0v 1809.505n 0.0v 1819.495n 0.0v 1819.505n 0.0v 1829.495n 0.0v 1829.505n 0.0v 1839.495n 0.0v 1839.505n 0.0v 1849.495n 0.0v 1849.505n 0.0v 1859.495n 0.0v 1859.505n 3.3v 1869.495n 3.3v 1869.505n 3.3v 1879.495n 3.3v 1879.505n 0.0v 1889.495n 0.0v 1889.505n 0.0v 1899.495n 0.0v 1899.505n 0.0v 1909.495n 0.0v 1909.505n 3.3v 1919.495n 3.3v 1919.505n 3.3v 1929.495n 3.3v 1929.505n 3.3v 1939.495n 3.3v 1939.505n 0.0v 1949.495n 0.0v 1949.505n 0.0v 1959.495n 0.0v 1959.505n 0.0v 1969.495n 0.0v 1969.505n 0.0v 1979.495n 0.0v 1979.505n 0.0v 1989.495n 0.0v 1989.505n 0.0v 1999.495n 0.0v 1999.505n 0.0v 2009.495n 0.0v 2009.505n 0.0v 2019.495n 0.0v 2019.505n 3.3v 2029.495n 3.3v 2029.505n 0.0v 2039.495n 0.0v 2039.505n 0.0v 2049.495n 0.0v 2049.505n 0.0v )
* (time, data): [(0, 0), (10, 1), (20, 0), (30, 1), (40, 1), (50, 1), (60, 1), (70, 1), (80, 1), (90, 1), (100, 1), (110, 1), (120, 1), (130, 1), (140, 1), (150, 1), (160, 1), (170, 0), (180, 0), (190, 0), (200, 0), (210, 0), (220, 0), (230, 0), (240, 0), (250, 0), (260, 0), (270, 0), (280, 0), (290, 0), (300, 0), (310, 0), (320, 0), (330, 0), (340, 0), (350, 0), (360, 0), (370, 0), (380, 0), (390, 0), (400, 1), (410, 1), (420, 1), (430, 1), (440, 1), (450, 1), (460, 1), (470, 1), (480, 1), (490, 1), (500, 0), (510, 0), (520, 0), (530, 0), (540, 0), (550, 0), (560, 0), (570, 0), (580, 0), (590, 0), (600, 0), (610, 0), (620, 0), (630, 0), (640, 0), (650, 0), (660, 1), (670, 1), (680, 0), (690, 0), (700, 0), (710, 0), (720, 0), (730, 0), (740, 0), (750, 0), (760, 0), (770, 0), (780, 0), (790, 0), (800, 0), (810, 0), (820, 0), (830, 0), (840, 0), (850, 0), (860, 1), (870, 1), (880, 1), (890, 1), (900, 1), (910, 1), (920, 1), (930, 1), (940, 1), (950, 1), (960, 1), (970, 1), (980, 1), (990, 1), (1000, 1), (1010, 1), (1020, 1), (1030, 1), (1040, 0), (1050, 0), (1060, 0), (1070, 0), (1080, 0), (1090, 0), (1100, 0), (1110, 0), (1120, 0), (1130, 0), (1140, 1), (1150, 1), (1160, 1), (1170, 1), (1180, 1), (1190, 1), (1200, 1), (1210, 0), (1220, 0), (1230, 0), (1240, 0), (1250, 1), (1260, 1), (1270, 1), (1280, 1), (1290, 1), (1300, 1), (1310, 1), (1320, 1), (1330, 1), (1340, 1), (1350, 1), (1360, 1), (1370, 1), (1380, 1), (1390, 1), (1400, 1), (1410, 1), (1420, 1), (1430, 1), (1440, 0), (1450, 0), (1460, 0), (1470, 0), (1480, 0), (1490, 0), (1500, 0), (1510, 0), (1520, 0), (1530, 0), (1540, 0), (1550, 0), (1560, 1), (1570, 1), (1580, 1), (1590, 1), (1600, 0), (1610, 0), (1620, 0), (1630, 0), (1640, 0), (1650, 0), (1660, 0), (1670, 0), (1680, 0), (1690, 0), (1700, 0), (1710, 0), (1720, 0), (1730, 1), (1740, 1), (1750, 1), (1760, 1), (1770, 1), (1780, 1), (1790, 1), (1800, 1), (1810, 1), (1820, 1), (1830, 1), (1840, 1), (1850, 1), (1860, 0), (1870, 0), (1880, 0), (1890, 0), (1900, 0), (1910, 1), (1920, 1), (1930, 1), (1940, 1), (1950, 1), (1960, 1), (1970, 1), (1980, 1), (1990, 1), (2000, 1), (2010, 1), (2020, 0), (2030, 1), (2040, 1), (2050, 1)]
Vdin1_17  din1_17  0 PWL (0n 0.0v 9.495n 0.0v 9.505n 3.3v 19.495n 3.3v 19.505n 0.0v 29.495n 0.0v 29.505n 3.3v 39.495n 3.3v 39.505n 3.3v 49.495n 3.3v 49.505n 3.3v 59.495n 3.3v 59.505n 3.3v 69.495n 3.3v 69.505n 3.3v 79.495n 3.3v 79.505n 3.3v 89.495n 3.3v 89.505n 3.3v 99.495n 3.3v 99.505n 3.3v 109.495n 3.3v 109.505n 3.3v 119.495n 3.3v 119.505n 3.3v 129.495n 3.3v 129.505n 3.3v 139.495n 3.3v 139.505n 3.3v 149.495n 3.3v 149.505n 3.3v 159.495n 3.3v 159.505n 3.3v 169.495n 3.3v 169.505n 0.0v 179.495n 0.0v 179.505n 0.0v 189.495n 0.0v 189.505n 0.0v 199.495n 0.0v 199.505n 0.0v 209.495n 0.0v 209.505n 0.0v 219.495n 0.0v 219.505n 0.0v 229.495n 0.0v 229.505n 0.0v 239.495n 0.0v 239.505n 0.0v 249.495n 0.0v 249.505n 0.0v 259.495n 0.0v 259.505n 0.0v 269.495n 0.0v 269.505n 0.0v 279.495n 0.0v 279.505n 0.0v 289.495n 0.0v 289.505n 0.0v 299.495n 0.0v 299.505n 0.0v 309.495n 0.0v 309.505n 0.0v 319.495n 0.0v 319.505n 0.0v 329.495n 0.0v 329.505n 0.0v 339.495n 0.0v 339.505n 0.0v 349.495n 0.0v 349.505n 0.0v 359.495n 0.0v 359.505n 0.0v 369.495n 0.0v 369.505n 0.0v 379.495n 0.0v 379.505n 0.0v 389.495n 0.0v 389.505n 0.0v 399.495n 0.0v 399.505n 3.3v 409.495n 3.3v 409.505n 3.3v 419.495n 3.3v 419.505n 3.3v 429.495n 3.3v 429.505n 3.3v 439.495n 3.3v 439.505n 3.3v 449.495n 3.3v 449.505n 3.3v 459.495n 3.3v 459.505n 3.3v 469.495n 3.3v 469.505n 3.3v 479.495n 3.3v 479.505n 3.3v 489.495n 3.3v 489.505n 3.3v 499.495n 3.3v 499.505n 0.0v 509.495n 0.0v 509.505n 0.0v 519.495n 0.0v 519.505n 0.0v 529.495n 0.0v 529.505n 0.0v 539.495n 0.0v 539.505n 0.0v 549.495n 0.0v 549.505n 0.0v 559.495n 0.0v 559.505n 0.0v 569.495n 0.0v 569.505n 0.0v 579.495n 0.0v 579.505n 0.0v 589.495n 0.0v 589.505n 0.0v 599.495n 0.0v 599.505n 0.0v 609.495n 0.0v 609.505n 0.0v 619.495n 0.0v 619.505n 0.0v 629.495n 0.0v 629.505n 0.0v 639.495n 0.0v 639.505n 0.0v 649.495n 0.0v 649.505n 0.0v 659.495n 0.0v 659.505n 3.3v 669.495n 3.3v 669.505n 3.3v 679.495n 3.3v 679.505n 0.0v 689.495n 0.0v 689.505n 0.0v 699.495n 0.0v 699.505n 0.0v 709.495n 0.0v 709.505n 0.0v 719.495n 0.0v 719.505n 0.0v 729.495n 0.0v 729.505n 0.0v 739.495n 0.0v 739.505n 0.0v 749.495n 0.0v 749.505n 0.0v 759.495n 0.0v 759.505n 0.0v 769.495n 0.0v 769.505n 0.0v 779.495n 0.0v 779.505n 0.0v 789.495n 0.0v 789.505n 0.0v 799.495n 0.0v 799.505n 0.0v 809.495n 0.0v 809.505n 0.0v 819.495n 0.0v 819.505n 0.0v 829.495n 0.0v 829.505n 0.0v 839.495n 0.0v 839.505n 0.0v 849.495n 0.0v 849.505n 0.0v 859.495n 0.0v 859.505n 3.3v 869.495n 3.3v 869.505n 3.3v 879.495n 3.3v 879.505n 3.3v 889.495n 3.3v 889.505n 3.3v 899.495n 3.3v 899.505n 3.3v 909.495n 3.3v 909.505n 3.3v 919.495n 3.3v 919.505n 3.3v 929.495n 3.3v 929.505n 3.3v 939.495n 3.3v 939.505n 3.3v 949.495n 3.3v 949.505n 3.3v 959.495n 3.3v 959.505n 3.3v 969.495n 3.3v 969.505n 3.3v 979.495n 3.3v 979.505n 3.3v 989.495n 3.3v 989.505n 3.3v 999.495n 3.3v 999.505n 3.3v 1009.495n 3.3v 1009.505n 3.3v 1019.495n 3.3v 1019.505n 3.3v 1029.495n 3.3v 1029.505n 3.3v 1039.495n 3.3v 1039.505n 0.0v 1049.495n 0.0v 1049.505n 0.0v 1059.495n 0.0v 1059.505n 0.0v 1069.495n 0.0v 1069.505n 0.0v 1079.495n 0.0v 1079.505n 0.0v 1089.495n 0.0v 1089.505n 0.0v 1099.495n 0.0v 1099.505n 0.0v 1109.495n 0.0v 1109.505n 0.0v 1119.495n 0.0v 1119.505n 0.0v 1129.495n 0.0v 1129.505n 0.0v 1139.495n 0.0v 1139.505n 3.3v 1149.495n 3.3v 1149.505n 3.3v 1159.495n 3.3v 1159.505n 3.3v 1169.495n 3.3v 1169.505n 3.3v 1179.495n 3.3v 1179.505n 3.3v 1189.495n 3.3v 1189.505n 3.3v 1199.495n 3.3v 1199.505n 3.3v 1209.495n 3.3v 1209.505n 0.0v 1219.495n 0.0v 1219.505n 0.0v 1229.495n 0.0v 1229.505n 0.0v 1239.495n 0.0v 1239.505n 0.0v 1249.495n 0.0v 1249.505n 3.3v 1259.495n 3.3v 1259.505n 3.3v 1269.495n 3.3v 1269.505n 3.3v 1279.495n 3.3v 1279.505n 3.3v 1289.495n 3.3v 1289.505n 3.3v 1299.495n 3.3v 1299.505n 3.3v 1309.495n 3.3v 1309.505n 3.3v 1319.495n 3.3v 1319.505n 3.3v 1329.495n 3.3v 1329.505n 3.3v 1339.495n 3.3v 1339.505n 3.3v 1349.495n 3.3v 1349.505n 3.3v 1359.495n 3.3v 1359.505n 3.3v 1369.495n 3.3v 1369.505n 3.3v 1379.495n 3.3v 1379.505n 3.3v 1389.495n 3.3v 1389.505n 3.3v 1399.495n 3.3v 1399.505n 3.3v 1409.495n 3.3v 1409.505n 3.3v 1419.495n 3.3v 1419.505n 3.3v 1429.495n 3.3v 1429.505n 3.3v 1439.495n 3.3v 1439.505n 0.0v 1449.495n 0.0v 1449.505n 0.0v 1459.495n 0.0v 1459.505n 0.0v 1469.495n 0.0v 1469.505n 0.0v 1479.495n 0.0v 1479.505n 0.0v 1489.495n 0.0v 1489.505n 0.0v 1499.495n 0.0v 1499.505n 0.0v 1509.495n 0.0v 1509.505n 0.0v 1519.495n 0.0v 1519.505n 0.0v 1529.495n 0.0v 1529.505n 0.0v 1539.495n 0.0v 1539.505n 0.0v 1549.495n 0.0v 1549.505n 0.0v 1559.495n 0.0v 1559.505n 3.3v 1569.495n 3.3v 1569.505n 3.3v 1579.495n 3.3v 1579.505n 3.3v 1589.495n 3.3v 1589.505n 3.3v 1599.495n 3.3v 1599.505n 0.0v 1609.495n 0.0v 1609.505n 0.0v 1619.495n 0.0v 1619.505n 0.0v 1629.495n 0.0v 1629.505n 0.0v 1639.495n 0.0v 1639.505n 0.0v 1649.495n 0.0v 1649.505n 0.0v 1659.495n 0.0v 1659.505n 0.0v 1669.495n 0.0v 1669.505n 0.0v 1679.495n 0.0v 1679.505n 0.0v 1689.495n 0.0v 1689.505n 0.0v 1699.495n 0.0v 1699.505n 0.0v 1709.495n 0.0v 1709.505n 0.0v 1719.495n 0.0v 1719.505n 0.0v 1729.495n 0.0v 1729.505n 3.3v 1739.495n 3.3v 1739.505n 3.3v 1749.495n 3.3v 1749.505n 3.3v 1759.495n 3.3v 1759.505n 3.3v 1769.495n 3.3v 1769.505n 3.3v 1779.495n 3.3v 1779.505n 3.3v 1789.495n 3.3v 1789.505n 3.3v 1799.495n 3.3v 1799.505n 3.3v 1809.495n 3.3v 1809.505n 3.3v 1819.495n 3.3v 1819.505n 3.3v 1829.495n 3.3v 1829.505n 3.3v 1839.495n 3.3v 1839.505n 3.3v 1849.495n 3.3v 1849.505n 3.3v 1859.495n 3.3v 1859.505n 0.0v 1869.495n 0.0v 1869.505n 0.0v 1879.495n 0.0v 1879.505n 0.0v 1889.495n 0.0v 1889.505n 0.0v 1899.495n 0.0v 1899.505n 0.0v 1909.495n 0.0v 1909.505n 3.3v 1919.495n 3.3v 1919.505n 3.3v 1929.495n 3.3v 1929.505n 3.3v 1939.495n 3.3v 1939.505n 3.3v 1949.495n 3.3v 1949.505n 3.3v 1959.495n 3.3v 1959.505n 3.3v 1969.495n 3.3v 1969.505n 3.3v 1979.495n 3.3v 1979.505n 3.3v 1989.495n 3.3v 1989.505n 3.3v 1999.495n 3.3v 1999.505n 3.3v 2009.495n 3.3v 2009.505n 3.3v 2019.495n 3.3v 2019.505n 0.0v 2029.495n 0.0v 2029.505n 3.3v 2039.495n 3.3v 2039.505n 3.3v 2049.495n 3.3v 2049.505n 3.3v )
* (time, data): [(0, 0), (10, 0), (20, 0), (30, 0), (40, 0), (50, 0), (60, 0), (70, 1), (80, 0), (90, 0), (100, 0), (110, 0), (120, 1), (130, 1), (140, 0), (150, 0), (160, 0), (170, 1), (180, 1), (190, 1), (200, 1), (210, 1), (220, 1), (230, 1), (240, 0), (250, 0), (260, 0), (270, 0), (280, 0), (290, 0), (300, 0), (310, 0), (320, 0), (330, 0), (340, 0), (350, 0), (360, 0), (370, 1), (380, 1), (390, 1), (400, 0), (410, 0), (420, 0), (430, 0), (440, 0), (450, 0), (460, 0), (470, 0), (480, 0), (490, 0), (500, 0), (510, 0), (520, 0), (530, 0), (540, 0), (550, 0), (560, 0), (570, 0), (580, 0), (590, 0), (600, 0), (610, 0), (620, 0), (630, 0), (640, 0), (650, 0), (660, 1), (670, 1), (680, 1), (690, 1), (700, 1), (710, 1), (720, 1), (730, 1), (740, 1), (750, 1), (760, 1), (770, 1), (780, 1), (790, 1), (800, 1), (810, 1), (820, 1), (830, 1), (840, 1), (850, 1), (860, 0), (870, 1), (880, 1), (890, 1), (900, 1), (910, 1), (920, 1), (930, 1), (940, 0), (950, 1), (960, 1), (970, 1), (980, 1), (990, 1), (1000, 1), (1010, 1), (1020, 1), (1030, 1), (1040, 0), (1050, 1), (1060, 1), (1070, 1), (1080, 1), (1090, 1), (1100, 1), (1110, 0), (1120, 0), (1130, 0), (1140, 1), (1150, 1), (1160, 1), (1170, 1), (1180, 1), (1190, 1), (1200, 1), (1210, 0), (1220, 0), (1230, 0), (1240, 0), (1250, 0), (1260, 0), (1270, 0), (1280, 0), (1290, 0), (1300, 0), (1310, 1), (1320, 1), (1330, 1), (1340, 1), (1350, 1), (1360, 1), (1370, 1), (1380, 1), (1390, 1), (1400, 1), (1410, 1), (1420, 1), (1430, 1), (1440, 1), (1450, 1), (1460, 1), (1470, 1), (1480, 1), (1490, 0), (1500, 0), (1510, 0), (1520, 0), (1530, 0), (1540, 0), (1550, 0), (1560, 0), (1570, 0), (1580, 0), (1590, 0), (1600, 0), (1610, 0), (1620, 0), (1630, 0), (1640, 0), (1650, 0), (1660, 0), (1670, 0), (1680, 0), (1690, 0), (1700, 0), (1710, 0), (1720, 0), (1730, 1), (1740, 1), (1750, 0), (1760, 0), (1770, 0), (1780, 0), (1790, 0), (1800, 0), (1810, 0), (1820, 0), (1830, 0), (1840, 0), (1850, 0), (1860, 1), (1870, 1), (1880, 1), (1890, 1), (1900, 1), (1910, 0), (1920, 0), (1930, 0), (1940, 0), (1950, 0), (1960, 0), (1970, 0), (1980, 1), (1990, 1), (2000, 0), (2010, 0), (2020, 0), (2030, 0), (2040, 0), (2050, 0)]
Vdin1_18  din1_18  0 PWL (0n 0.0v 9.495n 0.0v 9.505n 0.0v 19.495n 0.0v 19.505n 0.0v 29.495n 0.0v 29.505n 0.0v 39.495n 0.0v 39.505n 0.0v 49.495n 0.0v 49.505n 0.0v 59.495n 0.0v 59.505n 0.0v 69.495n 0.0v 69.505n 3.3v 79.495n 3.3v 79.505n 0.0v 89.495n 0.0v 89.505n 0.0v 99.495n 0.0v 99.505n 0.0v 109.495n 0.0v 109.505n 0.0v 119.495n 0.0v 119.505n 3.3v 129.495n 3.3v 129.505n 3.3v 139.495n 3.3v 139.505n 0.0v 149.495n 0.0v 149.505n 0.0v 159.495n 0.0v 159.505n 0.0v 169.495n 0.0v 169.505n 3.3v 179.495n 3.3v 179.505n 3.3v 189.495n 3.3v 189.505n 3.3v 199.495n 3.3v 199.505n 3.3v 209.495n 3.3v 209.505n 3.3v 219.495n 3.3v 219.505n 3.3v 229.495n 3.3v 229.505n 3.3v 239.495n 3.3v 239.505n 0.0v 249.495n 0.0v 249.505n 0.0v 259.495n 0.0v 259.505n 0.0v 269.495n 0.0v 269.505n 0.0v 279.495n 0.0v 279.505n 0.0v 289.495n 0.0v 289.505n 0.0v 299.495n 0.0v 299.505n 0.0v 309.495n 0.0v 309.505n 0.0v 319.495n 0.0v 319.505n 0.0v 329.495n 0.0v 329.505n 0.0v 339.495n 0.0v 339.505n 0.0v 349.495n 0.0v 349.505n 0.0v 359.495n 0.0v 359.505n 0.0v 369.495n 0.0v 369.505n 3.3v 379.495n 3.3v 379.505n 3.3v 389.495n 3.3v 389.505n 3.3v 399.495n 3.3v 399.505n 0.0v 409.495n 0.0v 409.505n 0.0v 419.495n 0.0v 419.505n 0.0v 429.495n 0.0v 429.505n 0.0v 439.495n 0.0v 439.505n 0.0v 449.495n 0.0v 449.505n 0.0v 459.495n 0.0v 459.505n 0.0v 469.495n 0.0v 469.505n 0.0v 479.495n 0.0v 479.505n 0.0v 489.495n 0.0v 489.505n 0.0v 499.495n 0.0v 499.505n 0.0v 509.495n 0.0v 509.505n 0.0v 519.495n 0.0v 519.505n 0.0v 529.495n 0.0v 529.505n 0.0v 539.495n 0.0v 539.505n 0.0v 549.495n 0.0v 549.505n 0.0v 559.495n 0.0v 559.505n 0.0v 569.495n 0.0v 569.505n 0.0v 579.495n 0.0v 579.505n 0.0v 589.495n 0.0v 589.505n 0.0v 599.495n 0.0v 599.505n 0.0v 609.495n 0.0v 609.505n 0.0v 619.495n 0.0v 619.505n 0.0v 629.495n 0.0v 629.505n 0.0v 639.495n 0.0v 639.505n 0.0v 649.495n 0.0v 649.505n 0.0v 659.495n 0.0v 659.505n 3.3v 669.495n 3.3v 669.505n 3.3v 679.495n 3.3v 679.505n 3.3v 689.495n 3.3v 689.505n 3.3v 699.495n 3.3v 699.505n 3.3v 709.495n 3.3v 709.505n 3.3v 719.495n 3.3v 719.505n 3.3v 729.495n 3.3v 729.505n 3.3v 739.495n 3.3v 739.505n 3.3v 749.495n 3.3v 749.505n 3.3v 759.495n 3.3v 759.505n 3.3v 769.495n 3.3v 769.505n 3.3v 779.495n 3.3v 779.505n 3.3v 789.495n 3.3v 789.505n 3.3v 799.495n 3.3v 799.505n 3.3v 809.495n 3.3v 809.505n 3.3v 819.495n 3.3v 819.505n 3.3v 829.495n 3.3v 829.505n 3.3v 839.495n 3.3v 839.505n 3.3v 849.495n 3.3v 849.505n 3.3v 859.495n 3.3v 859.505n 0.0v 869.495n 0.0v 869.505n 3.3v 879.495n 3.3v 879.505n 3.3v 889.495n 3.3v 889.505n 3.3v 899.495n 3.3v 899.505n 3.3v 909.495n 3.3v 909.505n 3.3v 919.495n 3.3v 919.505n 3.3v 929.495n 3.3v 929.505n 3.3v 939.495n 3.3v 939.505n 0.0v 949.495n 0.0v 949.505n 3.3v 959.495n 3.3v 959.505n 3.3v 969.495n 3.3v 969.505n 3.3v 979.495n 3.3v 979.505n 3.3v 989.495n 3.3v 989.505n 3.3v 999.495n 3.3v 999.505n 3.3v 1009.495n 3.3v 1009.505n 3.3v 1019.495n 3.3v 1019.505n 3.3v 1029.495n 3.3v 1029.505n 3.3v 1039.495n 3.3v 1039.505n 0.0v 1049.495n 0.0v 1049.505n 3.3v 1059.495n 3.3v 1059.505n 3.3v 1069.495n 3.3v 1069.505n 3.3v 1079.495n 3.3v 1079.505n 3.3v 1089.495n 3.3v 1089.505n 3.3v 1099.495n 3.3v 1099.505n 3.3v 1109.495n 3.3v 1109.505n 0.0v 1119.495n 0.0v 1119.505n 0.0v 1129.495n 0.0v 1129.505n 0.0v 1139.495n 0.0v 1139.505n 3.3v 1149.495n 3.3v 1149.505n 3.3v 1159.495n 3.3v 1159.505n 3.3v 1169.495n 3.3v 1169.505n 3.3v 1179.495n 3.3v 1179.505n 3.3v 1189.495n 3.3v 1189.505n 3.3v 1199.495n 3.3v 1199.505n 3.3v 1209.495n 3.3v 1209.505n 0.0v 1219.495n 0.0v 1219.505n 0.0v 1229.495n 0.0v 1229.505n 0.0v 1239.495n 0.0v 1239.505n 0.0v 1249.495n 0.0v 1249.505n 0.0v 1259.495n 0.0v 1259.505n 0.0v 1269.495n 0.0v 1269.505n 0.0v 1279.495n 0.0v 1279.505n 0.0v 1289.495n 0.0v 1289.505n 0.0v 1299.495n 0.0v 1299.505n 0.0v 1309.495n 0.0v 1309.505n 3.3v 1319.495n 3.3v 1319.505n 3.3v 1329.495n 3.3v 1329.505n 3.3v 1339.495n 3.3v 1339.505n 3.3v 1349.495n 3.3v 1349.505n 3.3v 1359.495n 3.3v 1359.505n 3.3v 1369.495n 3.3v 1369.505n 3.3v 1379.495n 3.3v 1379.505n 3.3v 1389.495n 3.3v 1389.505n 3.3v 1399.495n 3.3v 1399.505n 3.3v 1409.495n 3.3v 1409.505n 3.3v 1419.495n 3.3v 1419.505n 3.3v 1429.495n 3.3v 1429.505n 3.3v 1439.495n 3.3v 1439.505n 3.3v 1449.495n 3.3v 1449.505n 3.3v 1459.495n 3.3v 1459.505n 3.3v 1469.495n 3.3v 1469.505n 3.3v 1479.495n 3.3v 1479.505n 3.3v 1489.495n 3.3v 1489.505n 0.0v 1499.495n 0.0v 1499.505n 0.0v 1509.495n 0.0v 1509.505n 0.0v 1519.495n 0.0v 1519.505n 0.0v 1529.495n 0.0v 1529.505n 0.0v 1539.495n 0.0v 1539.505n 0.0v 1549.495n 0.0v 1549.505n 0.0v 1559.495n 0.0v 1559.505n 0.0v 1569.495n 0.0v 1569.505n 0.0v 1579.495n 0.0v 1579.505n 0.0v 1589.495n 0.0v 1589.505n 0.0v 1599.495n 0.0v 1599.505n 0.0v 1609.495n 0.0v 1609.505n 0.0v 1619.495n 0.0v 1619.505n 0.0v 1629.495n 0.0v 1629.505n 0.0v 1639.495n 0.0v 1639.505n 0.0v 1649.495n 0.0v 1649.505n 0.0v 1659.495n 0.0v 1659.505n 0.0v 1669.495n 0.0v 1669.505n 0.0v 1679.495n 0.0v 1679.505n 0.0v 1689.495n 0.0v 1689.505n 0.0v 1699.495n 0.0v 1699.505n 0.0v 1709.495n 0.0v 1709.505n 0.0v 1719.495n 0.0v 1719.505n 0.0v 1729.495n 0.0v 1729.505n 3.3v 1739.495n 3.3v 1739.505n 3.3v 1749.495n 3.3v 1749.505n 0.0v 1759.495n 0.0v 1759.505n 0.0v 1769.495n 0.0v 1769.505n 0.0v 1779.495n 0.0v 1779.505n 0.0v 1789.495n 0.0v 1789.505n 0.0v 1799.495n 0.0v 1799.505n 0.0v 1809.495n 0.0v 1809.505n 0.0v 1819.495n 0.0v 1819.505n 0.0v 1829.495n 0.0v 1829.505n 0.0v 1839.495n 0.0v 1839.505n 0.0v 1849.495n 0.0v 1849.505n 0.0v 1859.495n 0.0v 1859.505n 3.3v 1869.495n 3.3v 1869.505n 3.3v 1879.495n 3.3v 1879.505n 3.3v 1889.495n 3.3v 1889.505n 3.3v 1899.495n 3.3v 1899.505n 3.3v 1909.495n 3.3v 1909.505n 0.0v 1919.495n 0.0v 1919.505n 0.0v 1929.495n 0.0v 1929.505n 0.0v 1939.495n 0.0v 1939.505n 0.0v 1949.495n 0.0v 1949.505n 0.0v 1959.495n 0.0v 1959.505n 0.0v 1969.495n 0.0v 1969.505n 0.0v 1979.495n 0.0v 1979.505n 3.3v 1989.495n 3.3v 1989.505n 3.3v 1999.495n 3.3v 1999.505n 0.0v 2009.495n 0.0v 2009.505n 0.0v 2019.495n 0.0v 2019.505n 0.0v 2029.495n 0.0v 2029.505n 0.0v 2039.495n 0.0v 2039.505n 0.0v 2049.495n 0.0v 2049.505n 0.0v )
* (time, data): [(0, 0), (10, 1), (20, 1), (30, 0), (40, 0), (50, 0), (60, 0), (70, 1), (80, 0), (90, 0), (100, 0), (110, 0), (120, 0), (130, 0), (140, 0), (150, 0), (160, 0), (170, 1), (180, 1), (190, 1), (200, 1), (210, 1), (220, 1), (230, 1), (240, 0), (250, 0), (260, 0), (270, 0), (280, 0), (290, 0), (300, 0), (310, 0), (320, 0), (330, 0), (340, 0), (350, 0), (360, 0), (370, 0), (380, 0), (390, 0), (400, 1), (410, 1), (420, 1), (430, 1), (440, 1), (450, 1), (460, 1), (470, 1), (480, 1), (490, 1), (500, 1), (510, 1), (520, 1), (530, 1), (540, 1), (550, 1), (560, 1), (570, 1), (580, 1), (590, 1), (600, 1), (610, 1), (620, 1), (630, 1), (640, 1), (650, 1), (660, 1), (670, 1), (680, 1), (690, 1), (700, 1), (710, 1), (720, 0), (730, 0), (740, 0), (750, 0), (760, 0), (770, 0), (780, 0), (790, 0), (800, 0), (810, 0), (820, 0), (830, 0), (840, 0), (850, 0), (860, 0), (870, 0), (880, 0), (890, 0), (900, 0), (910, 0), (920, 0), (930, 0), (940, 0), (950, 1), (960, 1), (970, 1), (980, 1), (990, 1), (1000, 1), (1010, 1), (1020, 1), (1030, 1), (1040, 1), (1050, 1), (1060, 1), (1070, 1), (1080, 1), (1090, 1), (1100, 1), (1110, 1), (1120, 1), (1130, 1), (1140, 1), (1150, 1), (1160, 1), (1170, 1), (1180, 1), (1190, 1), (1200, 1), (1210, 0), (1220, 0), (1230, 0), (1240, 0), (1250, 1), (1260, 1), (1270, 1), (1280, 1), (1290, 1), (1300, 1), (1310, 0), (1320, 0), (1330, 0), (1340, 0), (1350, 0), (1360, 0), (1370, 0), (1380, 0), (1390, 0), (1400, 0), (1410, 0), (1420, 0), (1430, 0), (1440, 1), (1450, 1), (1460, 1), (1470, 1), (1480, 1), (1490, 1), (1500, 1), (1510, 1), (1520, 1), (1530, 1), (1540, 1), (1550, 1), (1560, 0), (1570, 0), (1580, 0), (1590, 0), (1600, 0), (1610, 0), (1620, 0), (1630, 0), (1640, 0), (1650, 0), (1660, 0), (1670, 0), (1680, 0), (1690, 0), (1700, 0), (1710, 0), (1720, 0), (1730, 1), (1740, 1), (1750, 0), (1760, 0), (1770, 0), (1780, 0), (1790, 0), (1800, 0), (1810, 0), (1820, 0), (1830, 0), (1840, 0), (1850, 0), (1860, 0), (1870, 0), (1880, 1), (1890, 1), (1900, 1), (1910, 0), (1920, 0), (1930, 0), (1940, 1), (1950, 1), (1960, 1), (1970, 1), (1980, 1), (1990, 1), (2000, 1), (2010, 1), (2020, 0), (2030, 1), (2040, 1), (2050, 1)]
Vdin1_19  din1_19  0 PWL (0n 0.0v 9.495n 0.0v 9.505n 3.3v 19.495n 3.3v 19.505n 3.3v 29.495n 3.3v 29.505n 0.0v 39.495n 0.0v 39.505n 0.0v 49.495n 0.0v 49.505n 0.0v 59.495n 0.0v 59.505n 0.0v 69.495n 0.0v 69.505n 3.3v 79.495n 3.3v 79.505n 0.0v 89.495n 0.0v 89.505n 0.0v 99.495n 0.0v 99.505n 0.0v 109.495n 0.0v 109.505n 0.0v 119.495n 0.0v 119.505n 0.0v 129.495n 0.0v 129.505n 0.0v 139.495n 0.0v 139.505n 0.0v 149.495n 0.0v 149.505n 0.0v 159.495n 0.0v 159.505n 0.0v 169.495n 0.0v 169.505n 3.3v 179.495n 3.3v 179.505n 3.3v 189.495n 3.3v 189.505n 3.3v 199.495n 3.3v 199.505n 3.3v 209.495n 3.3v 209.505n 3.3v 219.495n 3.3v 219.505n 3.3v 229.495n 3.3v 229.505n 3.3v 239.495n 3.3v 239.505n 0.0v 249.495n 0.0v 249.505n 0.0v 259.495n 0.0v 259.505n 0.0v 269.495n 0.0v 269.505n 0.0v 279.495n 0.0v 279.505n 0.0v 289.495n 0.0v 289.505n 0.0v 299.495n 0.0v 299.505n 0.0v 309.495n 0.0v 309.505n 0.0v 319.495n 0.0v 319.505n 0.0v 329.495n 0.0v 329.505n 0.0v 339.495n 0.0v 339.505n 0.0v 349.495n 0.0v 349.505n 0.0v 359.495n 0.0v 359.505n 0.0v 369.495n 0.0v 369.505n 0.0v 379.495n 0.0v 379.505n 0.0v 389.495n 0.0v 389.505n 0.0v 399.495n 0.0v 399.505n 3.3v 409.495n 3.3v 409.505n 3.3v 419.495n 3.3v 419.505n 3.3v 429.495n 3.3v 429.505n 3.3v 439.495n 3.3v 439.505n 3.3v 449.495n 3.3v 449.505n 3.3v 459.495n 3.3v 459.505n 3.3v 469.495n 3.3v 469.505n 3.3v 479.495n 3.3v 479.505n 3.3v 489.495n 3.3v 489.505n 3.3v 499.495n 3.3v 499.505n 3.3v 509.495n 3.3v 509.505n 3.3v 519.495n 3.3v 519.505n 3.3v 529.495n 3.3v 529.505n 3.3v 539.495n 3.3v 539.505n 3.3v 549.495n 3.3v 549.505n 3.3v 559.495n 3.3v 559.505n 3.3v 569.495n 3.3v 569.505n 3.3v 579.495n 3.3v 579.505n 3.3v 589.495n 3.3v 589.505n 3.3v 599.495n 3.3v 599.505n 3.3v 609.495n 3.3v 609.505n 3.3v 619.495n 3.3v 619.505n 3.3v 629.495n 3.3v 629.505n 3.3v 639.495n 3.3v 639.505n 3.3v 649.495n 3.3v 649.505n 3.3v 659.495n 3.3v 659.505n 3.3v 669.495n 3.3v 669.505n 3.3v 679.495n 3.3v 679.505n 3.3v 689.495n 3.3v 689.505n 3.3v 699.495n 3.3v 699.505n 3.3v 709.495n 3.3v 709.505n 3.3v 719.495n 3.3v 719.505n 0.0v 729.495n 0.0v 729.505n 0.0v 739.495n 0.0v 739.505n 0.0v 749.495n 0.0v 749.505n 0.0v 759.495n 0.0v 759.505n 0.0v 769.495n 0.0v 769.505n 0.0v 779.495n 0.0v 779.505n 0.0v 789.495n 0.0v 789.505n 0.0v 799.495n 0.0v 799.505n 0.0v 809.495n 0.0v 809.505n 0.0v 819.495n 0.0v 819.505n 0.0v 829.495n 0.0v 829.505n 0.0v 839.495n 0.0v 839.505n 0.0v 849.495n 0.0v 849.505n 0.0v 859.495n 0.0v 859.505n 0.0v 869.495n 0.0v 869.505n 0.0v 879.495n 0.0v 879.505n 0.0v 889.495n 0.0v 889.505n 0.0v 899.495n 0.0v 899.505n 0.0v 909.495n 0.0v 909.505n 0.0v 919.495n 0.0v 919.505n 0.0v 929.495n 0.0v 929.505n 0.0v 939.495n 0.0v 939.505n 0.0v 949.495n 0.0v 949.505n 3.3v 959.495n 3.3v 959.505n 3.3v 969.495n 3.3v 969.505n 3.3v 979.495n 3.3v 979.505n 3.3v 989.495n 3.3v 989.505n 3.3v 999.495n 3.3v 999.505n 3.3v 1009.495n 3.3v 1009.505n 3.3v 1019.495n 3.3v 1019.505n 3.3v 1029.495n 3.3v 1029.505n 3.3v 1039.495n 3.3v 1039.505n 3.3v 1049.495n 3.3v 1049.505n 3.3v 1059.495n 3.3v 1059.505n 3.3v 1069.495n 3.3v 1069.505n 3.3v 1079.495n 3.3v 1079.505n 3.3v 1089.495n 3.3v 1089.505n 3.3v 1099.495n 3.3v 1099.505n 3.3v 1109.495n 3.3v 1109.505n 3.3v 1119.495n 3.3v 1119.505n 3.3v 1129.495n 3.3v 1129.505n 3.3v 1139.495n 3.3v 1139.505n 3.3v 1149.495n 3.3v 1149.505n 3.3v 1159.495n 3.3v 1159.505n 3.3v 1169.495n 3.3v 1169.505n 3.3v 1179.495n 3.3v 1179.505n 3.3v 1189.495n 3.3v 1189.505n 3.3v 1199.495n 3.3v 1199.505n 3.3v 1209.495n 3.3v 1209.505n 0.0v 1219.495n 0.0v 1219.505n 0.0v 1229.495n 0.0v 1229.505n 0.0v 1239.495n 0.0v 1239.505n 0.0v 1249.495n 0.0v 1249.505n 3.3v 1259.495n 3.3v 1259.505n 3.3v 1269.495n 3.3v 1269.505n 3.3v 1279.495n 3.3v 1279.505n 3.3v 1289.495n 3.3v 1289.505n 3.3v 1299.495n 3.3v 1299.505n 3.3v 1309.495n 3.3v 1309.505n 0.0v 1319.495n 0.0v 1319.505n 0.0v 1329.495n 0.0v 1329.505n 0.0v 1339.495n 0.0v 1339.505n 0.0v 1349.495n 0.0v 1349.505n 0.0v 1359.495n 0.0v 1359.505n 0.0v 1369.495n 0.0v 1369.505n 0.0v 1379.495n 0.0v 1379.505n 0.0v 1389.495n 0.0v 1389.505n 0.0v 1399.495n 0.0v 1399.505n 0.0v 1409.495n 0.0v 1409.505n 0.0v 1419.495n 0.0v 1419.505n 0.0v 1429.495n 0.0v 1429.505n 0.0v 1439.495n 0.0v 1439.505n 3.3v 1449.495n 3.3v 1449.505n 3.3v 1459.495n 3.3v 1459.505n 3.3v 1469.495n 3.3v 1469.505n 3.3v 1479.495n 3.3v 1479.505n 3.3v 1489.495n 3.3v 1489.505n 3.3v 1499.495n 3.3v 1499.505n 3.3v 1509.495n 3.3v 1509.505n 3.3v 1519.495n 3.3v 1519.505n 3.3v 1529.495n 3.3v 1529.505n 3.3v 1539.495n 3.3v 1539.505n 3.3v 1549.495n 3.3v 1549.505n 3.3v 1559.495n 3.3v 1559.505n 0.0v 1569.495n 0.0v 1569.505n 0.0v 1579.495n 0.0v 1579.505n 0.0v 1589.495n 0.0v 1589.505n 0.0v 1599.495n 0.0v 1599.505n 0.0v 1609.495n 0.0v 1609.505n 0.0v 1619.495n 0.0v 1619.505n 0.0v 1629.495n 0.0v 1629.505n 0.0v 1639.495n 0.0v 1639.505n 0.0v 1649.495n 0.0v 1649.505n 0.0v 1659.495n 0.0v 1659.505n 0.0v 1669.495n 0.0v 1669.505n 0.0v 1679.495n 0.0v 1679.505n 0.0v 1689.495n 0.0v 1689.505n 0.0v 1699.495n 0.0v 1699.505n 0.0v 1709.495n 0.0v 1709.505n 0.0v 1719.495n 0.0v 1719.505n 0.0v 1729.495n 0.0v 1729.505n 3.3v 1739.495n 3.3v 1739.505n 3.3v 1749.495n 3.3v 1749.505n 0.0v 1759.495n 0.0v 1759.505n 0.0v 1769.495n 0.0v 1769.505n 0.0v 1779.495n 0.0v 1779.505n 0.0v 1789.495n 0.0v 1789.505n 0.0v 1799.495n 0.0v 1799.505n 0.0v 1809.495n 0.0v 1809.505n 0.0v 1819.495n 0.0v 1819.505n 0.0v 1829.495n 0.0v 1829.505n 0.0v 1839.495n 0.0v 1839.505n 0.0v 1849.495n 0.0v 1849.505n 0.0v 1859.495n 0.0v 1859.505n 0.0v 1869.495n 0.0v 1869.505n 0.0v 1879.495n 0.0v 1879.505n 3.3v 1889.495n 3.3v 1889.505n 3.3v 1899.495n 3.3v 1899.505n 3.3v 1909.495n 3.3v 1909.505n 0.0v 1919.495n 0.0v 1919.505n 0.0v 1929.495n 0.0v 1929.505n 0.0v 1939.495n 0.0v 1939.505n 3.3v 1949.495n 3.3v 1949.505n 3.3v 1959.495n 3.3v 1959.505n 3.3v 1969.495n 3.3v 1969.505n 3.3v 1979.495n 3.3v 1979.505n 3.3v 1989.495n 3.3v 1989.505n 3.3v 1999.495n 3.3v 1999.505n 3.3v 2009.495n 3.3v 2009.505n 3.3v 2019.495n 3.3v 2019.505n 0.0v 2029.495n 0.0v 2029.505n 3.3v 2039.495n 3.3v 2039.505n 3.3v 2049.495n 3.3v 2049.505n 3.3v )
* (time, data): [(0, 0), (10, 1), (20, 0), (30, 0), (40, 0), (50, 0), (60, 0), (70, 1), (80, 1), (90, 1), (100, 1), (110, 1), (120, 0), (130, 0), (140, 0), (150, 0), (160, 0), (170, 1), (180, 1), (190, 1), (200, 1), (210, 1), (220, 1), (230, 1), (240, 1), (250, 1), (260, 1), (270, 1), (280, 1), (290, 1), (300, 1), (310, 1), (320, 1), (330, 1), (340, 1), (350, 1), (360, 1), (370, 1), (380, 0), (390, 0), (400, 0), (410, 0), (420, 0), (430, 0), (440, 0), (450, 0), (460, 0), (470, 0), (480, 0), (490, 0), (500, 0), (510, 0), (520, 0), (530, 0), (540, 0), (550, 0), (560, 0), (570, 0), (580, 0), (590, 0), (600, 0), (610, 0), (620, 0), (630, 0), (640, 0), (650, 0), (660, 0), (670, 0), (680, 1), (690, 1), (700, 1), (710, 1), (720, 0), (730, 0), (740, 0), (750, 0), (760, 0), (770, 0), (780, 0), (790, 0), (800, 0), (810, 0), (820, 0), (830, 0), (840, 0), (850, 0), (860, 0), (870, 1), (880, 1), (890, 1), (900, 1), (910, 1), (920, 1), (930, 1), (940, 0), (950, 0), (960, 0), (970, 0), (980, 0), (990, 0), (1000, 0), (1010, 0), (1020, 0), (1030, 0), (1040, 1), (1050, 1), (1060, 1), (1070, 1), (1080, 1), (1090, 1), (1100, 0), (1110, 1), (1120, 1), (1130, 1), (1140, 1), (1150, 1), (1160, 1), (1170, 1), (1180, 1), (1190, 1), (1200, 1), (1210, 0), (1220, 0), (1230, 0), (1240, 0), (1250, 0), (1260, 0), (1270, 0), (1280, 0), (1290, 0), (1300, 0), (1310, 0), (1320, 0), (1330, 0), (1340, 0), (1350, 0), (1360, 0), (1370, 0), (1380, 0), (1390, 0), (1400, 0), (1410, 0), (1420, 0), (1430, 0), (1440, 0), (1450, 0), (1460, 0), (1470, 0), (1480, 0), (1490, 0), (1500, 0), (1510, 0), (1520, 0), (1530, 0), (1540, 0), (1550, 0), (1560, 0), (1570, 0), (1580, 0), (1590, 0), (1600, 0), (1610, 0), (1620, 0), (1630, 0), (1640, 0), (1650, 0), (1660, 0), (1670, 0), (1680, 0), (1690, 0), (1700, 0), (1710, 0), (1720, 0), (1730, 0), (1740, 0), (1750, 0), (1760, 0), (1770, 1), (1780, 1), (1790, 1), (1800, 1), (1810, 1), (1820, 1), (1830, 1), (1840, 1), (1850, 1), (1860, 1), (1870, 1), (1880, 0), (1890, 0), (1900, 0), (1910, 0), (1920, 0), (1930, 0), (1940, 1), (1950, 1), (1960, 1), (1970, 1), (1980, 1), (1990, 1), (2000, 0), (2010, 0), (2020, 1), (2030, 1), (2040, 1), (2050, 1)]
Vdin1_20  din1_20  0 PWL (0n 0.0v 9.495n 0.0v 9.505n 3.3v 19.495n 3.3v 19.505n 0.0v 29.495n 0.0v 29.505n 0.0v 39.495n 0.0v 39.505n 0.0v 49.495n 0.0v 49.505n 0.0v 59.495n 0.0v 59.505n 0.0v 69.495n 0.0v 69.505n 3.3v 79.495n 3.3v 79.505n 3.3v 89.495n 3.3v 89.505n 3.3v 99.495n 3.3v 99.505n 3.3v 109.495n 3.3v 109.505n 3.3v 119.495n 3.3v 119.505n 0.0v 129.495n 0.0v 129.505n 0.0v 139.495n 0.0v 139.505n 0.0v 149.495n 0.0v 149.505n 0.0v 159.495n 0.0v 159.505n 0.0v 169.495n 0.0v 169.505n 3.3v 179.495n 3.3v 179.505n 3.3v 189.495n 3.3v 189.505n 3.3v 199.495n 3.3v 199.505n 3.3v 209.495n 3.3v 209.505n 3.3v 219.495n 3.3v 219.505n 3.3v 229.495n 3.3v 229.505n 3.3v 239.495n 3.3v 239.505n 3.3v 249.495n 3.3v 249.505n 3.3v 259.495n 3.3v 259.505n 3.3v 269.495n 3.3v 269.505n 3.3v 279.495n 3.3v 279.505n 3.3v 289.495n 3.3v 289.505n 3.3v 299.495n 3.3v 299.505n 3.3v 309.495n 3.3v 309.505n 3.3v 319.495n 3.3v 319.505n 3.3v 329.495n 3.3v 329.505n 3.3v 339.495n 3.3v 339.505n 3.3v 349.495n 3.3v 349.505n 3.3v 359.495n 3.3v 359.505n 3.3v 369.495n 3.3v 369.505n 3.3v 379.495n 3.3v 379.505n 0.0v 389.495n 0.0v 389.505n 0.0v 399.495n 0.0v 399.505n 0.0v 409.495n 0.0v 409.505n 0.0v 419.495n 0.0v 419.505n 0.0v 429.495n 0.0v 429.505n 0.0v 439.495n 0.0v 439.505n 0.0v 449.495n 0.0v 449.505n 0.0v 459.495n 0.0v 459.505n 0.0v 469.495n 0.0v 469.505n 0.0v 479.495n 0.0v 479.505n 0.0v 489.495n 0.0v 489.505n 0.0v 499.495n 0.0v 499.505n 0.0v 509.495n 0.0v 509.505n 0.0v 519.495n 0.0v 519.505n 0.0v 529.495n 0.0v 529.505n 0.0v 539.495n 0.0v 539.505n 0.0v 549.495n 0.0v 549.505n 0.0v 559.495n 0.0v 559.505n 0.0v 569.495n 0.0v 569.505n 0.0v 579.495n 0.0v 579.505n 0.0v 589.495n 0.0v 589.505n 0.0v 599.495n 0.0v 599.505n 0.0v 609.495n 0.0v 609.505n 0.0v 619.495n 0.0v 619.505n 0.0v 629.495n 0.0v 629.505n 0.0v 639.495n 0.0v 639.505n 0.0v 649.495n 0.0v 649.505n 0.0v 659.495n 0.0v 659.505n 0.0v 669.495n 0.0v 669.505n 0.0v 679.495n 0.0v 679.505n 3.3v 689.495n 3.3v 689.505n 3.3v 699.495n 3.3v 699.505n 3.3v 709.495n 3.3v 709.505n 3.3v 719.495n 3.3v 719.505n 0.0v 729.495n 0.0v 729.505n 0.0v 739.495n 0.0v 739.505n 0.0v 749.495n 0.0v 749.505n 0.0v 759.495n 0.0v 759.505n 0.0v 769.495n 0.0v 769.505n 0.0v 779.495n 0.0v 779.505n 0.0v 789.495n 0.0v 789.505n 0.0v 799.495n 0.0v 799.505n 0.0v 809.495n 0.0v 809.505n 0.0v 819.495n 0.0v 819.505n 0.0v 829.495n 0.0v 829.505n 0.0v 839.495n 0.0v 839.505n 0.0v 849.495n 0.0v 849.505n 0.0v 859.495n 0.0v 859.505n 0.0v 869.495n 0.0v 869.505n 3.3v 879.495n 3.3v 879.505n 3.3v 889.495n 3.3v 889.505n 3.3v 899.495n 3.3v 899.505n 3.3v 909.495n 3.3v 909.505n 3.3v 919.495n 3.3v 919.505n 3.3v 929.495n 3.3v 929.505n 3.3v 939.495n 3.3v 939.505n 0.0v 949.495n 0.0v 949.505n 0.0v 959.495n 0.0v 959.505n 0.0v 969.495n 0.0v 969.505n 0.0v 979.495n 0.0v 979.505n 0.0v 989.495n 0.0v 989.505n 0.0v 999.495n 0.0v 999.505n 0.0v 1009.495n 0.0v 1009.505n 0.0v 1019.495n 0.0v 1019.505n 0.0v 1029.495n 0.0v 1029.505n 0.0v 1039.495n 0.0v 1039.505n 3.3v 1049.495n 3.3v 1049.505n 3.3v 1059.495n 3.3v 1059.505n 3.3v 1069.495n 3.3v 1069.505n 3.3v 1079.495n 3.3v 1079.505n 3.3v 1089.495n 3.3v 1089.505n 3.3v 1099.495n 3.3v 1099.505n 0.0v 1109.495n 0.0v 1109.505n 3.3v 1119.495n 3.3v 1119.505n 3.3v 1129.495n 3.3v 1129.505n 3.3v 1139.495n 3.3v 1139.505n 3.3v 1149.495n 3.3v 1149.505n 3.3v 1159.495n 3.3v 1159.505n 3.3v 1169.495n 3.3v 1169.505n 3.3v 1179.495n 3.3v 1179.505n 3.3v 1189.495n 3.3v 1189.505n 3.3v 1199.495n 3.3v 1199.505n 3.3v 1209.495n 3.3v 1209.505n 0.0v 1219.495n 0.0v 1219.505n 0.0v 1229.495n 0.0v 1229.505n 0.0v 1239.495n 0.0v 1239.505n 0.0v 1249.495n 0.0v 1249.505n 0.0v 1259.495n 0.0v 1259.505n 0.0v 1269.495n 0.0v 1269.505n 0.0v 1279.495n 0.0v 1279.505n 0.0v 1289.495n 0.0v 1289.505n 0.0v 1299.495n 0.0v 1299.505n 0.0v 1309.495n 0.0v 1309.505n 0.0v 1319.495n 0.0v 1319.505n 0.0v 1329.495n 0.0v 1329.505n 0.0v 1339.495n 0.0v 1339.505n 0.0v 1349.495n 0.0v 1349.505n 0.0v 1359.495n 0.0v 1359.505n 0.0v 1369.495n 0.0v 1369.505n 0.0v 1379.495n 0.0v 1379.505n 0.0v 1389.495n 0.0v 1389.505n 0.0v 1399.495n 0.0v 1399.505n 0.0v 1409.495n 0.0v 1409.505n 0.0v 1419.495n 0.0v 1419.505n 0.0v 1429.495n 0.0v 1429.505n 0.0v 1439.495n 0.0v 1439.505n 0.0v 1449.495n 0.0v 1449.505n 0.0v 1459.495n 0.0v 1459.505n 0.0v 1469.495n 0.0v 1469.505n 0.0v 1479.495n 0.0v 1479.505n 0.0v 1489.495n 0.0v 1489.505n 0.0v 1499.495n 0.0v 1499.505n 0.0v 1509.495n 0.0v 1509.505n 0.0v 1519.495n 0.0v 1519.505n 0.0v 1529.495n 0.0v 1529.505n 0.0v 1539.495n 0.0v 1539.505n 0.0v 1549.495n 0.0v 1549.505n 0.0v 1559.495n 0.0v 1559.505n 0.0v 1569.495n 0.0v 1569.505n 0.0v 1579.495n 0.0v 1579.505n 0.0v 1589.495n 0.0v 1589.505n 0.0v 1599.495n 0.0v 1599.505n 0.0v 1609.495n 0.0v 1609.505n 0.0v 1619.495n 0.0v 1619.505n 0.0v 1629.495n 0.0v 1629.505n 0.0v 1639.495n 0.0v 1639.505n 0.0v 1649.495n 0.0v 1649.505n 0.0v 1659.495n 0.0v 1659.505n 0.0v 1669.495n 0.0v 1669.505n 0.0v 1679.495n 0.0v 1679.505n 0.0v 1689.495n 0.0v 1689.505n 0.0v 1699.495n 0.0v 1699.505n 0.0v 1709.495n 0.0v 1709.505n 0.0v 1719.495n 0.0v 1719.505n 0.0v 1729.495n 0.0v 1729.505n 0.0v 1739.495n 0.0v 1739.505n 0.0v 1749.495n 0.0v 1749.505n 0.0v 1759.495n 0.0v 1759.505n 0.0v 1769.495n 0.0v 1769.505n 3.3v 1779.495n 3.3v 1779.505n 3.3v 1789.495n 3.3v 1789.505n 3.3v 1799.495n 3.3v 1799.505n 3.3v 1809.495n 3.3v 1809.505n 3.3v 1819.495n 3.3v 1819.505n 3.3v 1829.495n 3.3v 1829.505n 3.3v 1839.495n 3.3v 1839.505n 3.3v 1849.495n 3.3v 1849.505n 3.3v 1859.495n 3.3v 1859.505n 3.3v 1869.495n 3.3v 1869.505n 3.3v 1879.495n 3.3v 1879.505n 0.0v 1889.495n 0.0v 1889.505n 0.0v 1899.495n 0.0v 1899.505n 0.0v 1909.495n 0.0v 1909.505n 0.0v 1919.495n 0.0v 1919.505n 0.0v 1929.495n 0.0v 1929.505n 0.0v 1939.495n 0.0v 1939.505n 3.3v 1949.495n 3.3v 1949.505n 3.3v 1959.495n 3.3v 1959.505n 3.3v 1969.495n 3.3v 1969.505n 3.3v 1979.495n 3.3v 1979.505n 3.3v 1989.495n 3.3v 1989.505n 3.3v 1999.495n 3.3v 1999.505n 0.0v 2009.495n 0.0v 2009.505n 0.0v 2019.495n 0.0v 2019.505n 3.3v 2029.495n 3.3v 2029.505n 3.3v 2039.495n 3.3v 2039.505n 3.3v 2049.495n 3.3v 2049.505n 3.3v )
* (time, data): [(0, 0), (10, 0), (20, 0), (30, 0), (40, 0), (50, 0), (60, 0), (70, 0), (80, 0), (90, 0), (100, 0), (110, 0), (120, 0), (130, 0), (140, 0), (150, 0), (160, 0), (170, 0), (180, 0), (190, 0), (200, 0), (210, 0), (220, 0), (230, 0), (240, 0), (250, 0), (260, 0), (270, 0), (280, 0), (290, 0), (300, 0), (310, 0), (320, 0), (330, 0), (340, 0), (350, 0), (360, 0), (370, 0), (380, 1), (390, 1), (400, 0), (410, 0), (420, 0), (430, 0), (440, 0), (450, 0), (460, 0), (470, 0), (480, 0), (490, 0), (500, 0), (510, 0), (520, 0), (530, 0), (540, 0), (550, 0), (560, 0), (570, 0), (580, 0), (590, 0), (600, 0), (610, 0), (620, 0), (630, 0), (640, 0), (650, 0), (660, 1), (670, 1), (680, 0), (690, 0), (700, 0), (710, 1), (720, 0), (730, 0), (740, 0), (750, 0), (760, 0), (770, 0), (780, 0), (790, 0), (800, 0), (810, 0), (820, 0), (830, 0), (840, 0), (850, 0), (860, 0), (870, 1), (880, 1), (890, 1), (900, 1), (910, 1), (920, 1), (930, 1), (940, 1), (950, 1), (960, 1), (970, 1), (980, 1), (990, 1), (1000, 1), (1010, 1), (1020, 1), (1030, 1), (1040, 1), (1050, 1), (1060, 1), (1070, 1), (1080, 1), (1090, 1), (1100, 1), (1110, 0), (1120, 0), (1130, 0), (1140, 1), (1150, 1), (1160, 1), (1170, 1), (1180, 1), (1190, 1), (1200, 1), (1210, 0), (1220, 0), (1230, 0), (1240, 0), (1250, 1), (1260, 1), (1270, 1), (1280, 1), (1290, 1), (1300, 1), (1310, 0), (1320, 0), (1330, 0), (1340, 0), (1350, 0), (1360, 0), (1370, 0), (1380, 0), (1390, 0), (1400, 0), (1410, 0), (1420, 0), (1430, 0), (1440, 1), (1450, 1), (1460, 1), (1470, 1), (1480, 1), (1490, 0), (1500, 0), (1510, 0), (1520, 0), (1530, 0), (1540, 0), (1550, 0), (1560, 1), (1570, 1), (1580, 1), (1590, 1), (1600, 0), (1610, 0), (1620, 0), (1630, 0), (1640, 0), (1650, 0), (1660, 0), (1670, 0), (1680, 0), (1690, 0), (1700, 0), (1710, 0), (1720, 0), (1730, 1), (1740, 1), (1750, 0), (1760, 0), (1770, 1), (1780, 1), (1790, 1), (1800, 1), (1810, 1), (1820, 1), (1830, 1), (1840, 1), (1850, 1), (1860, 1), (1870, 1), (1880, 0), (1890, 0), (1900, 0), (1910, 1), (1920, 1), (1930, 1), (1940, 1), (1950, 1), (1960, 1), (1970, 1), (1980, 1), (1990, 1), (2000, 0), (2010, 0), (2020, 1), (2030, 0), (2040, 0), (2050, 0)]
Vdin1_21  din1_21  0 PWL (0n 0.0v 9.495n 0.0v 9.505n 0.0v 19.495n 0.0v 19.505n 0.0v 29.495n 0.0v 29.505n 0.0v 39.495n 0.0v 39.505n 0.0v 49.495n 0.0v 49.505n 0.0v 59.495n 0.0v 59.505n 0.0v 69.495n 0.0v 69.505n 0.0v 79.495n 0.0v 79.505n 0.0v 89.495n 0.0v 89.505n 0.0v 99.495n 0.0v 99.505n 0.0v 109.495n 0.0v 109.505n 0.0v 119.495n 0.0v 119.505n 0.0v 129.495n 0.0v 129.505n 0.0v 139.495n 0.0v 139.505n 0.0v 149.495n 0.0v 149.505n 0.0v 159.495n 0.0v 159.505n 0.0v 169.495n 0.0v 169.505n 0.0v 179.495n 0.0v 179.505n 0.0v 189.495n 0.0v 189.505n 0.0v 199.495n 0.0v 199.505n 0.0v 209.495n 0.0v 209.505n 0.0v 219.495n 0.0v 219.505n 0.0v 229.495n 0.0v 229.505n 0.0v 239.495n 0.0v 239.505n 0.0v 249.495n 0.0v 249.505n 0.0v 259.495n 0.0v 259.505n 0.0v 269.495n 0.0v 269.505n 0.0v 279.495n 0.0v 279.505n 0.0v 289.495n 0.0v 289.505n 0.0v 299.495n 0.0v 299.505n 0.0v 309.495n 0.0v 309.505n 0.0v 319.495n 0.0v 319.505n 0.0v 329.495n 0.0v 329.505n 0.0v 339.495n 0.0v 339.505n 0.0v 349.495n 0.0v 349.505n 0.0v 359.495n 0.0v 359.505n 0.0v 369.495n 0.0v 369.505n 0.0v 379.495n 0.0v 379.505n 3.3v 389.495n 3.3v 389.505n 3.3v 399.495n 3.3v 399.505n 0.0v 409.495n 0.0v 409.505n 0.0v 419.495n 0.0v 419.505n 0.0v 429.495n 0.0v 429.505n 0.0v 439.495n 0.0v 439.505n 0.0v 449.495n 0.0v 449.505n 0.0v 459.495n 0.0v 459.505n 0.0v 469.495n 0.0v 469.505n 0.0v 479.495n 0.0v 479.505n 0.0v 489.495n 0.0v 489.505n 0.0v 499.495n 0.0v 499.505n 0.0v 509.495n 0.0v 509.505n 0.0v 519.495n 0.0v 519.505n 0.0v 529.495n 0.0v 529.505n 0.0v 539.495n 0.0v 539.505n 0.0v 549.495n 0.0v 549.505n 0.0v 559.495n 0.0v 559.505n 0.0v 569.495n 0.0v 569.505n 0.0v 579.495n 0.0v 579.505n 0.0v 589.495n 0.0v 589.505n 0.0v 599.495n 0.0v 599.505n 0.0v 609.495n 0.0v 609.505n 0.0v 619.495n 0.0v 619.505n 0.0v 629.495n 0.0v 629.505n 0.0v 639.495n 0.0v 639.505n 0.0v 649.495n 0.0v 649.505n 0.0v 659.495n 0.0v 659.505n 3.3v 669.495n 3.3v 669.505n 3.3v 679.495n 3.3v 679.505n 0.0v 689.495n 0.0v 689.505n 0.0v 699.495n 0.0v 699.505n 0.0v 709.495n 0.0v 709.505n 3.3v 719.495n 3.3v 719.505n 0.0v 729.495n 0.0v 729.505n 0.0v 739.495n 0.0v 739.505n 0.0v 749.495n 0.0v 749.505n 0.0v 759.495n 0.0v 759.505n 0.0v 769.495n 0.0v 769.505n 0.0v 779.495n 0.0v 779.505n 0.0v 789.495n 0.0v 789.505n 0.0v 799.495n 0.0v 799.505n 0.0v 809.495n 0.0v 809.505n 0.0v 819.495n 0.0v 819.505n 0.0v 829.495n 0.0v 829.505n 0.0v 839.495n 0.0v 839.505n 0.0v 849.495n 0.0v 849.505n 0.0v 859.495n 0.0v 859.505n 0.0v 869.495n 0.0v 869.505n 3.3v 879.495n 3.3v 879.505n 3.3v 889.495n 3.3v 889.505n 3.3v 899.495n 3.3v 899.505n 3.3v 909.495n 3.3v 909.505n 3.3v 919.495n 3.3v 919.505n 3.3v 929.495n 3.3v 929.505n 3.3v 939.495n 3.3v 939.505n 3.3v 949.495n 3.3v 949.505n 3.3v 959.495n 3.3v 959.505n 3.3v 969.495n 3.3v 969.505n 3.3v 979.495n 3.3v 979.505n 3.3v 989.495n 3.3v 989.505n 3.3v 999.495n 3.3v 999.505n 3.3v 1009.495n 3.3v 1009.505n 3.3v 1019.495n 3.3v 1019.505n 3.3v 1029.495n 3.3v 1029.505n 3.3v 1039.495n 3.3v 1039.505n 3.3v 1049.495n 3.3v 1049.505n 3.3v 1059.495n 3.3v 1059.505n 3.3v 1069.495n 3.3v 1069.505n 3.3v 1079.495n 3.3v 1079.505n 3.3v 1089.495n 3.3v 1089.505n 3.3v 1099.495n 3.3v 1099.505n 3.3v 1109.495n 3.3v 1109.505n 0.0v 1119.495n 0.0v 1119.505n 0.0v 1129.495n 0.0v 1129.505n 0.0v 1139.495n 0.0v 1139.505n 3.3v 1149.495n 3.3v 1149.505n 3.3v 1159.495n 3.3v 1159.505n 3.3v 1169.495n 3.3v 1169.505n 3.3v 1179.495n 3.3v 1179.505n 3.3v 1189.495n 3.3v 1189.505n 3.3v 1199.495n 3.3v 1199.505n 3.3v 1209.495n 3.3v 1209.505n 0.0v 1219.495n 0.0v 1219.505n 0.0v 1229.495n 0.0v 1229.505n 0.0v 1239.495n 0.0v 1239.505n 0.0v 1249.495n 0.0v 1249.505n 3.3v 1259.495n 3.3v 1259.505n 3.3v 1269.495n 3.3v 1269.505n 3.3v 1279.495n 3.3v 1279.505n 3.3v 1289.495n 3.3v 1289.505n 3.3v 1299.495n 3.3v 1299.505n 3.3v 1309.495n 3.3v 1309.505n 0.0v 1319.495n 0.0v 1319.505n 0.0v 1329.495n 0.0v 1329.505n 0.0v 1339.495n 0.0v 1339.505n 0.0v 1349.495n 0.0v 1349.505n 0.0v 1359.495n 0.0v 1359.505n 0.0v 1369.495n 0.0v 1369.505n 0.0v 1379.495n 0.0v 1379.505n 0.0v 1389.495n 0.0v 1389.505n 0.0v 1399.495n 0.0v 1399.505n 0.0v 1409.495n 0.0v 1409.505n 0.0v 1419.495n 0.0v 1419.505n 0.0v 1429.495n 0.0v 1429.505n 0.0v 1439.495n 0.0v 1439.505n 3.3v 1449.495n 3.3v 1449.505n 3.3v 1459.495n 3.3v 1459.505n 3.3v 1469.495n 3.3v 1469.505n 3.3v 1479.495n 3.3v 1479.505n 3.3v 1489.495n 3.3v 1489.505n 0.0v 1499.495n 0.0v 1499.505n 0.0v 1509.495n 0.0v 1509.505n 0.0v 1519.495n 0.0v 1519.505n 0.0v 1529.495n 0.0v 1529.505n 0.0v 1539.495n 0.0v 1539.505n 0.0v 1549.495n 0.0v 1549.505n 0.0v 1559.495n 0.0v 1559.505n 3.3v 1569.495n 3.3v 1569.505n 3.3v 1579.495n 3.3v 1579.505n 3.3v 1589.495n 3.3v 1589.505n 3.3v 1599.495n 3.3v 1599.505n 0.0v 1609.495n 0.0v 1609.505n 0.0v 1619.495n 0.0v 1619.505n 0.0v 1629.495n 0.0v 1629.505n 0.0v 1639.495n 0.0v 1639.505n 0.0v 1649.495n 0.0v 1649.505n 0.0v 1659.495n 0.0v 1659.505n 0.0v 1669.495n 0.0v 1669.505n 0.0v 1679.495n 0.0v 1679.505n 0.0v 1689.495n 0.0v 1689.505n 0.0v 1699.495n 0.0v 1699.505n 0.0v 1709.495n 0.0v 1709.505n 0.0v 1719.495n 0.0v 1719.505n 0.0v 1729.495n 0.0v 1729.505n 3.3v 1739.495n 3.3v 1739.505n 3.3v 1749.495n 3.3v 1749.505n 0.0v 1759.495n 0.0v 1759.505n 0.0v 1769.495n 0.0v 1769.505n 3.3v 1779.495n 3.3v 1779.505n 3.3v 1789.495n 3.3v 1789.505n 3.3v 1799.495n 3.3v 1799.505n 3.3v 1809.495n 3.3v 1809.505n 3.3v 1819.495n 3.3v 1819.505n 3.3v 1829.495n 3.3v 1829.505n 3.3v 1839.495n 3.3v 1839.505n 3.3v 1849.495n 3.3v 1849.505n 3.3v 1859.495n 3.3v 1859.505n 3.3v 1869.495n 3.3v 1869.505n 3.3v 1879.495n 3.3v 1879.505n 0.0v 1889.495n 0.0v 1889.505n 0.0v 1899.495n 0.0v 1899.505n 0.0v 1909.495n 0.0v 1909.505n 3.3v 1919.495n 3.3v 1919.505n 3.3v 1929.495n 3.3v 1929.505n 3.3v 1939.495n 3.3v 1939.505n 3.3v 1949.495n 3.3v 1949.505n 3.3v 1959.495n 3.3v 1959.505n 3.3v 1969.495n 3.3v 1969.505n 3.3v 1979.495n 3.3v 1979.505n 3.3v 1989.495n 3.3v 1989.505n 3.3v 1999.495n 3.3v 1999.505n 0.0v 2009.495n 0.0v 2009.505n 0.0v 2019.495n 0.0v 2019.505n 3.3v 2029.495n 3.3v 2029.505n 0.0v 2039.495n 0.0v 2039.505n 0.0v 2049.495n 0.0v 2049.505n 0.0v )
* (time, data): [(0, 0), (10, 0), (20, 1), (30, 0), (40, 0), (50, 0), (60, 0), (70, 1), (80, 0), (90, 0), (100, 0), (110, 0), (120, 1), (130, 1), (140, 0), (150, 0), (160, 0), (170, 0), (180, 0), (190, 0), (200, 0), (210, 0), (220, 0), (230, 0), (240, 0), (250, 0), (260, 0), (270, 0), (280, 0), (290, 0), (300, 0), (310, 0), (320, 0), (330, 0), (340, 0), (350, 0), (360, 0), (370, 1), (380, 0), (390, 0), (400, 1), (410, 1), (420, 1), (430, 1), (440, 1), (450, 1), (460, 1), (470, 1), (480, 1), (490, 1), (500, 0), (510, 0), (520, 0), (530, 0), (540, 0), (550, 0), (560, 0), (570, 0), (580, 0), (590, 0), (600, 0), (610, 0), (620, 0), (630, 0), (640, 0), (650, 0), (660, 1), (670, 1), (680, 1), (690, 1), (700, 1), (710, 1), (720, 0), (730, 0), (740, 0), (750, 0), (760, 0), (770, 0), (780, 0), (790, 0), (800, 0), (810, 0), (820, 0), (830, 0), (840, 0), (850, 0), (860, 0), (870, 0), (880, 0), (890, 0), (900, 0), (910, 0), (920, 0), (930, 0), (940, 0), (950, 0), (960, 0), (970, 0), (980, 0), (990, 0), (1000, 0), (1010, 0), (1020, 0), (1030, 0), (1040, 0), (1050, 0), (1060, 0), (1070, 0), (1080, 0), (1090, 0), (1100, 0), (1110, 0), (1120, 0), (1130, 0), (1140, 1), (1150, 1), (1160, 1), (1170, 1), (1180, 1), (1190, 1), (1200, 1), (1210, 1), (1220, 1), (1230, 1), (1240, 1), (1250, 0), (1260, 0), (1270, 0), (1280, 0), (1290, 0), (1300, 0), (1310, 1), (1320, 1), (1330, 1), (1340, 1), (1350, 1), (1360, 1), (1370, 1), (1380, 1), (1390, 1), (1400, 1), (1410, 1), (1420, 1), (1430, 1), (1440, 1), (1450, 1), (1460, 1), (1470, 1), (1480, 1), (1490, 0), (1500, 0), (1510, 0), (1520, 0), (1530, 0), (1540, 0), (1550, 1), (1560, 1), (1570, 1), (1580, 1), (1590, 1), (1600, 1), (1610, 1), (1620, 1), (1630, 1), (1640, 1), (1650, 1), (1660, 1), (1670, 1), (1680, 1), (1690, 1), (1700, 1), (1710, 1), (1720, 1), (1730, 0), (1740, 0), (1750, 0), (1760, 0), (1770, 1), (1780, 1), (1790, 1), (1800, 1), (1810, 1), (1820, 0), (1830, 0), (1840, 0), (1850, 0), (1860, 0), (1870, 0), (1880, 1), (1890, 1), (1900, 1), (1910, 1), (1920, 1), (1930, 1), (1940, 1), (1950, 1), (1960, 1), (1970, 1), (1980, 0), (1990, 0), (2000, 1), (2010, 1), (2020, 1), (2030, 0), (2040, 0), (2050, 0)]
Vdin1_22  din1_22  0 PWL (0n 0.0v 9.495n 0.0v 9.505n 0.0v 19.495n 0.0v 19.505n 3.3v 29.495n 3.3v 29.505n 0.0v 39.495n 0.0v 39.505n 0.0v 49.495n 0.0v 49.505n 0.0v 59.495n 0.0v 59.505n 0.0v 69.495n 0.0v 69.505n 3.3v 79.495n 3.3v 79.505n 0.0v 89.495n 0.0v 89.505n 0.0v 99.495n 0.0v 99.505n 0.0v 109.495n 0.0v 109.505n 0.0v 119.495n 0.0v 119.505n 3.3v 129.495n 3.3v 129.505n 3.3v 139.495n 3.3v 139.505n 0.0v 149.495n 0.0v 149.505n 0.0v 159.495n 0.0v 159.505n 0.0v 169.495n 0.0v 169.505n 0.0v 179.495n 0.0v 179.505n 0.0v 189.495n 0.0v 189.505n 0.0v 199.495n 0.0v 199.505n 0.0v 209.495n 0.0v 209.505n 0.0v 219.495n 0.0v 219.505n 0.0v 229.495n 0.0v 229.505n 0.0v 239.495n 0.0v 239.505n 0.0v 249.495n 0.0v 249.505n 0.0v 259.495n 0.0v 259.505n 0.0v 269.495n 0.0v 269.505n 0.0v 279.495n 0.0v 279.505n 0.0v 289.495n 0.0v 289.505n 0.0v 299.495n 0.0v 299.505n 0.0v 309.495n 0.0v 309.505n 0.0v 319.495n 0.0v 319.505n 0.0v 329.495n 0.0v 329.505n 0.0v 339.495n 0.0v 339.505n 0.0v 349.495n 0.0v 349.505n 0.0v 359.495n 0.0v 359.505n 0.0v 369.495n 0.0v 369.505n 3.3v 379.495n 3.3v 379.505n 0.0v 389.495n 0.0v 389.505n 0.0v 399.495n 0.0v 399.505n 3.3v 409.495n 3.3v 409.505n 3.3v 419.495n 3.3v 419.505n 3.3v 429.495n 3.3v 429.505n 3.3v 439.495n 3.3v 439.505n 3.3v 449.495n 3.3v 449.505n 3.3v 459.495n 3.3v 459.505n 3.3v 469.495n 3.3v 469.505n 3.3v 479.495n 3.3v 479.505n 3.3v 489.495n 3.3v 489.505n 3.3v 499.495n 3.3v 499.505n 0.0v 509.495n 0.0v 509.505n 0.0v 519.495n 0.0v 519.505n 0.0v 529.495n 0.0v 529.505n 0.0v 539.495n 0.0v 539.505n 0.0v 549.495n 0.0v 549.505n 0.0v 559.495n 0.0v 559.505n 0.0v 569.495n 0.0v 569.505n 0.0v 579.495n 0.0v 579.505n 0.0v 589.495n 0.0v 589.505n 0.0v 599.495n 0.0v 599.505n 0.0v 609.495n 0.0v 609.505n 0.0v 619.495n 0.0v 619.505n 0.0v 629.495n 0.0v 629.505n 0.0v 639.495n 0.0v 639.505n 0.0v 649.495n 0.0v 649.505n 0.0v 659.495n 0.0v 659.505n 3.3v 669.495n 3.3v 669.505n 3.3v 679.495n 3.3v 679.505n 3.3v 689.495n 3.3v 689.505n 3.3v 699.495n 3.3v 699.505n 3.3v 709.495n 3.3v 709.505n 3.3v 719.495n 3.3v 719.505n 0.0v 729.495n 0.0v 729.505n 0.0v 739.495n 0.0v 739.505n 0.0v 749.495n 0.0v 749.505n 0.0v 759.495n 0.0v 759.505n 0.0v 769.495n 0.0v 769.505n 0.0v 779.495n 0.0v 779.505n 0.0v 789.495n 0.0v 789.505n 0.0v 799.495n 0.0v 799.505n 0.0v 809.495n 0.0v 809.505n 0.0v 819.495n 0.0v 819.505n 0.0v 829.495n 0.0v 829.505n 0.0v 839.495n 0.0v 839.505n 0.0v 849.495n 0.0v 849.505n 0.0v 859.495n 0.0v 859.505n 0.0v 869.495n 0.0v 869.505n 0.0v 879.495n 0.0v 879.505n 0.0v 889.495n 0.0v 889.505n 0.0v 899.495n 0.0v 899.505n 0.0v 909.495n 0.0v 909.505n 0.0v 919.495n 0.0v 919.505n 0.0v 929.495n 0.0v 929.505n 0.0v 939.495n 0.0v 939.505n 0.0v 949.495n 0.0v 949.505n 0.0v 959.495n 0.0v 959.505n 0.0v 969.495n 0.0v 969.505n 0.0v 979.495n 0.0v 979.505n 0.0v 989.495n 0.0v 989.505n 0.0v 999.495n 0.0v 999.505n 0.0v 1009.495n 0.0v 1009.505n 0.0v 1019.495n 0.0v 1019.505n 0.0v 1029.495n 0.0v 1029.505n 0.0v 1039.495n 0.0v 1039.505n 0.0v 1049.495n 0.0v 1049.505n 0.0v 1059.495n 0.0v 1059.505n 0.0v 1069.495n 0.0v 1069.505n 0.0v 1079.495n 0.0v 1079.505n 0.0v 1089.495n 0.0v 1089.505n 0.0v 1099.495n 0.0v 1099.505n 0.0v 1109.495n 0.0v 1109.505n 0.0v 1119.495n 0.0v 1119.505n 0.0v 1129.495n 0.0v 1129.505n 0.0v 1139.495n 0.0v 1139.505n 3.3v 1149.495n 3.3v 1149.505n 3.3v 1159.495n 3.3v 1159.505n 3.3v 1169.495n 3.3v 1169.505n 3.3v 1179.495n 3.3v 1179.505n 3.3v 1189.495n 3.3v 1189.505n 3.3v 1199.495n 3.3v 1199.505n 3.3v 1209.495n 3.3v 1209.505n 3.3v 1219.495n 3.3v 1219.505n 3.3v 1229.495n 3.3v 1229.505n 3.3v 1239.495n 3.3v 1239.505n 3.3v 1249.495n 3.3v 1249.505n 0.0v 1259.495n 0.0v 1259.505n 0.0v 1269.495n 0.0v 1269.505n 0.0v 1279.495n 0.0v 1279.505n 0.0v 1289.495n 0.0v 1289.505n 0.0v 1299.495n 0.0v 1299.505n 0.0v 1309.495n 0.0v 1309.505n 3.3v 1319.495n 3.3v 1319.505n 3.3v 1329.495n 3.3v 1329.505n 3.3v 1339.495n 3.3v 1339.505n 3.3v 1349.495n 3.3v 1349.505n 3.3v 1359.495n 3.3v 1359.505n 3.3v 1369.495n 3.3v 1369.505n 3.3v 1379.495n 3.3v 1379.505n 3.3v 1389.495n 3.3v 1389.505n 3.3v 1399.495n 3.3v 1399.505n 3.3v 1409.495n 3.3v 1409.505n 3.3v 1419.495n 3.3v 1419.505n 3.3v 1429.495n 3.3v 1429.505n 3.3v 1439.495n 3.3v 1439.505n 3.3v 1449.495n 3.3v 1449.505n 3.3v 1459.495n 3.3v 1459.505n 3.3v 1469.495n 3.3v 1469.505n 3.3v 1479.495n 3.3v 1479.505n 3.3v 1489.495n 3.3v 1489.505n 0.0v 1499.495n 0.0v 1499.505n 0.0v 1509.495n 0.0v 1509.505n 0.0v 1519.495n 0.0v 1519.505n 0.0v 1529.495n 0.0v 1529.505n 0.0v 1539.495n 0.0v 1539.505n 0.0v 1549.495n 0.0v 1549.505n 3.3v 1559.495n 3.3v 1559.505n 3.3v 1569.495n 3.3v 1569.505n 3.3v 1579.495n 3.3v 1579.505n 3.3v 1589.495n 3.3v 1589.505n 3.3v 1599.495n 3.3v 1599.505n 3.3v 1609.495n 3.3v 1609.505n 3.3v 1619.495n 3.3v 1619.505n 3.3v 1629.495n 3.3v 1629.505n 3.3v 1639.495n 3.3v 1639.505n 3.3v 1649.495n 3.3v 1649.505n 3.3v 1659.495n 3.3v 1659.505n 3.3v 1669.495n 3.3v 1669.505n 3.3v 1679.495n 3.3v 1679.505n 3.3v 1689.495n 3.3v 1689.505n 3.3v 1699.495n 3.3v 1699.505n 3.3v 1709.495n 3.3v 1709.505n 3.3v 1719.495n 3.3v 1719.505n 3.3v 1729.495n 3.3v 1729.505n 0.0v 1739.495n 0.0v 1739.505n 0.0v 1749.495n 0.0v 1749.505n 0.0v 1759.495n 0.0v 1759.505n 0.0v 1769.495n 0.0v 1769.505n 3.3v 1779.495n 3.3v 1779.505n 3.3v 1789.495n 3.3v 1789.505n 3.3v 1799.495n 3.3v 1799.505n 3.3v 1809.495n 3.3v 1809.505n 3.3v 1819.495n 3.3v 1819.505n 0.0v 1829.495n 0.0v 1829.505n 0.0v 1839.495n 0.0v 1839.505n 0.0v 1849.495n 0.0v 1849.505n 0.0v 1859.495n 0.0v 1859.505n 0.0v 1869.495n 0.0v 1869.505n 0.0v 1879.495n 0.0v 1879.505n 3.3v 1889.495n 3.3v 1889.505n 3.3v 1899.495n 3.3v 1899.505n 3.3v 1909.495n 3.3v 1909.505n 3.3v 1919.495n 3.3v 1919.505n 3.3v 1929.495n 3.3v 1929.505n 3.3v 1939.495n 3.3v 1939.505n 3.3v 1949.495n 3.3v 1949.505n 3.3v 1959.495n 3.3v 1959.505n 3.3v 1969.495n 3.3v 1969.505n 3.3v 1979.495n 3.3v 1979.505n 0.0v 1989.495n 0.0v 1989.505n 0.0v 1999.495n 0.0v 1999.505n 3.3v 2009.495n 3.3v 2009.505n 3.3v 2019.495n 3.3v 2019.505n 3.3v 2029.495n 3.3v 2029.505n 0.0v 2039.495n 0.0v 2039.505n 0.0v 2049.495n 0.0v 2049.505n 0.0v )
* (time, data): [(0, 0), (10, 0), (20, 0), (30, 1), (40, 1), (50, 1), (60, 1), (70, 1), (80, 0), (90, 0), (100, 0), (110, 0), (120, 0), (130, 0), (140, 1), (150, 1), (160, 1), (170, 1), (180, 1), (190, 1), (200, 1), (210, 1), (220, 1), (230, 1), (240, 1), (250, 1), (260, 1), (270, 1), (280, 1), (290, 1), (300, 1), (310, 1), (320, 1), (330, 1), (340, 1), (350, 1), (360, 1), (370, 1), (380, 0), (390, 0), (400, 0), (410, 0), (420, 0), (430, 0), (440, 0), (450, 0), (460, 0), (470, 0), (480, 0), (490, 0), (500, 0), (510, 0), (520, 0), (530, 0), (540, 0), (550, 0), (560, 0), (570, 0), (580, 0), (590, 0), (600, 0), (610, 0), (620, 0), (630, 0), (640, 0), (650, 0), (660, 1), (670, 1), (680, 1), (690, 1), (700, 1), (710, 1), (720, 0), (730, 0), (740, 0), (750, 0), (760, 0), (770, 0), (780, 0), (790, 0), (800, 0), (810, 0), (820, 0), (830, 0), (840, 0), (850, 0), (860, 0), (870, 1), (880, 1), (890, 1), (900, 1), (910, 1), (920, 1), (930, 1), (940, 1), (950, 0), (960, 0), (970, 0), (980, 0), (990, 0), (1000, 0), (1010, 0), (1020, 0), (1030, 0), (1040, 0), (1050, 0), (1060, 0), (1070, 0), (1080, 0), (1090, 0), (1100, 1), (1110, 1), (1120, 1), (1130, 1), (1140, 0), (1150, 0), (1160, 0), (1170, 0), (1180, 0), (1190, 0), (1200, 0), (1210, 1), (1220, 1), (1230, 1), (1240, 1), (1250, 0), (1260, 0), (1270, 0), (1280, 0), (1290, 0), (1300, 0), (1310, 0), (1320, 0), (1330, 0), (1340, 0), (1350, 0), (1360, 0), (1370, 0), (1380, 0), (1390, 0), (1400, 0), (1410, 0), (1420, 0), (1430, 0), (1440, 0), (1450, 0), (1460, 0), (1470, 0), (1480, 0), (1490, 0), (1500, 0), (1510, 0), (1520, 0), (1530, 0), (1540, 0), (1550, 0), (1560, 1), (1570, 1), (1580, 1), (1590, 1), (1600, 0), (1610, 0), (1620, 0), (1630, 0), (1640, 0), (1650, 0), (1660, 0), (1670, 0), (1680, 0), (1690, 0), (1700, 0), (1710, 0), (1720, 0), (1730, 0), (1740, 0), (1750, 1), (1760, 1), (1770, 1), (1780, 1), (1790, 1), (1800, 1), (1810, 1), (1820, 0), (1830, 0), (1840, 0), (1850, 0), (1860, 1), (1870, 1), (1880, 1), (1890, 1), (1900, 1), (1910, 1), (1920, 1), (1930, 1), (1940, 1), (1950, 1), (1960, 1), (1970, 1), (1980, 0), (1990, 0), (2000, 0), (2010, 0), (2020, 0), (2030, 0), (2040, 0), (2050, 0)]
Vdin1_23  din1_23  0 PWL (0n 0.0v 9.495n 0.0v 9.505n 0.0v 19.495n 0.0v 19.505n 0.0v 29.495n 0.0v 29.505n 3.3v 39.495n 3.3v 39.505n 3.3v 49.495n 3.3v 49.505n 3.3v 59.495n 3.3v 59.505n 3.3v 69.495n 3.3v 69.505n 3.3v 79.495n 3.3v 79.505n 0.0v 89.495n 0.0v 89.505n 0.0v 99.495n 0.0v 99.505n 0.0v 109.495n 0.0v 109.505n 0.0v 119.495n 0.0v 119.505n 0.0v 129.495n 0.0v 129.505n 0.0v 139.495n 0.0v 139.505n 3.3v 149.495n 3.3v 149.505n 3.3v 159.495n 3.3v 159.505n 3.3v 169.495n 3.3v 169.505n 3.3v 179.495n 3.3v 179.505n 3.3v 189.495n 3.3v 189.505n 3.3v 199.495n 3.3v 199.505n 3.3v 209.495n 3.3v 209.505n 3.3v 219.495n 3.3v 219.505n 3.3v 229.495n 3.3v 229.505n 3.3v 239.495n 3.3v 239.505n 3.3v 249.495n 3.3v 249.505n 3.3v 259.495n 3.3v 259.505n 3.3v 269.495n 3.3v 269.505n 3.3v 279.495n 3.3v 279.505n 3.3v 289.495n 3.3v 289.505n 3.3v 299.495n 3.3v 299.505n 3.3v 309.495n 3.3v 309.505n 3.3v 319.495n 3.3v 319.505n 3.3v 329.495n 3.3v 329.505n 3.3v 339.495n 3.3v 339.505n 3.3v 349.495n 3.3v 349.505n 3.3v 359.495n 3.3v 359.505n 3.3v 369.495n 3.3v 369.505n 3.3v 379.495n 3.3v 379.505n 0.0v 389.495n 0.0v 389.505n 0.0v 399.495n 0.0v 399.505n 0.0v 409.495n 0.0v 409.505n 0.0v 419.495n 0.0v 419.505n 0.0v 429.495n 0.0v 429.505n 0.0v 439.495n 0.0v 439.505n 0.0v 449.495n 0.0v 449.505n 0.0v 459.495n 0.0v 459.505n 0.0v 469.495n 0.0v 469.505n 0.0v 479.495n 0.0v 479.505n 0.0v 489.495n 0.0v 489.505n 0.0v 499.495n 0.0v 499.505n 0.0v 509.495n 0.0v 509.505n 0.0v 519.495n 0.0v 519.505n 0.0v 529.495n 0.0v 529.505n 0.0v 539.495n 0.0v 539.505n 0.0v 549.495n 0.0v 549.505n 0.0v 559.495n 0.0v 559.505n 0.0v 569.495n 0.0v 569.505n 0.0v 579.495n 0.0v 579.505n 0.0v 589.495n 0.0v 589.505n 0.0v 599.495n 0.0v 599.505n 0.0v 609.495n 0.0v 609.505n 0.0v 619.495n 0.0v 619.505n 0.0v 629.495n 0.0v 629.505n 0.0v 639.495n 0.0v 639.505n 0.0v 649.495n 0.0v 649.505n 0.0v 659.495n 0.0v 659.505n 3.3v 669.495n 3.3v 669.505n 3.3v 679.495n 3.3v 679.505n 3.3v 689.495n 3.3v 689.505n 3.3v 699.495n 3.3v 699.505n 3.3v 709.495n 3.3v 709.505n 3.3v 719.495n 3.3v 719.505n 0.0v 729.495n 0.0v 729.505n 0.0v 739.495n 0.0v 739.505n 0.0v 749.495n 0.0v 749.505n 0.0v 759.495n 0.0v 759.505n 0.0v 769.495n 0.0v 769.505n 0.0v 779.495n 0.0v 779.505n 0.0v 789.495n 0.0v 789.505n 0.0v 799.495n 0.0v 799.505n 0.0v 809.495n 0.0v 809.505n 0.0v 819.495n 0.0v 819.505n 0.0v 829.495n 0.0v 829.505n 0.0v 839.495n 0.0v 839.505n 0.0v 849.495n 0.0v 849.505n 0.0v 859.495n 0.0v 859.505n 0.0v 869.495n 0.0v 869.505n 3.3v 879.495n 3.3v 879.505n 3.3v 889.495n 3.3v 889.505n 3.3v 899.495n 3.3v 899.505n 3.3v 909.495n 3.3v 909.505n 3.3v 919.495n 3.3v 919.505n 3.3v 929.495n 3.3v 929.505n 3.3v 939.495n 3.3v 939.505n 3.3v 949.495n 3.3v 949.505n 0.0v 959.495n 0.0v 959.505n 0.0v 969.495n 0.0v 969.505n 0.0v 979.495n 0.0v 979.505n 0.0v 989.495n 0.0v 989.505n 0.0v 999.495n 0.0v 999.505n 0.0v 1009.495n 0.0v 1009.505n 0.0v 1019.495n 0.0v 1019.505n 0.0v 1029.495n 0.0v 1029.505n 0.0v 1039.495n 0.0v 1039.505n 0.0v 1049.495n 0.0v 1049.505n 0.0v 1059.495n 0.0v 1059.505n 0.0v 1069.495n 0.0v 1069.505n 0.0v 1079.495n 0.0v 1079.505n 0.0v 1089.495n 0.0v 1089.505n 0.0v 1099.495n 0.0v 1099.505n 3.3v 1109.495n 3.3v 1109.505n 3.3v 1119.495n 3.3v 1119.505n 3.3v 1129.495n 3.3v 1129.505n 3.3v 1139.495n 3.3v 1139.505n 0.0v 1149.495n 0.0v 1149.505n 0.0v 1159.495n 0.0v 1159.505n 0.0v 1169.495n 0.0v 1169.505n 0.0v 1179.495n 0.0v 1179.505n 0.0v 1189.495n 0.0v 1189.505n 0.0v 1199.495n 0.0v 1199.505n 0.0v 1209.495n 0.0v 1209.505n 3.3v 1219.495n 3.3v 1219.505n 3.3v 1229.495n 3.3v 1229.505n 3.3v 1239.495n 3.3v 1239.505n 3.3v 1249.495n 3.3v 1249.505n 0.0v 1259.495n 0.0v 1259.505n 0.0v 1269.495n 0.0v 1269.505n 0.0v 1279.495n 0.0v 1279.505n 0.0v 1289.495n 0.0v 1289.505n 0.0v 1299.495n 0.0v 1299.505n 0.0v 1309.495n 0.0v 1309.505n 0.0v 1319.495n 0.0v 1319.505n 0.0v 1329.495n 0.0v 1329.505n 0.0v 1339.495n 0.0v 1339.505n 0.0v 1349.495n 0.0v 1349.505n 0.0v 1359.495n 0.0v 1359.505n 0.0v 1369.495n 0.0v 1369.505n 0.0v 1379.495n 0.0v 1379.505n 0.0v 1389.495n 0.0v 1389.505n 0.0v 1399.495n 0.0v 1399.505n 0.0v 1409.495n 0.0v 1409.505n 0.0v 1419.495n 0.0v 1419.505n 0.0v 1429.495n 0.0v 1429.505n 0.0v 1439.495n 0.0v 1439.505n 0.0v 1449.495n 0.0v 1449.505n 0.0v 1459.495n 0.0v 1459.505n 0.0v 1469.495n 0.0v 1469.505n 0.0v 1479.495n 0.0v 1479.505n 0.0v 1489.495n 0.0v 1489.505n 0.0v 1499.495n 0.0v 1499.505n 0.0v 1509.495n 0.0v 1509.505n 0.0v 1519.495n 0.0v 1519.505n 0.0v 1529.495n 0.0v 1529.505n 0.0v 1539.495n 0.0v 1539.505n 0.0v 1549.495n 0.0v 1549.505n 0.0v 1559.495n 0.0v 1559.505n 3.3v 1569.495n 3.3v 1569.505n 3.3v 1579.495n 3.3v 1579.505n 3.3v 1589.495n 3.3v 1589.505n 3.3v 1599.495n 3.3v 1599.505n 0.0v 1609.495n 0.0v 1609.505n 0.0v 1619.495n 0.0v 1619.505n 0.0v 1629.495n 0.0v 1629.505n 0.0v 1639.495n 0.0v 1639.505n 0.0v 1649.495n 0.0v 1649.505n 0.0v 1659.495n 0.0v 1659.505n 0.0v 1669.495n 0.0v 1669.505n 0.0v 1679.495n 0.0v 1679.505n 0.0v 1689.495n 0.0v 1689.505n 0.0v 1699.495n 0.0v 1699.505n 0.0v 1709.495n 0.0v 1709.505n 0.0v 1719.495n 0.0v 1719.505n 0.0v 1729.495n 0.0v 1729.505n 0.0v 1739.495n 0.0v 1739.505n 0.0v 1749.495n 0.0v 1749.505n 3.3v 1759.495n 3.3v 1759.505n 3.3v 1769.495n 3.3v 1769.505n 3.3v 1779.495n 3.3v 1779.505n 3.3v 1789.495n 3.3v 1789.505n 3.3v 1799.495n 3.3v 1799.505n 3.3v 1809.495n 3.3v 1809.505n 3.3v 1819.495n 3.3v 1819.505n 0.0v 1829.495n 0.0v 1829.505n 0.0v 1839.495n 0.0v 1839.505n 0.0v 1849.495n 0.0v 1849.505n 0.0v 1859.495n 0.0v 1859.505n 3.3v 1869.495n 3.3v 1869.505n 3.3v 1879.495n 3.3v 1879.505n 3.3v 1889.495n 3.3v 1889.505n 3.3v 1899.495n 3.3v 1899.505n 3.3v 1909.495n 3.3v 1909.505n 3.3v 1919.495n 3.3v 1919.505n 3.3v 1929.495n 3.3v 1929.505n 3.3v 1939.495n 3.3v 1939.505n 3.3v 1949.495n 3.3v 1949.505n 3.3v 1959.495n 3.3v 1959.505n 3.3v 1969.495n 3.3v 1969.505n 3.3v 1979.495n 3.3v 1979.505n 0.0v 1989.495n 0.0v 1989.505n 0.0v 1999.495n 0.0v 1999.505n 0.0v 2009.495n 0.0v 2009.505n 0.0v 2019.495n 0.0v 2019.505n 0.0v 2029.495n 0.0v 2029.505n 0.0v 2039.495n 0.0v 2039.505n 0.0v 2049.495n 0.0v 2049.505n 0.0v )
* (time, data): [(0, 0), (10, 0), (20, 0), (30, 1), (40, 1), (50, 1), (60, 1), (70, 1), (80, 0), (90, 0), (100, 0), (110, 0), (120, 1), (130, 1), (140, 1), (150, 1), (160, 1), (170, 0), (180, 0), (190, 0), (200, 0), (210, 0), (220, 0), (230, 0), (240, 1), (250, 1), (260, 1), (270, 1), (280, 1), (290, 1), (300, 1), (310, 1), (320, 1), (330, 1), (340, 1), (350, 1), (360, 1), (370, 0), (380, 1), (390, 1), (400, 1), (410, 1), (420, 1), (430, 1), (440, 1), (450, 1), (460, 1), (470, 1), (480, 1), (490, 1), (500, 1), (510, 1), (520, 1), (530, 1), (540, 1), (550, 1), (560, 1), (570, 1), (580, 1), (590, 1), (600, 1), (610, 1), (620, 1), (630, 1), (640, 1), (650, 1), (660, 1), (670, 1), (680, 1), (690, 1), (700, 1), (710, 1), (720, 0), (730, 0), (740, 0), (750, 0), (760, 0), (770, 0), (780, 0), (790, 0), (800, 0), (810, 0), (820, 0), (830, 0), (840, 0), (850, 0), (860, 0), (870, 0), (880, 0), (890, 0), (900, 0), (910, 0), (920, 0), (930, 0), (940, 0), (950, 0), (960, 0), (970, 0), (980, 0), (990, 0), (1000, 0), (1010, 0), (1020, 0), (1030, 0), (1040, 1), (1050, 1), (1060, 1), (1070, 1), (1080, 1), (1090, 1), (1100, 1), (1110, 1), (1120, 1), (1130, 1), (1140, 0), (1150, 0), (1160, 0), (1170, 0), (1180, 0), (1190, 0), (1200, 0), (1210, 1), (1220, 1), (1230, 1), (1240, 1), (1250, 1), (1260, 1), (1270, 1), (1280, 1), (1290, 1), (1300, 1), (1310, 0), (1320, 0), (1330, 0), (1340, 0), (1350, 0), (1360, 0), (1370, 0), (1380, 0), (1390, 0), (1400, 0), (1410, 0), (1420, 0), (1430, 0), (1440, 0), (1450, 0), (1460, 0), (1470, 0), (1480, 0), (1490, 1), (1500, 1), (1510, 1), (1520, 1), (1530, 1), (1540, 1), (1550, 1), (1560, 0), (1570, 0), (1580, 0), (1590, 0), (1600, 0), (1610, 0), (1620, 0), (1630, 0), (1640, 0), (1650, 0), (1660, 0), (1670, 0), (1680, 0), (1690, 0), (1700, 0), (1710, 0), (1720, 0), (1730, 0), (1740, 0), (1750, 0), (1760, 0), (1770, 0), (1780, 0), (1790, 0), (1800, 0), (1810, 0), (1820, 1), (1830, 1), (1840, 1), (1850, 1), (1860, 0), (1870, 0), (1880, 0), (1890, 0), (1900, 0), (1910, 1), (1920, 1), (1930, 1), (1940, 0), (1950, 0), (1960, 0), (1970, 0), (1980, 1), (1990, 1), (2000, 0), (2010, 0), (2020, 0), (2030, 1), (2040, 1), (2050, 1)]
Vdin1_24  din1_24  0 PWL (0n 0.0v 9.495n 0.0v 9.505n 0.0v 19.495n 0.0v 19.505n 0.0v 29.495n 0.0v 29.505n 3.3v 39.495n 3.3v 39.505n 3.3v 49.495n 3.3v 49.505n 3.3v 59.495n 3.3v 59.505n 3.3v 69.495n 3.3v 69.505n 3.3v 79.495n 3.3v 79.505n 0.0v 89.495n 0.0v 89.505n 0.0v 99.495n 0.0v 99.505n 0.0v 109.495n 0.0v 109.505n 0.0v 119.495n 0.0v 119.505n 3.3v 129.495n 3.3v 129.505n 3.3v 139.495n 3.3v 139.505n 3.3v 149.495n 3.3v 149.505n 3.3v 159.495n 3.3v 159.505n 3.3v 169.495n 3.3v 169.505n 0.0v 179.495n 0.0v 179.505n 0.0v 189.495n 0.0v 189.505n 0.0v 199.495n 0.0v 199.505n 0.0v 209.495n 0.0v 209.505n 0.0v 219.495n 0.0v 219.505n 0.0v 229.495n 0.0v 229.505n 0.0v 239.495n 0.0v 239.505n 3.3v 249.495n 3.3v 249.505n 3.3v 259.495n 3.3v 259.505n 3.3v 269.495n 3.3v 269.505n 3.3v 279.495n 3.3v 279.505n 3.3v 289.495n 3.3v 289.505n 3.3v 299.495n 3.3v 299.505n 3.3v 309.495n 3.3v 309.505n 3.3v 319.495n 3.3v 319.505n 3.3v 329.495n 3.3v 329.505n 3.3v 339.495n 3.3v 339.505n 3.3v 349.495n 3.3v 349.505n 3.3v 359.495n 3.3v 359.505n 3.3v 369.495n 3.3v 369.505n 0.0v 379.495n 0.0v 379.505n 3.3v 389.495n 3.3v 389.505n 3.3v 399.495n 3.3v 399.505n 3.3v 409.495n 3.3v 409.505n 3.3v 419.495n 3.3v 419.505n 3.3v 429.495n 3.3v 429.505n 3.3v 439.495n 3.3v 439.505n 3.3v 449.495n 3.3v 449.505n 3.3v 459.495n 3.3v 459.505n 3.3v 469.495n 3.3v 469.505n 3.3v 479.495n 3.3v 479.505n 3.3v 489.495n 3.3v 489.505n 3.3v 499.495n 3.3v 499.505n 3.3v 509.495n 3.3v 509.505n 3.3v 519.495n 3.3v 519.505n 3.3v 529.495n 3.3v 529.505n 3.3v 539.495n 3.3v 539.505n 3.3v 549.495n 3.3v 549.505n 3.3v 559.495n 3.3v 559.505n 3.3v 569.495n 3.3v 569.505n 3.3v 579.495n 3.3v 579.505n 3.3v 589.495n 3.3v 589.505n 3.3v 599.495n 3.3v 599.505n 3.3v 609.495n 3.3v 609.505n 3.3v 619.495n 3.3v 619.505n 3.3v 629.495n 3.3v 629.505n 3.3v 639.495n 3.3v 639.505n 3.3v 649.495n 3.3v 649.505n 3.3v 659.495n 3.3v 659.505n 3.3v 669.495n 3.3v 669.505n 3.3v 679.495n 3.3v 679.505n 3.3v 689.495n 3.3v 689.505n 3.3v 699.495n 3.3v 699.505n 3.3v 709.495n 3.3v 709.505n 3.3v 719.495n 3.3v 719.505n 0.0v 729.495n 0.0v 729.505n 0.0v 739.495n 0.0v 739.505n 0.0v 749.495n 0.0v 749.505n 0.0v 759.495n 0.0v 759.505n 0.0v 769.495n 0.0v 769.505n 0.0v 779.495n 0.0v 779.505n 0.0v 789.495n 0.0v 789.505n 0.0v 799.495n 0.0v 799.505n 0.0v 809.495n 0.0v 809.505n 0.0v 819.495n 0.0v 819.505n 0.0v 829.495n 0.0v 829.505n 0.0v 839.495n 0.0v 839.505n 0.0v 849.495n 0.0v 849.505n 0.0v 859.495n 0.0v 859.505n 0.0v 869.495n 0.0v 869.505n 0.0v 879.495n 0.0v 879.505n 0.0v 889.495n 0.0v 889.505n 0.0v 899.495n 0.0v 899.505n 0.0v 909.495n 0.0v 909.505n 0.0v 919.495n 0.0v 919.505n 0.0v 929.495n 0.0v 929.505n 0.0v 939.495n 0.0v 939.505n 0.0v 949.495n 0.0v 949.505n 0.0v 959.495n 0.0v 959.505n 0.0v 969.495n 0.0v 969.505n 0.0v 979.495n 0.0v 979.505n 0.0v 989.495n 0.0v 989.505n 0.0v 999.495n 0.0v 999.505n 0.0v 1009.495n 0.0v 1009.505n 0.0v 1019.495n 0.0v 1019.505n 0.0v 1029.495n 0.0v 1029.505n 0.0v 1039.495n 0.0v 1039.505n 3.3v 1049.495n 3.3v 1049.505n 3.3v 1059.495n 3.3v 1059.505n 3.3v 1069.495n 3.3v 1069.505n 3.3v 1079.495n 3.3v 1079.505n 3.3v 1089.495n 3.3v 1089.505n 3.3v 1099.495n 3.3v 1099.505n 3.3v 1109.495n 3.3v 1109.505n 3.3v 1119.495n 3.3v 1119.505n 3.3v 1129.495n 3.3v 1129.505n 3.3v 1139.495n 3.3v 1139.505n 0.0v 1149.495n 0.0v 1149.505n 0.0v 1159.495n 0.0v 1159.505n 0.0v 1169.495n 0.0v 1169.505n 0.0v 1179.495n 0.0v 1179.505n 0.0v 1189.495n 0.0v 1189.505n 0.0v 1199.495n 0.0v 1199.505n 0.0v 1209.495n 0.0v 1209.505n 3.3v 1219.495n 3.3v 1219.505n 3.3v 1229.495n 3.3v 1229.505n 3.3v 1239.495n 3.3v 1239.505n 3.3v 1249.495n 3.3v 1249.505n 3.3v 1259.495n 3.3v 1259.505n 3.3v 1269.495n 3.3v 1269.505n 3.3v 1279.495n 3.3v 1279.505n 3.3v 1289.495n 3.3v 1289.505n 3.3v 1299.495n 3.3v 1299.505n 3.3v 1309.495n 3.3v 1309.505n 0.0v 1319.495n 0.0v 1319.505n 0.0v 1329.495n 0.0v 1329.505n 0.0v 1339.495n 0.0v 1339.505n 0.0v 1349.495n 0.0v 1349.505n 0.0v 1359.495n 0.0v 1359.505n 0.0v 1369.495n 0.0v 1369.505n 0.0v 1379.495n 0.0v 1379.505n 0.0v 1389.495n 0.0v 1389.505n 0.0v 1399.495n 0.0v 1399.505n 0.0v 1409.495n 0.0v 1409.505n 0.0v 1419.495n 0.0v 1419.505n 0.0v 1429.495n 0.0v 1429.505n 0.0v 1439.495n 0.0v 1439.505n 0.0v 1449.495n 0.0v 1449.505n 0.0v 1459.495n 0.0v 1459.505n 0.0v 1469.495n 0.0v 1469.505n 0.0v 1479.495n 0.0v 1479.505n 0.0v 1489.495n 0.0v 1489.505n 3.3v 1499.495n 3.3v 1499.505n 3.3v 1509.495n 3.3v 1509.505n 3.3v 1519.495n 3.3v 1519.505n 3.3v 1529.495n 3.3v 1529.505n 3.3v 1539.495n 3.3v 1539.505n 3.3v 1549.495n 3.3v 1549.505n 3.3v 1559.495n 3.3v 1559.505n 0.0v 1569.495n 0.0v 1569.505n 0.0v 1579.495n 0.0v 1579.505n 0.0v 1589.495n 0.0v 1589.505n 0.0v 1599.495n 0.0v 1599.505n 0.0v 1609.495n 0.0v 1609.505n 0.0v 1619.495n 0.0v 1619.505n 0.0v 1629.495n 0.0v 1629.505n 0.0v 1639.495n 0.0v 1639.505n 0.0v 1649.495n 0.0v 1649.505n 0.0v 1659.495n 0.0v 1659.505n 0.0v 1669.495n 0.0v 1669.505n 0.0v 1679.495n 0.0v 1679.505n 0.0v 1689.495n 0.0v 1689.505n 0.0v 1699.495n 0.0v 1699.505n 0.0v 1709.495n 0.0v 1709.505n 0.0v 1719.495n 0.0v 1719.505n 0.0v 1729.495n 0.0v 1729.505n 0.0v 1739.495n 0.0v 1739.505n 0.0v 1749.495n 0.0v 1749.505n 0.0v 1759.495n 0.0v 1759.505n 0.0v 1769.495n 0.0v 1769.505n 0.0v 1779.495n 0.0v 1779.505n 0.0v 1789.495n 0.0v 1789.505n 0.0v 1799.495n 0.0v 1799.505n 0.0v 1809.495n 0.0v 1809.505n 0.0v 1819.495n 0.0v 1819.505n 3.3v 1829.495n 3.3v 1829.505n 3.3v 1839.495n 3.3v 1839.505n 3.3v 1849.495n 3.3v 1849.505n 3.3v 1859.495n 3.3v 1859.505n 0.0v 1869.495n 0.0v 1869.505n 0.0v 1879.495n 0.0v 1879.505n 0.0v 1889.495n 0.0v 1889.505n 0.0v 1899.495n 0.0v 1899.505n 0.0v 1909.495n 0.0v 1909.505n 3.3v 1919.495n 3.3v 1919.505n 3.3v 1929.495n 3.3v 1929.505n 3.3v 1939.495n 3.3v 1939.505n 0.0v 1949.495n 0.0v 1949.505n 0.0v 1959.495n 0.0v 1959.505n 0.0v 1969.495n 0.0v 1969.505n 0.0v 1979.495n 0.0v 1979.505n 3.3v 1989.495n 3.3v 1989.505n 3.3v 1999.495n 3.3v 1999.505n 0.0v 2009.495n 0.0v 2009.505n 0.0v 2019.495n 0.0v 2019.505n 0.0v 2029.495n 0.0v 2029.505n 3.3v 2039.495n 3.3v 2039.505n 3.3v 2049.495n 3.3v 2049.505n 3.3v )
* (time, data): [(0, 0), (10, 0), (20, 0), (30, 1), (40, 1), (50, 1), (60, 1), (70, 0), (80, 0), (90, 0), (100, 0), (110, 0), (120, 1), (130, 1), (140, 1), (150, 1), (160, 1), (170, 1), (180, 1), (190, 1), (200, 1), (210, 1), (220, 1), (230, 1), (240, 1), (250, 1), (260, 1), (270, 1), (280, 1), (290, 1), (300, 1), (310, 1), (320, 1), (330, 1), (340, 1), (350, 1), (360, 1), (370, 1), (380, 1), (390, 1), (400, 0), (410, 0), (420, 0), (430, 0), (440, 0), (450, 0), (460, 0), (470, 0), (480, 0), (490, 0), (500, 0), (510, 0), (520, 0), (530, 0), (540, 0), (550, 0), (560, 0), (570, 0), (580, 0), (590, 0), (600, 0), (610, 0), (620, 0), (630, 0), (640, 0), (650, 0), (660, 0), (670, 0), (680, 0), (690, 0), (700, 0), (710, 0), (720, 0), (730, 0), (740, 0), (750, 0), (760, 0), (770, 0), (780, 0), (790, 0), (800, 0), (810, 0), (820, 0), (830, 0), (840, 0), (850, 0), (860, 1), (870, 0), (880, 0), (890, 0), (900, 0), (910, 0), (920, 0), (930, 0), (940, 0), (950, 1), (960, 1), (970, 1), (980, 1), (990, 1), (1000, 1), (1010, 1), (1020, 1), (1030, 1), (1040, 1), (1050, 0), (1060, 0), (1070, 0), (1080, 0), (1090, 0), (1100, 0), (1110, 1), (1120, 1), (1130, 1), (1140, 1), (1150, 1), (1160, 1), (1170, 1), (1180, 1), (1190, 1), (1200, 1), (1210, 1), (1220, 1), (1230, 1), (1240, 1), (1250, 0), (1260, 0), (1270, 0), (1280, 0), (1290, 0), (1300, 0), (1310, 1), (1320, 1), (1330, 1), (1340, 1), (1350, 1), (1360, 1), (1370, 1), (1380, 1), (1390, 1), (1400, 1), (1410, 1), (1420, 1), (1430, 1), (1440, 0), (1450, 0), (1460, 0), (1470, 0), (1480, 0), (1490, 1), (1500, 1), (1510, 1), (1520, 1), (1530, 1), (1540, 1), (1550, 0), (1560, 0), (1570, 0), (1580, 0), (1590, 0), (1600, 0), (1610, 0), (1620, 0), (1630, 0), (1640, 0), (1650, 0), (1660, 0), (1670, 0), (1680, 0), (1690, 0), (1700, 0), (1710, 0), (1720, 0), (1730, 0), (1740, 0), (1750, 1), (1760, 1), (1770, 0), (1780, 0), (1790, 0), (1800, 0), (1810, 0), (1820, 1), (1830, 1), (1840, 1), (1850, 1), (1860, 0), (1870, 0), (1880, 0), (1890, 0), (1900, 0), (1910, 0), (1920, 0), (1930, 0), (1940, 1), (1950, 1), (1960, 1), (1970, 1), (1980, 0), (1990, 0), (2000, 1), (2010, 1), (2020, 0), (2030, 1), (2040, 1), (2050, 1)]
Vdin1_25  din1_25  0 PWL (0n 0.0v 9.495n 0.0v 9.505n 0.0v 19.495n 0.0v 19.505n 0.0v 29.495n 0.0v 29.505n 3.3v 39.495n 3.3v 39.505n 3.3v 49.495n 3.3v 49.505n 3.3v 59.495n 3.3v 59.505n 3.3v 69.495n 3.3v 69.505n 0.0v 79.495n 0.0v 79.505n 0.0v 89.495n 0.0v 89.505n 0.0v 99.495n 0.0v 99.505n 0.0v 109.495n 0.0v 109.505n 0.0v 119.495n 0.0v 119.505n 3.3v 129.495n 3.3v 129.505n 3.3v 139.495n 3.3v 139.505n 3.3v 149.495n 3.3v 149.505n 3.3v 159.495n 3.3v 159.505n 3.3v 169.495n 3.3v 169.505n 3.3v 179.495n 3.3v 179.505n 3.3v 189.495n 3.3v 189.505n 3.3v 199.495n 3.3v 199.505n 3.3v 209.495n 3.3v 209.505n 3.3v 219.495n 3.3v 219.505n 3.3v 229.495n 3.3v 229.505n 3.3v 239.495n 3.3v 239.505n 3.3v 249.495n 3.3v 249.505n 3.3v 259.495n 3.3v 259.505n 3.3v 269.495n 3.3v 269.505n 3.3v 279.495n 3.3v 279.505n 3.3v 289.495n 3.3v 289.505n 3.3v 299.495n 3.3v 299.505n 3.3v 309.495n 3.3v 309.505n 3.3v 319.495n 3.3v 319.505n 3.3v 329.495n 3.3v 329.505n 3.3v 339.495n 3.3v 339.505n 3.3v 349.495n 3.3v 349.505n 3.3v 359.495n 3.3v 359.505n 3.3v 369.495n 3.3v 369.505n 3.3v 379.495n 3.3v 379.505n 3.3v 389.495n 3.3v 389.505n 3.3v 399.495n 3.3v 399.505n 0.0v 409.495n 0.0v 409.505n 0.0v 419.495n 0.0v 419.505n 0.0v 429.495n 0.0v 429.505n 0.0v 439.495n 0.0v 439.505n 0.0v 449.495n 0.0v 449.505n 0.0v 459.495n 0.0v 459.505n 0.0v 469.495n 0.0v 469.505n 0.0v 479.495n 0.0v 479.505n 0.0v 489.495n 0.0v 489.505n 0.0v 499.495n 0.0v 499.505n 0.0v 509.495n 0.0v 509.505n 0.0v 519.495n 0.0v 519.505n 0.0v 529.495n 0.0v 529.505n 0.0v 539.495n 0.0v 539.505n 0.0v 549.495n 0.0v 549.505n 0.0v 559.495n 0.0v 559.505n 0.0v 569.495n 0.0v 569.505n 0.0v 579.495n 0.0v 579.505n 0.0v 589.495n 0.0v 589.505n 0.0v 599.495n 0.0v 599.505n 0.0v 609.495n 0.0v 609.505n 0.0v 619.495n 0.0v 619.505n 0.0v 629.495n 0.0v 629.505n 0.0v 639.495n 0.0v 639.505n 0.0v 649.495n 0.0v 649.505n 0.0v 659.495n 0.0v 659.505n 0.0v 669.495n 0.0v 669.505n 0.0v 679.495n 0.0v 679.505n 0.0v 689.495n 0.0v 689.505n 0.0v 699.495n 0.0v 699.505n 0.0v 709.495n 0.0v 709.505n 0.0v 719.495n 0.0v 719.505n 0.0v 729.495n 0.0v 729.505n 0.0v 739.495n 0.0v 739.505n 0.0v 749.495n 0.0v 749.505n 0.0v 759.495n 0.0v 759.505n 0.0v 769.495n 0.0v 769.505n 0.0v 779.495n 0.0v 779.505n 0.0v 789.495n 0.0v 789.505n 0.0v 799.495n 0.0v 799.505n 0.0v 809.495n 0.0v 809.505n 0.0v 819.495n 0.0v 819.505n 0.0v 829.495n 0.0v 829.505n 0.0v 839.495n 0.0v 839.505n 0.0v 849.495n 0.0v 849.505n 0.0v 859.495n 0.0v 859.505n 3.3v 869.495n 3.3v 869.505n 0.0v 879.495n 0.0v 879.505n 0.0v 889.495n 0.0v 889.505n 0.0v 899.495n 0.0v 899.505n 0.0v 909.495n 0.0v 909.505n 0.0v 919.495n 0.0v 919.505n 0.0v 929.495n 0.0v 929.505n 0.0v 939.495n 0.0v 939.505n 0.0v 949.495n 0.0v 949.505n 3.3v 959.495n 3.3v 959.505n 3.3v 969.495n 3.3v 969.505n 3.3v 979.495n 3.3v 979.505n 3.3v 989.495n 3.3v 989.505n 3.3v 999.495n 3.3v 999.505n 3.3v 1009.495n 3.3v 1009.505n 3.3v 1019.495n 3.3v 1019.505n 3.3v 1029.495n 3.3v 1029.505n 3.3v 1039.495n 3.3v 1039.505n 3.3v 1049.495n 3.3v 1049.505n 0.0v 1059.495n 0.0v 1059.505n 0.0v 1069.495n 0.0v 1069.505n 0.0v 1079.495n 0.0v 1079.505n 0.0v 1089.495n 0.0v 1089.505n 0.0v 1099.495n 0.0v 1099.505n 0.0v 1109.495n 0.0v 1109.505n 3.3v 1119.495n 3.3v 1119.505n 3.3v 1129.495n 3.3v 1129.505n 3.3v 1139.495n 3.3v 1139.505n 3.3v 1149.495n 3.3v 1149.505n 3.3v 1159.495n 3.3v 1159.505n 3.3v 1169.495n 3.3v 1169.505n 3.3v 1179.495n 3.3v 1179.505n 3.3v 1189.495n 3.3v 1189.505n 3.3v 1199.495n 3.3v 1199.505n 3.3v 1209.495n 3.3v 1209.505n 3.3v 1219.495n 3.3v 1219.505n 3.3v 1229.495n 3.3v 1229.505n 3.3v 1239.495n 3.3v 1239.505n 3.3v 1249.495n 3.3v 1249.505n 0.0v 1259.495n 0.0v 1259.505n 0.0v 1269.495n 0.0v 1269.505n 0.0v 1279.495n 0.0v 1279.505n 0.0v 1289.495n 0.0v 1289.505n 0.0v 1299.495n 0.0v 1299.505n 0.0v 1309.495n 0.0v 1309.505n 3.3v 1319.495n 3.3v 1319.505n 3.3v 1329.495n 3.3v 1329.505n 3.3v 1339.495n 3.3v 1339.505n 3.3v 1349.495n 3.3v 1349.505n 3.3v 1359.495n 3.3v 1359.505n 3.3v 1369.495n 3.3v 1369.505n 3.3v 1379.495n 3.3v 1379.505n 3.3v 1389.495n 3.3v 1389.505n 3.3v 1399.495n 3.3v 1399.505n 3.3v 1409.495n 3.3v 1409.505n 3.3v 1419.495n 3.3v 1419.505n 3.3v 1429.495n 3.3v 1429.505n 3.3v 1439.495n 3.3v 1439.505n 0.0v 1449.495n 0.0v 1449.505n 0.0v 1459.495n 0.0v 1459.505n 0.0v 1469.495n 0.0v 1469.505n 0.0v 1479.495n 0.0v 1479.505n 0.0v 1489.495n 0.0v 1489.505n 3.3v 1499.495n 3.3v 1499.505n 3.3v 1509.495n 3.3v 1509.505n 3.3v 1519.495n 3.3v 1519.505n 3.3v 1529.495n 3.3v 1529.505n 3.3v 1539.495n 3.3v 1539.505n 3.3v 1549.495n 3.3v 1549.505n 0.0v 1559.495n 0.0v 1559.505n 0.0v 1569.495n 0.0v 1569.505n 0.0v 1579.495n 0.0v 1579.505n 0.0v 1589.495n 0.0v 1589.505n 0.0v 1599.495n 0.0v 1599.505n 0.0v 1609.495n 0.0v 1609.505n 0.0v 1619.495n 0.0v 1619.505n 0.0v 1629.495n 0.0v 1629.505n 0.0v 1639.495n 0.0v 1639.505n 0.0v 1649.495n 0.0v 1649.505n 0.0v 1659.495n 0.0v 1659.505n 0.0v 1669.495n 0.0v 1669.505n 0.0v 1679.495n 0.0v 1679.505n 0.0v 1689.495n 0.0v 1689.505n 0.0v 1699.495n 0.0v 1699.505n 0.0v 1709.495n 0.0v 1709.505n 0.0v 1719.495n 0.0v 1719.505n 0.0v 1729.495n 0.0v 1729.505n 0.0v 1739.495n 0.0v 1739.505n 0.0v 1749.495n 0.0v 1749.505n 3.3v 1759.495n 3.3v 1759.505n 3.3v 1769.495n 3.3v 1769.505n 0.0v 1779.495n 0.0v 1779.505n 0.0v 1789.495n 0.0v 1789.505n 0.0v 1799.495n 0.0v 1799.505n 0.0v 1809.495n 0.0v 1809.505n 0.0v 1819.495n 0.0v 1819.505n 3.3v 1829.495n 3.3v 1829.505n 3.3v 1839.495n 3.3v 1839.505n 3.3v 1849.495n 3.3v 1849.505n 3.3v 1859.495n 3.3v 1859.505n 0.0v 1869.495n 0.0v 1869.505n 0.0v 1879.495n 0.0v 1879.505n 0.0v 1889.495n 0.0v 1889.505n 0.0v 1899.495n 0.0v 1899.505n 0.0v 1909.495n 0.0v 1909.505n 0.0v 1919.495n 0.0v 1919.505n 0.0v 1929.495n 0.0v 1929.505n 0.0v 1939.495n 0.0v 1939.505n 3.3v 1949.495n 3.3v 1949.505n 3.3v 1959.495n 3.3v 1959.505n 3.3v 1969.495n 3.3v 1969.505n 3.3v 1979.495n 3.3v 1979.505n 0.0v 1989.495n 0.0v 1989.505n 0.0v 1999.495n 0.0v 1999.505n 3.3v 2009.495n 3.3v 2009.505n 3.3v 2019.495n 3.3v 2019.505n 0.0v 2029.495n 0.0v 2029.505n 3.3v 2039.495n 3.3v 2039.505n 3.3v 2049.495n 3.3v 2049.505n 3.3v )
* (time, data): [(0, 0), (10, 0), (20, 1), (30, 0), (40, 0), (50, 0), (60, 0), (70, 1), (80, 1), (90, 1), (100, 1), (110, 1), (120, 0), (130, 0), (140, 0), (150, 0), (160, 0), (170, 1), (180, 1), (190, 1), (200, 1), (210, 1), (220, 1), (230, 1), (240, 0), (250, 0), (260, 0), (270, 0), (280, 0), (290, 0), (300, 0), (310, 0), (320, 0), (330, 0), (340, 0), (350, 0), (360, 0), (370, 1), (380, 0), (390, 0), (400, 0), (410, 0), (420, 0), (430, 0), (440, 0), (450, 0), (460, 0), (470, 0), (480, 0), (490, 0), (500, 0), (510, 0), (520, 0), (530, 0), (540, 0), (550, 0), (560, 0), (570, 0), (580, 0), (590, 0), (600, 0), (610, 0), (620, 0), (630, 0), (640, 0), (650, 0), (660, 1), (670, 1), (680, 1), (690, 1), (700, 1), (710, 1), (720, 1), (730, 1), (740, 1), (750, 1), (760, 1), (770, 1), (780, 1), (790, 1), (800, 1), (810, 1), (820, 1), (830, 1), (840, 1), (850, 1), (860, 0), (870, 1), (880, 1), (890, 1), (900, 1), (910, 1), (920, 1), (930, 1), (940, 0), (950, 0), (960, 0), (970, 0), (980, 0), (990, 0), (1000, 0), (1010, 0), (1020, 0), (1030, 0), (1040, 0), (1050, 0), (1060, 0), (1070, 0), (1080, 0), (1090, 0), (1100, 0), (1110, 0), (1120, 0), (1130, 0), (1140, 0), (1150, 0), (1160, 0), (1170, 0), (1180, 0), (1190, 0), (1200, 0), (1210, 0), (1220, 0), (1230, 0), (1240, 0), (1250, 0), (1260, 0), (1270, 0), (1280, 0), (1290, 0), (1300, 0), (1310, 0), (1320, 0), (1330, 0), (1340, 0), (1350, 0), (1360, 0), (1370, 0), (1380, 0), (1390, 0), (1400, 0), (1410, 0), (1420, 0), (1430, 0), (1440, 1), (1450, 1), (1460, 1), (1470, 1), (1480, 1), (1490, 0), (1500, 0), (1510, 0), (1520, 0), (1530, 0), (1540, 0), (1550, 0), (1560, 0), (1570, 0), (1580, 0), (1590, 0), (1600, 0), (1610, 0), (1620, 0), (1630, 0), (1640, 0), (1650, 0), (1660, 0), (1670, 0), (1680, 0), (1690, 0), (1700, 0), (1710, 0), (1720, 0), (1730, 0), (1740, 0), (1750, 1), (1760, 1), (1770, 1), (1780, 1), (1790, 1), (1800, 1), (1810, 1), (1820, 1), (1830, 1), (1840, 1), (1850, 1), (1860, 1), (1870, 1), (1880, 1), (1890, 1), (1900, 1), (1910, 0), (1920, 0), (1930, 0), (1940, 0), (1950, 0), (1960, 0), (1970, 0), (1980, 0), (1990, 0), (2000, 1), (2010, 1), (2020, 1), (2030, 0), (2040, 0), (2050, 0)]
Vdin1_26  din1_26  0 PWL (0n 0.0v 9.495n 0.0v 9.505n 0.0v 19.495n 0.0v 19.505n 3.3v 29.495n 3.3v 29.505n 0.0v 39.495n 0.0v 39.505n 0.0v 49.495n 0.0v 49.505n 0.0v 59.495n 0.0v 59.505n 0.0v 69.495n 0.0v 69.505n 3.3v 79.495n 3.3v 79.505n 3.3v 89.495n 3.3v 89.505n 3.3v 99.495n 3.3v 99.505n 3.3v 109.495n 3.3v 109.505n 3.3v 119.495n 3.3v 119.505n 0.0v 129.495n 0.0v 129.505n 0.0v 139.495n 0.0v 139.505n 0.0v 149.495n 0.0v 149.505n 0.0v 159.495n 0.0v 159.505n 0.0v 169.495n 0.0v 169.505n 3.3v 179.495n 3.3v 179.505n 3.3v 189.495n 3.3v 189.505n 3.3v 199.495n 3.3v 199.505n 3.3v 209.495n 3.3v 209.505n 3.3v 219.495n 3.3v 219.505n 3.3v 229.495n 3.3v 229.505n 3.3v 239.495n 3.3v 239.505n 0.0v 249.495n 0.0v 249.505n 0.0v 259.495n 0.0v 259.505n 0.0v 269.495n 0.0v 269.505n 0.0v 279.495n 0.0v 279.505n 0.0v 289.495n 0.0v 289.505n 0.0v 299.495n 0.0v 299.505n 0.0v 309.495n 0.0v 309.505n 0.0v 319.495n 0.0v 319.505n 0.0v 329.495n 0.0v 329.505n 0.0v 339.495n 0.0v 339.505n 0.0v 349.495n 0.0v 349.505n 0.0v 359.495n 0.0v 359.505n 0.0v 369.495n 0.0v 369.505n 3.3v 379.495n 3.3v 379.505n 0.0v 389.495n 0.0v 389.505n 0.0v 399.495n 0.0v 399.505n 0.0v 409.495n 0.0v 409.505n 0.0v 419.495n 0.0v 419.505n 0.0v 429.495n 0.0v 429.505n 0.0v 439.495n 0.0v 439.505n 0.0v 449.495n 0.0v 449.505n 0.0v 459.495n 0.0v 459.505n 0.0v 469.495n 0.0v 469.505n 0.0v 479.495n 0.0v 479.505n 0.0v 489.495n 0.0v 489.505n 0.0v 499.495n 0.0v 499.505n 0.0v 509.495n 0.0v 509.505n 0.0v 519.495n 0.0v 519.505n 0.0v 529.495n 0.0v 529.505n 0.0v 539.495n 0.0v 539.505n 0.0v 549.495n 0.0v 549.505n 0.0v 559.495n 0.0v 559.505n 0.0v 569.495n 0.0v 569.505n 0.0v 579.495n 0.0v 579.505n 0.0v 589.495n 0.0v 589.505n 0.0v 599.495n 0.0v 599.505n 0.0v 609.495n 0.0v 609.505n 0.0v 619.495n 0.0v 619.505n 0.0v 629.495n 0.0v 629.505n 0.0v 639.495n 0.0v 639.505n 0.0v 649.495n 0.0v 649.505n 0.0v 659.495n 0.0v 659.505n 3.3v 669.495n 3.3v 669.505n 3.3v 679.495n 3.3v 679.505n 3.3v 689.495n 3.3v 689.505n 3.3v 699.495n 3.3v 699.505n 3.3v 709.495n 3.3v 709.505n 3.3v 719.495n 3.3v 719.505n 3.3v 729.495n 3.3v 729.505n 3.3v 739.495n 3.3v 739.505n 3.3v 749.495n 3.3v 749.505n 3.3v 759.495n 3.3v 759.505n 3.3v 769.495n 3.3v 769.505n 3.3v 779.495n 3.3v 779.505n 3.3v 789.495n 3.3v 789.505n 3.3v 799.495n 3.3v 799.505n 3.3v 809.495n 3.3v 809.505n 3.3v 819.495n 3.3v 819.505n 3.3v 829.495n 3.3v 829.505n 3.3v 839.495n 3.3v 839.505n 3.3v 849.495n 3.3v 849.505n 3.3v 859.495n 3.3v 859.505n 0.0v 869.495n 0.0v 869.505n 3.3v 879.495n 3.3v 879.505n 3.3v 889.495n 3.3v 889.505n 3.3v 899.495n 3.3v 899.505n 3.3v 909.495n 3.3v 909.505n 3.3v 919.495n 3.3v 919.505n 3.3v 929.495n 3.3v 929.505n 3.3v 939.495n 3.3v 939.505n 0.0v 949.495n 0.0v 949.505n 0.0v 959.495n 0.0v 959.505n 0.0v 969.495n 0.0v 969.505n 0.0v 979.495n 0.0v 979.505n 0.0v 989.495n 0.0v 989.505n 0.0v 999.495n 0.0v 999.505n 0.0v 1009.495n 0.0v 1009.505n 0.0v 1019.495n 0.0v 1019.505n 0.0v 1029.495n 0.0v 1029.505n 0.0v 1039.495n 0.0v 1039.505n 0.0v 1049.495n 0.0v 1049.505n 0.0v 1059.495n 0.0v 1059.505n 0.0v 1069.495n 0.0v 1069.505n 0.0v 1079.495n 0.0v 1079.505n 0.0v 1089.495n 0.0v 1089.505n 0.0v 1099.495n 0.0v 1099.505n 0.0v 1109.495n 0.0v 1109.505n 0.0v 1119.495n 0.0v 1119.505n 0.0v 1129.495n 0.0v 1129.505n 0.0v 1139.495n 0.0v 1139.505n 0.0v 1149.495n 0.0v 1149.505n 0.0v 1159.495n 0.0v 1159.505n 0.0v 1169.495n 0.0v 1169.505n 0.0v 1179.495n 0.0v 1179.505n 0.0v 1189.495n 0.0v 1189.505n 0.0v 1199.495n 0.0v 1199.505n 0.0v 1209.495n 0.0v 1209.505n 0.0v 1219.495n 0.0v 1219.505n 0.0v 1229.495n 0.0v 1229.505n 0.0v 1239.495n 0.0v 1239.505n 0.0v 1249.495n 0.0v 1249.505n 0.0v 1259.495n 0.0v 1259.505n 0.0v 1269.495n 0.0v 1269.505n 0.0v 1279.495n 0.0v 1279.505n 0.0v 1289.495n 0.0v 1289.505n 0.0v 1299.495n 0.0v 1299.505n 0.0v 1309.495n 0.0v 1309.505n 0.0v 1319.495n 0.0v 1319.505n 0.0v 1329.495n 0.0v 1329.505n 0.0v 1339.495n 0.0v 1339.505n 0.0v 1349.495n 0.0v 1349.505n 0.0v 1359.495n 0.0v 1359.505n 0.0v 1369.495n 0.0v 1369.505n 0.0v 1379.495n 0.0v 1379.505n 0.0v 1389.495n 0.0v 1389.505n 0.0v 1399.495n 0.0v 1399.505n 0.0v 1409.495n 0.0v 1409.505n 0.0v 1419.495n 0.0v 1419.505n 0.0v 1429.495n 0.0v 1429.505n 0.0v 1439.495n 0.0v 1439.505n 3.3v 1449.495n 3.3v 1449.505n 3.3v 1459.495n 3.3v 1459.505n 3.3v 1469.495n 3.3v 1469.505n 3.3v 1479.495n 3.3v 1479.505n 3.3v 1489.495n 3.3v 1489.505n 0.0v 1499.495n 0.0v 1499.505n 0.0v 1509.495n 0.0v 1509.505n 0.0v 1519.495n 0.0v 1519.505n 0.0v 1529.495n 0.0v 1529.505n 0.0v 1539.495n 0.0v 1539.505n 0.0v 1549.495n 0.0v 1549.505n 0.0v 1559.495n 0.0v 1559.505n 0.0v 1569.495n 0.0v 1569.505n 0.0v 1579.495n 0.0v 1579.505n 0.0v 1589.495n 0.0v 1589.505n 0.0v 1599.495n 0.0v 1599.505n 0.0v 1609.495n 0.0v 1609.505n 0.0v 1619.495n 0.0v 1619.505n 0.0v 1629.495n 0.0v 1629.505n 0.0v 1639.495n 0.0v 1639.505n 0.0v 1649.495n 0.0v 1649.505n 0.0v 1659.495n 0.0v 1659.505n 0.0v 1669.495n 0.0v 1669.505n 0.0v 1679.495n 0.0v 1679.505n 0.0v 1689.495n 0.0v 1689.505n 0.0v 1699.495n 0.0v 1699.505n 0.0v 1709.495n 0.0v 1709.505n 0.0v 1719.495n 0.0v 1719.505n 0.0v 1729.495n 0.0v 1729.505n 0.0v 1739.495n 0.0v 1739.505n 0.0v 1749.495n 0.0v 1749.505n 3.3v 1759.495n 3.3v 1759.505n 3.3v 1769.495n 3.3v 1769.505n 3.3v 1779.495n 3.3v 1779.505n 3.3v 1789.495n 3.3v 1789.505n 3.3v 1799.495n 3.3v 1799.505n 3.3v 1809.495n 3.3v 1809.505n 3.3v 1819.495n 3.3v 1819.505n 3.3v 1829.495n 3.3v 1829.505n 3.3v 1839.495n 3.3v 1839.505n 3.3v 1849.495n 3.3v 1849.505n 3.3v 1859.495n 3.3v 1859.505n 3.3v 1869.495n 3.3v 1869.505n 3.3v 1879.495n 3.3v 1879.505n 3.3v 1889.495n 3.3v 1889.505n 3.3v 1899.495n 3.3v 1899.505n 3.3v 1909.495n 3.3v 1909.505n 0.0v 1919.495n 0.0v 1919.505n 0.0v 1929.495n 0.0v 1929.505n 0.0v 1939.495n 0.0v 1939.505n 0.0v 1949.495n 0.0v 1949.505n 0.0v 1959.495n 0.0v 1959.505n 0.0v 1969.495n 0.0v 1969.505n 0.0v 1979.495n 0.0v 1979.505n 0.0v 1989.495n 0.0v 1989.505n 0.0v 1999.495n 0.0v 1999.505n 3.3v 2009.495n 3.3v 2009.505n 3.3v 2019.495n 3.3v 2019.505n 3.3v 2029.495n 3.3v 2029.505n 0.0v 2039.495n 0.0v 2039.505n 0.0v 2049.495n 0.0v 2049.505n 0.0v )
* (time, data): [(0, 0), (10, 0), (20, 0), (30, 0), (40, 0), (50, 0), (60, 0), (70, 0), (80, 0), (90, 0), (100, 0), (110, 0), (120, 0), (130, 0), (140, 1), (150, 1), (160, 1), (170, 1), (180, 1), (190, 1), (200, 1), (210, 1), (220, 1), (230, 1), (240, 1), (250, 1), (260, 1), (270, 1), (280, 1), (290, 1), (300, 1), (310, 1), (320, 1), (330, 1), (340, 1), (350, 1), (360, 1), (370, 1), (380, 1), (390, 1), (400, 0), (410, 0), (420, 0), (430, 0), (440, 0), (450, 0), (460, 0), (470, 0), (480, 0), (490, 0), (500, 1), (510, 1), (520, 1), (530, 1), (540, 1), (550, 1), (560, 1), (570, 1), (580, 1), (590, 1), (600, 1), (610, 1), (620, 1), (630, 1), (640, 1), (650, 1), (660, 0), (670, 0), (680, 1), (690, 1), (700, 1), (710, 0), (720, 1), (730, 1), (740, 1), (750, 1), (760, 1), (770, 1), (780, 1), (790, 1), (800, 1), (810, 1), (820, 1), (830, 1), (840, 1), (850, 1), (860, 0), (870, 0), (880, 0), (890, 0), (900, 0), (910, 0), (920, 0), (930, 0), (940, 1), (950, 1), (960, 1), (970, 1), (980, 1), (990, 1), (1000, 1), (1010, 1), (1020, 1), (1030, 1), (1040, 1), (1050, 1), (1060, 1), (1070, 1), (1080, 1), (1090, 1), (1100, 0), (1110, 1), (1120, 1), (1130, 1), (1140, 1), (1150, 1), (1160, 1), (1170, 1), (1180, 1), (1190, 1), (1200, 1), (1210, 1), (1220, 1), (1230, 1), (1240, 1), (1250, 1), (1260, 1), (1270, 1), (1280, 1), (1290, 1), (1300, 1), (1310, 0), (1320, 0), (1330, 0), (1340, 0), (1350, 0), (1360, 0), (1370, 0), (1380, 0), (1390, 0), (1400, 0), (1410, 0), (1420, 0), (1430, 0), (1440, 0), (1450, 0), (1460, 0), (1470, 0), (1480, 0), (1490, 0), (1500, 0), (1510, 0), (1520, 0), (1530, 0), (1540, 0), (1550, 0), (1560, 0), (1570, 0), (1580, 0), (1590, 0), (1600, 1), (1610, 1), (1620, 1), (1630, 1), (1640, 1), (1650, 1), (1660, 1), (1670, 1), (1680, 1), (1690, 1), (1700, 1), (1710, 1), (1720, 1), (1730, 0), (1740, 0), (1750, 1), (1760, 1), (1770, 1), (1780, 1), (1790, 1), (1800, 1), (1810, 1), (1820, 1), (1830, 1), (1840, 1), (1850, 1), (1860, 1), (1870, 1), (1880, 0), (1890, 0), (1900, 0), (1910, 0), (1920, 0), (1930, 0), (1940, 0), (1950, 0), (1960, 0), (1970, 0), (1980, 1), (1990, 1), (2000, 0), (2010, 0), (2020, 0), (2030, 0), (2040, 0), (2050, 0)]
Vdin1_27  din1_27  0 PWL (0n 0.0v 9.495n 0.0v 9.505n 0.0v 19.495n 0.0v 19.505n 0.0v 29.495n 0.0v 29.505n 0.0v 39.495n 0.0v 39.505n 0.0v 49.495n 0.0v 49.505n 0.0v 59.495n 0.0v 59.505n 0.0v 69.495n 0.0v 69.505n 0.0v 79.495n 0.0v 79.505n 0.0v 89.495n 0.0v 89.505n 0.0v 99.495n 0.0v 99.505n 0.0v 109.495n 0.0v 109.505n 0.0v 119.495n 0.0v 119.505n 0.0v 129.495n 0.0v 129.505n 0.0v 139.495n 0.0v 139.505n 3.3v 149.495n 3.3v 149.505n 3.3v 159.495n 3.3v 159.505n 3.3v 169.495n 3.3v 169.505n 3.3v 179.495n 3.3v 179.505n 3.3v 189.495n 3.3v 189.505n 3.3v 199.495n 3.3v 199.505n 3.3v 209.495n 3.3v 209.505n 3.3v 219.495n 3.3v 219.505n 3.3v 229.495n 3.3v 229.505n 3.3v 239.495n 3.3v 239.505n 3.3v 249.495n 3.3v 249.505n 3.3v 259.495n 3.3v 259.505n 3.3v 269.495n 3.3v 269.505n 3.3v 279.495n 3.3v 279.505n 3.3v 289.495n 3.3v 289.505n 3.3v 299.495n 3.3v 299.505n 3.3v 309.495n 3.3v 309.505n 3.3v 319.495n 3.3v 319.505n 3.3v 329.495n 3.3v 329.505n 3.3v 339.495n 3.3v 339.505n 3.3v 349.495n 3.3v 349.505n 3.3v 359.495n 3.3v 359.505n 3.3v 369.495n 3.3v 369.505n 3.3v 379.495n 3.3v 379.505n 3.3v 389.495n 3.3v 389.505n 3.3v 399.495n 3.3v 399.505n 0.0v 409.495n 0.0v 409.505n 0.0v 419.495n 0.0v 419.505n 0.0v 429.495n 0.0v 429.505n 0.0v 439.495n 0.0v 439.505n 0.0v 449.495n 0.0v 449.505n 0.0v 459.495n 0.0v 459.505n 0.0v 469.495n 0.0v 469.505n 0.0v 479.495n 0.0v 479.505n 0.0v 489.495n 0.0v 489.505n 0.0v 499.495n 0.0v 499.505n 3.3v 509.495n 3.3v 509.505n 3.3v 519.495n 3.3v 519.505n 3.3v 529.495n 3.3v 529.505n 3.3v 539.495n 3.3v 539.505n 3.3v 549.495n 3.3v 549.505n 3.3v 559.495n 3.3v 559.505n 3.3v 569.495n 3.3v 569.505n 3.3v 579.495n 3.3v 579.505n 3.3v 589.495n 3.3v 589.505n 3.3v 599.495n 3.3v 599.505n 3.3v 609.495n 3.3v 609.505n 3.3v 619.495n 3.3v 619.505n 3.3v 629.495n 3.3v 629.505n 3.3v 639.495n 3.3v 639.505n 3.3v 649.495n 3.3v 649.505n 3.3v 659.495n 3.3v 659.505n 0.0v 669.495n 0.0v 669.505n 0.0v 679.495n 0.0v 679.505n 3.3v 689.495n 3.3v 689.505n 3.3v 699.495n 3.3v 699.505n 3.3v 709.495n 3.3v 709.505n 0.0v 719.495n 0.0v 719.505n 3.3v 729.495n 3.3v 729.505n 3.3v 739.495n 3.3v 739.505n 3.3v 749.495n 3.3v 749.505n 3.3v 759.495n 3.3v 759.505n 3.3v 769.495n 3.3v 769.505n 3.3v 779.495n 3.3v 779.505n 3.3v 789.495n 3.3v 789.505n 3.3v 799.495n 3.3v 799.505n 3.3v 809.495n 3.3v 809.505n 3.3v 819.495n 3.3v 819.505n 3.3v 829.495n 3.3v 829.505n 3.3v 839.495n 3.3v 839.505n 3.3v 849.495n 3.3v 849.505n 3.3v 859.495n 3.3v 859.505n 0.0v 869.495n 0.0v 869.505n 0.0v 879.495n 0.0v 879.505n 0.0v 889.495n 0.0v 889.505n 0.0v 899.495n 0.0v 899.505n 0.0v 909.495n 0.0v 909.505n 0.0v 919.495n 0.0v 919.505n 0.0v 929.495n 0.0v 929.505n 0.0v 939.495n 0.0v 939.505n 3.3v 949.495n 3.3v 949.505n 3.3v 959.495n 3.3v 959.505n 3.3v 969.495n 3.3v 969.505n 3.3v 979.495n 3.3v 979.505n 3.3v 989.495n 3.3v 989.505n 3.3v 999.495n 3.3v 999.505n 3.3v 1009.495n 3.3v 1009.505n 3.3v 1019.495n 3.3v 1019.505n 3.3v 1029.495n 3.3v 1029.505n 3.3v 1039.495n 3.3v 1039.505n 3.3v 1049.495n 3.3v 1049.505n 3.3v 1059.495n 3.3v 1059.505n 3.3v 1069.495n 3.3v 1069.505n 3.3v 1079.495n 3.3v 1079.505n 3.3v 1089.495n 3.3v 1089.505n 3.3v 1099.495n 3.3v 1099.505n 0.0v 1109.495n 0.0v 1109.505n 3.3v 1119.495n 3.3v 1119.505n 3.3v 1129.495n 3.3v 1129.505n 3.3v 1139.495n 3.3v 1139.505n 3.3v 1149.495n 3.3v 1149.505n 3.3v 1159.495n 3.3v 1159.505n 3.3v 1169.495n 3.3v 1169.505n 3.3v 1179.495n 3.3v 1179.505n 3.3v 1189.495n 3.3v 1189.505n 3.3v 1199.495n 3.3v 1199.505n 3.3v 1209.495n 3.3v 1209.505n 3.3v 1219.495n 3.3v 1219.505n 3.3v 1229.495n 3.3v 1229.505n 3.3v 1239.495n 3.3v 1239.505n 3.3v 1249.495n 3.3v 1249.505n 3.3v 1259.495n 3.3v 1259.505n 3.3v 1269.495n 3.3v 1269.505n 3.3v 1279.495n 3.3v 1279.505n 3.3v 1289.495n 3.3v 1289.505n 3.3v 1299.495n 3.3v 1299.505n 3.3v 1309.495n 3.3v 1309.505n 0.0v 1319.495n 0.0v 1319.505n 0.0v 1329.495n 0.0v 1329.505n 0.0v 1339.495n 0.0v 1339.505n 0.0v 1349.495n 0.0v 1349.505n 0.0v 1359.495n 0.0v 1359.505n 0.0v 1369.495n 0.0v 1369.505n 0.0v 1379.495n 0.0v 1379.505n 0.0v 1389.495n 0.0v 1389.505n 0.0v 1399.495n 0.0v 1399.505n 0.0v 1409.495n 0.0v 1409.505n 0.0v 1419.495n 0.0v 1419.505n 0.0v 1429.495n 0.0v 1429.505n 0.0v 1439.495n 0.0v 1439.505n 0.0v 1449.495n 0.0v 1449.505n 0.0v 1459.495n 0.0v 1459.505n 0.0v 1469.495n 0.0v 1469.505n 0.0v 1479.495n 0.0v 1479.505n 0.0v 1489.495n 0.0v 1489.505n 0.0v 1499.495n 0.0v 1499.505n 0.0v 1509.495n 0.0v 1509.505n 0.0v 1519.495n 0.0v 1519.505n 0.0v 1529.495n 0.0v 1529.505n 0.0v 1539.495n 0.0v 1539.505n 0.0v 1549.495n 0.0v 1549.505n 0.0v 1559.495n 0.0v 1559.505n 0.0v 1569.495n 0.0v 1569.505n 0.0v 1579.495n 0.0v 1579.505n 0.0v 1589.495n 0.0v 1589.505n 0.0v 1599.495n 0.0v 1599.505n 3.3v 1609.495n 3.3v 1609.505n 3.3v 1619.495n 3.3v 1619.505n 3.3v 1629.495n 3.3v 1629.505n 3.3v 1639.495n 3.3v 1639.505n 3.3v 1649.495n 3.3v 1649.505n 3.3v 1659.495n 3.3v 1659.505n 3.3v 1669.495n 3.3v 1669.505n 3.3v 1679.495n 3.3v 1679.505n 3.3v 1689.495n 3.3v 1689.505n 3.3v 1699.495n 3.3v 1699.505n 3.3v 1709.495n 3.3v 1709.505n 3.3v 1719.495n 3.3v 1719.505n 3.3v 1729.495n 3.3v 1729.505n 0.0v 1739.495n 0.0v 1739.505n 0.0v 1749.495n 0.0v 1749.505n 3.3v 1759.495n 3.3v 1759.505n 3.3v 1769.495n 3.3v 1769.505n 3.3v 1779.495n 3.3v 1779.505n 3.3v 1789.495n 3.3v 1789.505n 3.3v 1799.495n 3.3v 1799.505n 3.3v 1809.495n 3.3v 1809.505n 3.3v 1819.495n 3.3v 1819.505n 3.3v 1829.495n 3.3v 1829.505n 3.3v 1839.495n 3.3v 1839.505n 3.3v 1849.495n 3.3v 1849.505n 3.3v 1859.495n 3.3v 1859.505n 3.3v 1869.495n 3.3v 1869.505n 3.3v 1879.495n 3.3v 1879.505n 0.0v 1889.495n 0.0v 1889.505n 0.0v 1899.495n 0.0v 1899.505n 0.0v 1909.495n 0.0v 1909.505n 0.0v 1919.495n 0.0v 1919.505n 0.0v 1929.495n 0.0v 1929.505n 0.0v 1939.495n 0.0v 1939.505n 0.0v 1949.495n 0.0v 1949.505n 0.0v 1959.495n 0.0v 1959.505n 0.0v 1969.495n 0.0v 1969.505n 0.0v 1979.495n 0.0v 1979.505n 3.3v 1989.495n 3.3v 1989.505n 3.3v 1999.495n 3.3v 1999.505n 0.0v 2009.495n 0.0v 2009.505n 0.0v 2019.495n 0.0v 2019.505n 0.0v 2029.495n 0.0v 2029.505n 0.0v 2039.495n 0.0v 2039.505n 0.0v 2049.495n 0.0v 2049.505n 0.0v )
* (time, data): [(0, 0), (10, 0), (20, 1), (30, 1), (40, 1), (50, 1), (60, 1), (70, 1), (80, 0), (90, 0), (100, 0), (110, 0), (120, 0), (130, 0), (140, 0), (150, 0), (160, 0), (170, 1), (180, 1), (190, 1), (200, 1), (210, 1), (220, 1), (230, 1), (240, 1), (250, 1), (260, 1), (270, 1), (280, 1), (290, 1), (300, 1), (310, 1), (320, 1), (330, 1), (340, 1), (350, 1), (360, 1), (370, 0), (380, 1), (390, 1), (400, 0), (410, 0), (420, 0), (430, 0), (440, 0), (450, 0), (460, 0), (470, 0), (480, 0), (490, 0), (500, 0), (510, 0), (520, 0), (530, 0), (540, 0), (550, 0), (560, 0), (570, 0), (580, 0), (590, 0), (600, 0), (610, 0), (620, 0), (630, 0), (640, 0), (650, 0), (660, 1), (670, 1), (680, 0), (690, 0), (700, 0), (710, 0), (720, 0), (730, 0), (740, 0), (750, 0), (760, 0), (770, 0), (780, 0), (790, 0), (800, 0), (810, 0), (820, 0), (830, 0), (840, 0), (850, 0), (860, 0), (870, 1), (880, 1), (890, 1), (900, 1), (910, 1), (920, 1), (930, 1), (940, 0), (950, 1), (960, 1), (970, 1), (980, 1), (990, 1), (1000, 1), (1010, 1), (1020, 1), (1030, 1), (1040, 1), (1050, 0), (1060, 0), (1070, 0), (1080, 0), (1090, 0), (1100, 0), (1110, 1), (1120, 1), (1130, 1), (1140, 0), (1150, 0), (1160, 0), (1170, 0), (1180, 0), (1190, 0), (1200, 0), (1210, 1), (1220, 1), (1230, 1), (1240, 1), (1250, 0), (1260, 0), (1270, 0), (1280, 0), (1290, 0), (1300, 0), (1310, 1), (1320, 1), (1330, 1), (1340, 1), (1350, 1), (1360, 1), (1370, 1), (1380, 1), (1390, 1), (1400, 1), (1410, 1), (1420, 1), (1430, 1), (1440, 1), (1450, 1), (1460, 1), (1470, 1), (1480, 1), (1490, 0), (1500, 0), (1510, 0), (1520, 0), (1530, 0), (1540, 0), (1550, 0), (1560, 0), (1570, 0), (1580, 0), (1590, 0), (1600, 0), (1610, 0), (1620, 0), (1630, 0), (1640, 0), (1650, 0), (1660, 0), (1670, 0), (1680, 0), (1690, 0), (1700, 0), (1710, 0), (1720, 0), (1730, 0), (1740, 0), (1750, 0), (1760, 0), (1770, 0), (1780, 0), (1790, 0), (1800, 0), (1810, 0), (1820, 1), (1830, 1), (1840, 1), (1850, 1), (1860, 1), (1870, 1), (1880, 1), (1890, 1), (1900, 1), (1910, 0), (1920, 0), (1930, 0), (1940, 0), (1950, 0), (1960, 0), (1970, 0), (1980, 0), (1990, 0), (2000, 1), (2010, 1), (2020, 0), (2030, 0), (2040, 0), (2050, 0)]
Vdin1_28  din1_28  0 PWL (0n 0.0v 9.495n 0.0v 9.505n 0.0v 19.495n 0.0v 19.505n 3.3v 29.495n 3.3v 29.505n 3.3v 39.495n 3.3v 39.505n 3.3v 49.495n 3.3v 49.505n 3.3v 59.495n 3.3v 59.505n 3.3v 69.495n 3.3v 69.505n 3.3v 79.495n 3.3v 79.505n 0.0v 89.495n 0.0v 89.505n 0.0v 99.495n 0.0v 99.505n 0.0v 109.495n 0.0v 109.505n 0.0v 119.495n 0.0v 119.505n 0.0v 129.495n 0.0v 129.505n 0.0v 139.495n 0.0v 139.505n 0.0v 149.495n 0.0v 149.505n 0.0v 159.495n 0.0v 159.505n 0.0v 169.495n 0.0v 169.505n 3.3v 179.495n 3.3v 179.505n 3.3v 189.495n 3.3v 189.505n 3.3v 199.495n 3.3v 199.505n 3.3v 209.495n 3.3v 209.505n 3.3v 219.495n 3.3v 219.505n 3.3v 229.495n 3.3v 229.505n 3.3v 239.495n 3.3v 239.505n 3.3v 249.495n 3.3v 249.505n 3.3v 259.495n 3.3v 259.505n 3.3v 269.495n 3.3v 269.505n 3.3v 279.495n 3.3v 279.505n 3.3v 289.495n 3.3v 289.505n 3.3v 299.495n 3.3v 299.505n 3.3v 309.495n 3.3v 309.505n 3.3v 319.495n 3.3v 319.505n 3.3v 329.495n 3.3v 329.505n 3.3v 339.495n 3.3v 339.505n 3.3v 349.495n 3.3v 349.505n 3.3v 359.495n 3.3v 359.505n 3.3v 369.495n 3.3v 369.505n 0.0v 379.495n 0.0v 379.505n 3.3v 389.495n 3.3v 389.505n 3.3v 399.495n 3.3v 399.505n 0.0v 409.495n 0.0v 409.505n 0.0v 419.495n 0.0v 419.505n 0.0v 429.495n 0.0v 429.505n 0.0v 439.495n 0.0v 439.505n 0.0v 449.495n 0.0v 449.505n 0.0v 459.495n 0.0v 459.505n 0.0v 469.495n 0.0v 469.505n 0.0v 479.495n 0.0v 479.505n 0.0v 489.495n 0.0v 489.505n 0.0v 499.495n 0.0v 499.505n 0.0v 509.495n 0.0v 509.505n 0.0v 519.495n 0.0v 519.505n 0.0v 529.495n 0.0v 529.505n 0.0v 539.495n 0.0v 539.505n 0.0v 549.495n 0.0v 549.505n 0.0v 559.495n 0.0v 559.505n 0.0v 569.495n 0.0v 569.505n 0.0v 579.495n 0.0v 579.505n 0.0v 589.495n 0.0v 589.505n 0.0v 599.495n 0.0v 599.505n 0.0v 609.495n 0.0v 609.505n 0.0v 619.495n 0.0v 619.505n 0.0v 629.495n 0.0v 629.505n 0.0v 639.495n 0.0v 639.505n 0.0v 649.495n 0.0v 649.505n 0.0v 659.495n 0.0v 659.505n 3.3v 669.495n 3.3v 669.505n 3.3v 679.495n 3.3v 679.505n 0.0v 689.495n 0.0v 689.505n 0.0v 699.495n 0.0v 699.505n 0.0v 709.495n 0.0v 709.505n 0.0v 719.495n 0.0v 719.505n 0.0v 729.495n 0.0v 729.505n 0.0v 739.495n 0.0v 739.505n 0.0v 749.495n 0.0v 749.505n 0.0v 759.495n 0.0v 759.505n 0.0v 769.495n 0.0v 769.505n 0.0v 779.495n 0.0v 779.505n 0.0v 789.495n 0.0v 789.505n 0.0v 799.495n 0.0v 799.505n 0.0v 809.495n 0.0v 809.505n 0.0v 819.495n 0.0v 819.505n 0.0v 829.495n 0.0v 829.505n 0.0v 839.495n 0.0v 839.505n 0.0v 849.495n 0.0v 849.505n 0.0v 859.495n 0.0v 859.505n 0.0v 869.495n 0.0v 869.505n 3.3v 879.495n 3.3v 879.505n 3.3v 889.495n 3.3v 889.505n 3.3v 899.495n 3.3v 899.505n 3.3v 909.495n 3.3v 909.505n 3.3v 919.495n 3.3v 919.505n 3.3v 929.495n 3.3v 929.505n 3.3v 939.495n 3.3v 939.505n 0.0v 949.495n 0.0v 949.505n 3.3v 959.495n 3.3v 959.505n 3.3v 969.495n 3.3v 969.505n 3.3v 979.495n 3.3v 979.505n 3.3v 989.495n 3.3v 989.505n 3.3v 999.495n 3.3v 999.505n 3.3v 1009.495n 3.3v 1009.505n 3.3v 1019.495n 3.3v 1019.505n 3.3v 1029.495n 3.3v 1029.505n 3.3v 1039.495n 3.3v 1039.505n 3.3v 1049.495n 3.3v 1049.505n 0.0v 1059.495n 0.0v 1059.505n 0.0v 1069.495n 0.0v 1069.505n 0.0v 1079.495n 0.0v 1079.505n 0.0v 1089.495n 0.0v 1089.505n 0.0v 1099.495n 0.0v 1099.505n 0.0v 1109.495n 0.0v 1109.505n 3.3v 1119.495n 3.3v 1119.505n 3.3v 1129.495n 3.3v 1129.505n 3.3v 1139.495n 3.3v 1139.505n 0.0v 1149.495n 0.0v 1149.505n 0.0v 1159.495n 0.0v 1159.505n 0.0v 1169.495n 0.0v 1169.505n 0.0v 1179.495n 0.0v 1179.505n 0.0v 1189.495n 0.0v 1189.505n 0.0v 1199.495n 0.0v 1199.505n 0.0v 1209.495n 0.0v 1209.505n 3.3v 1219.495n 3.3v 1219.505n 3.3v 1229.495n 3.3v 1229.505n 3.3v 1239.495n 3.3v 1239.505n 3.3v 1249.495n 3.3v 1249.505n 0.0v 1259.495n 0.0v 1259.505n 0.0v 1269.495n 0.0v 1269.505n 0.0v 1279.495n 0.0v 1279.505n 0.0v 1289.495n 0.0v 1289.505n 0.0v 1299.495n 0.0v 1299.505n 0.0v 1309.495n 0.0v 1309.505n 3.3v 1319.495n 3.3v 1319.505n 3.3v 1329.495n 3.3v 1329.505n 3.3v 1339.495n 3.3v 1339.505n 3.3v 1349.495n 3.3v 1349.505n 3.3v 1359.495n 3.3v 1359.505n 3.3v 1369.495n 3.3v 1369.505n 3.3v 1379.495n 3.3v 1379.505n 3.3v 1389.495n 3.3v 1389.505n 3.3v 1399.495n 3.3v 1399.505n 3.3v 1409.495n 3.3v 1409.505n 3.3v 1419.495n 3.3v 1419.505n 3.3v 1429.495n 3.3v 1429.505n 3.3v 1439.495n 3.3v 1439.505n 3.3v 1449.495n 3.3v 1449.505n 3.3v 1459.495n 3.3v 1459.505n 3.3v 1469.495n 3.3v 1469.505n 3.3v 1479.495n 3.3v 1479.505n 3.3v 1489.495n 3.3v 1489.505n 0.0v 1499.495n 0.0v 1499.505n 0.0v 1509.495n 0.0v 1509.505n 0.0v 1519.495n 0.0v 1519.505n 0.0v 1529.495n 0.0v 1529.505n 0.0v 1539.495n 0.0v 1539.505n 0.0v 1549.495n 0.0v 1549.505n 0.0v 1559.495n 0.0v 1559.505n 0.0v 1569.495n 0.0v 1569.505n 0.0v 1579.495n 0.0v 1579.505n 0.0v 1589.495n 0.0v 1589.505n 0.0v 1599.495n 0.0v 1599.505n 0.0v 1609.495n 0.0v 1609.505n 0.0v 1619.495n 0.0v 1619.505n 0.0v 1629.495n 0.0v 1629.505n 0.0v 1639.495n 0.0v 1639.505n 0.0v 1649.495n 0.0v 1649.505n 0.0v 1659.495n 0.0v 1659.505n 0.0v 1669.495n 0.0v 1669.505n 0.0v 1679.495n 0.0v 1679.505n 0.0v 1689.495n 0.0v 1689.505n 0.0v 1699.495n 0.0v 1699.505n 0.0v 1709.495n 0.0v 1709.505n 0.0v 1719.495n 0.0v 1719.505n 0.0v 1729.495n 0.0v 1729.505n 0.0v 1739.495n 0.0v 1739.505n 0.0v 1749.495n 0.0v 1749.505n 0.0v 1759.495n 0.0v 1759.505n 0.0v 1769.495n 0.0v 1769.505n 0.0v 1779.495n 0.0v 1779.505n 0.0v 1789.495n 0.0v 1789.505n 0.0v 1799.495n 0.0v 1799.505n 0.0v 1809.495n 0.0v 1809.505n 0.0v 1819.495n 0.0v 1819.505n 3.3v 1829.495n 3.3v 1829.505n 3.3v 1839.495n 3.3v 1839.505n 3.3v 1849.495n 3.3v 1849.505n 3.3v 1859.495n 3.3v 1859.505n 3.3v 1869.495n 3.3v 1869.505n 3.3v 1879.495n 3.3v 1879.505n 3.3v 1889.495n 3.3v 1889.505n 3.3v 1899.495n 3.3v 1899.505n 3.3v 1909.495n 3.3v 1909.505n 0.0v 1919.495n 0.0v 1919.505n 0.0v 1929.495n 0.0v 1929.505n 0.0v 1939.495n 0.0v 1939.505n 0.0v 1949.495n 0.0v 1949.505n 0.0v 1959.495n 0.0v 1959.505n 0.0v 1969.495n 0.0v 1969.505n 0.0v 1979.495n 0.0v 1979.505n 0.0v 1989.495n 0.0v 1989.505n 0.0v 1999.495n 0.0v 1999.505n 3.3v 2009.495n 3.3v 2009.505n 3.3v 2019.495n 3.3v 2019.505n 0.0v 2029.495n 0.0v 2029.505n 0.0v 2039.495n 0.0v 2039.505n 0.0v 2049.495n 0.0v 2049.505n 0.0v )
* (time, data): [(0, 0), (10, 1), (20, 1), (30, 0), (40, 0), (50, 0), (60, 0), (70, 1), (80, 0), (90, 0), (100, 0), (110, 0), (120, 1), (130, 1), (140, 0), (150, 0), (160, 0), (170, 0), (180, 0), (190, 0), (200, 0), (210, 0), (220, 0), (230, 0), (240, 0), (250, 0), (260, 0), (270, 0), (280, 0), (290, 0), (300, 0), (310, 0), (320, 0), (330, 0), (340, 0), (350, 0), (360, 0), (370, 0), (380, 0), (390, 0), (400, 1), (410, 1), (420, 1), (430, 1), (440, 1), (450, 1), (460, 1), (470, 1), (480, 1), (490, 1), (500, 1), (510, 1), (520, 1), (530, 1), (540, 1), (550, 1), (560, 1), (570, 1), (580, 1), (590, 1), (600, 1), (610, 1), (620, 1), (630, 1), (640, 1), (650, 1), (660, 1), (670, 1), (680, 1), (690, 1), (700, 1), (710, 0), (720, 1), (730, 1), (740, 1), (750, 1), (760, 1), (770, 1), (780, 1), (790, 1), (800, 1), (810, 1), (820, 1), (830, 1), (840, 1), (850, 1), (860, 1), (870, 0), (880, 0), (890, 0), (900, 0), (910, 0), (920, 0), (930, 0), (940, 0), (950, 0), (960, 0), (970, 0), (980, 0), (990, 0), (1000, 0), (1010, 0), (1020, 0), (1030, 0), (1040, 1), (1050, 1), (1060, 1), (1070, 1), (1080, 1), (1090, 1), (1100, 1), (1110, 0), (1120, 0), (1130, 0), (1140, 1), (1150, 1), (1160, 1), (1170, 1), (1180, 1), (1190, 1), (1200, 1), (1210, 1), (1220, 1), (1230, 1), (1240, 1), (1250, 1), (1260, 1), (1270, 1), (1280, 1), (1290, 1), (1300, 1), (1310, 0), (1320, 0), (1330, 0), (1340, 0), (1350, 0), (1360, 0), (1370, 0), (1380, 0), (1390, 0), (1400, 0), (1410, 0), (1420, 0), (1430, 0), (1440, 0), (1450, 0), (1460, 0), (1470, 0), (1480, 0), (1490, 0), (1500, 0), (1510, 0), (1520, 0), (1530, 0), (1540, 0), (1550, 0), (1560, 1), (1570, 1), (1580, 1), (1590, 1), (1600, 0), (1610, 0), (1620, 0), (1630, 0), (1640, 0), (1650, 0), (1660, 0), (1670, 0), (1680, 0), (1690, 0), (1700, 0), (1710, 0), (1720, 0), (1730, 1), (1740, 1), (1750, 1), (1760, 1), (1770, 1), (1780, 1), (1790, 1), (1800, 1), (1810, 1), (1820, 0), (1830, 0), (1840, 0), (1850, 0), (1860, 0), (1870, 0), (1880, 1), (1890, 1), (1900, 1), (1910, 1), (1920, 1), (1930, 1), (1940, 0), (1950, 0), (1960, 0), (1970, 0), (1980, 1), (1990, 1), (2000, 1), (2010, 1), (2020, 0), (2030, 1), (2040, 1), (2050, 1)]
Vdin1_29  din1_29  0 PWL (0n 0.0v 9.495n 0.0v 9.505n 3.3v 19.495n 3.3v 19.505n 3.3v 29.495n 3.3v 29.505n 0.0v 39.495n 0.0v 39.505n 0.0v 49.495n 0.0v 49.505n 0.0v 59.495n 0.0v 59.505n 0.0v 69.495n 0.0v 69.505n 3.3v 79.495n 3.3v 79.505n 0.0v 89.495n 0.0v 89.505n 0.0v 99.495n 0.0v 99.505n 0.0v 109.495n 0.0v 109.505n 0.0v 119.495n 0.0v 119.505n 3.3v 129.495n 3.3v 129.505n 3.3v 139.495n 3.3v 139.505n 0.0v 149.495n 0.0v 149.505n 0.0v 159.495n 0.0v 159.505n 0.0v 169.495n 0.0v 169.505n 0.0v 179.495n 0.0v 179.505n 0.0v 189.495n 0.0v 189.505n 0.0v 199.495n 0.0v 199.505n 0.0v 209.495n 0.0v 209.505n 0.0v 219.495n 0.0v 219.505n 0.0v 229.495n 0.0v 229.505n 0.0v 239.495n 0.0v 239.505n 0.0v 249.495n 0.0v 249.505n 0.0v 259.495n 0.0v 259.505n 0.0v 269.495n 0.0v 269.505n 0.0v 279.495n 0.0v 279.505n 0.0v 289.495n 0.0v 289.505n 0.0v 299.495n 0.0v 299.505n 0.0v 309.495n 0.0v 309.505n 0.0v 319.495n 0.0v 319.505n 0.0v 329.495n 0.0v 329.505n 0.0v 339.495n 0.0v 339.505n 0.0v 349.495n 0.0v 349.505n 0.0v 359.495n 0.0v 359.505n 0.0v 369.495n 0.0v 369.505n 0.0v 379.495n 0.0v 379.505n 0.0v 389.495n 0.0v 389.505n 0.0v 399.495n 0.0v 399.505n 3.3v 409.495n 3.3v 409.505n 3.3v 419.495n 3.3v 419.505n 3.3v 429.495n 3.3v 429.505n 3.3v 439.495n 3.3v 439.505n 3.3v 449.495n 3.3v 449.505n 3.3v 459.495n 3.3v 459.505n 3.3v 469.495n 3.3v 469.505n 3.3v 479.495n 3.3v 479.505n 3.3v 489.495n 3.3v 489.505n 3.3v 499.495n 3.3v 499.505n 3.3v 509.495n 3.3v 509.505n 3.3v 519.495n 3.3v 519.505n 3.3v 529.495n 3.3v 529.505n 3.3v 539.495n 3.3v 539.505n 3.3v 549.495n 3.3v 549.505n 3.3v 559.495n 3.3v 559.505n 3.3v 569.495n 3.3v 569.505n 3.3v 579.495n 3.3v 579.505n 3.3v 589.495n 3.3v 589.505n 3.3v 599.495n 3.3v 599.505n 3.3v 609.495n 3.3v 609.505n 3.3v 619.495n 3.3v 619.505n 3.3v 629.495n 3.3v 629.505n 3.3v 639.495n 3.3v 639.505n 3.3v 649.495n 3.3v 649.505n 3.3v 659.495n 3.3v 659.505n 3.3v 669.495n 3.3v 669.505n 3.3v 679.495n 3.3v 679.505n 3.3v 689.495n 3.3v 689.505n 3.3v 699.495n 3.3v 699.505n 3.3v 709.495n 3.3v 709.505n 0.0v 719.495n 0.0v 719.505n 3.3v 729.495n 3.3v 729.505n 3.3v 739.495n 3.3v 739.505n 3.3v 749.495n 3.3v 749.505n 3.3v 759.495n 3.3v 759.505n 3.3v 769.495n 3.3v 769.505n 3.3v 779.495n 3.3v 779.505n 3.3v 789.495n 3.3v 789.505n 3.3v 799.495n 3.3v 799.505n 3.3v 809.495n 3.3v 809.505n 3.3v 819.495n 3.3v 819.505n 3.3v 829.495n 3.3v 829.505n 3.3v 839.495n 3.3v 839.505n 3.3v 849.495n 3.3v 849.505n 3.3v 859.495n 3.3v 859.505n 3.3v 869.495n 3.3v 869.505n 0.0v 879.495n 0.0v 879.505n 0.0v 889.495n 0.0v 889.505n 0.0v 899.495n 0.0v 899.505n 0.0v 909.495n 0.0v 909.505n 0.0v 919.495n 0.0v 919.505n 0.0v 929.495n 0.0v 929.505n 0.0v 939.495n 0.0v 939.505n 0.0v 949.495n 0.0v 949.505n 0.0v 959.495n 0.0v 959.505n 0.0v 969.495n 0.0v 969.505n 0.0v 979.495n 0.0v 979.505n 0.0v 989.495n 0.0v 989.505n 0.0v 999.495n 0.0v 999.505n 0.0v 1009.495n 0.0v 1009.505n 0.0v 1019.495n 0.0v 1019.505n 0.0v 1029.495n 0.0v 1029.505n 0.0v 1039.495n 0.0v 1039.505n 3.3v 1049.495n 3.3v 1049.505n 3.3v 1059.495n 3.3v 1059.505n 3.3v 1069.495n 3.3v 1069.505n 3.3v 1079.495n 3.3v 1079.505n 3.3v 1089.495n 3.3v 1089.505n 3.3v 1099.495n 3.3v 1099.505n 3.3v 1109.495n 3.3v 1109.505n 0.0v 1119.495n 0.0v 1119.505n 0.0v 1129.495n 0.0v 1129.505n 0.0v 1139.495n 0.0v 1139.505n 3.3v 1149.495n 3.3v 1149.505n 3.3v 1159.495n 3.3v 1159.505n 3.3v 1169.495n 3.3v 1169.505n 3.3v 1179.495n 3.3v 1179.505n 3.3v 1189.495n 3.3v 1189.505n 3.3v 1199.495n 3.3v 1199.505n 3.3v 1209.495n 3.3v 1209.505n 3.3v 1219.495n 3.3v 1219.505n 3.3v 1229.495n 3.3v 1229.505n 3.3v 1239.495n 3.3v 1239.505n 3.3v 1249.495n 3.3v 1249.505n 3.3v 1259.495n 3.3v 1259.505n 3.3v 1269.495n 3.3v 1269.505n 3.3v 1279.495n 3.3v 1279.505n 3.3v 1289.495n 3.3v 1289.505n 3.3v 1299.495n 3.3v 1299.505n 3.3v 1309.495n 3.3v 1309.505n 0.0v 1319.495n 0.0v 1319.505n 0.0v 1329.495n 0.0v 1329.505n 0.0v 1339.495n 0.0v 1339.505n 0.0v 1349.495n 0.0v 1349.505n 0.0v 1359.495n 0.0v 1359.505n 0.0v 1369.495n 0.0v 1369.505n 0.0v 1379.495n 0.0v 1379.505n 0.0v 1389.495n 0.0v 1389.505n 0.0v 1399.495n 0.0v 1399.505n 0.0v 1409.495n 0.0v 1409.505n 0.0v 1419.495n 0.0v 1419.505n 0.0v 1429.495n 0.0v 1429.505n 0.0v 1439.495n 0.0v 1439.505n 0.0v 1449.495n 0.0v 1449.505n 0.0v 1459.495n 0.0v 1459.505n 0.0v 1469.495n 0.0v 1469.505n 0.0v 1479.495n 0.0v 1479.505n 0.0v 1489.495n 0.0v 1489.505n 0.0v 1499.495n 0.0v 1499.505n 0.0v 1509.495n 0.0v 1509.505n 0.0v 1519.495n 0.0v 1519.505n 0.0v 1529.495n 0.0v 1529.505n 0.0v 1539.495n 0.0v 1539.505n 0.0v 1549.495n 0.0v 1549.505n 0.0v 1559.495n 0.0v 1559.505n 3.3v 1569.495n 3.3v 1569.505n 3.3v 1579.495n 3.3v 1579.505n 3.3v 1589.495n 3.3v 1589.505n 3.3v 1599.495n 3.3v 1599.505n 0.0v 1609.495n 0.0v 1609.505n 0.0v 1619.495n 0.0v 1619.505n 0.0v 1629.495n 0.0v 1629.505n 0.0v 1639.495n 0.0v 1639.505n 0.0v 1649.495n 0.0v 1649.505n 0.0v 1659.495n 0.0v 1659.505n 0.0v 1669.495n 0.0v 1669.505n 0.0v 1679.495n 0.0v 1679.505n 0.0v 1689.495n 0.0v 1689.505n 0.0v 1699.495n 0.0v 1699.505n 0.0v 1709.495n 0.0v 1709.505n 0.0v 1719.495n 0.0v 1719.505n 0.0v 1729.495n 0.0v 1729.505n 3.3v 1739.495n 3.3v 1739.505n 3.3v 1749.495n 3.3v 1749.505n 3.3v 1759.495n 3.3v 1759.505n 3.3v 1769.495n 3.3v 1769.505n 3.3v 1779.495n 3.3v 1779.505n 3.3v 1789.495n 3.3v 1789.505n 3.3v 1799.495n 3.3v 1799.505n 3.3v 1809.495n 3.3v 1809.505n 3.3v 1819.495n 3.3v 1819.505n 0.0v 1829.495n 0.0v 1829.505n 0.0v 1839.495n 0.0v 1839.505n 0.0v 1849.495n 0.0v 1849.505n 0.0v 1859.495n 0.0v 1859.505n 0.0v 1869.495n 0.0v 1869.505n 0.0v 1879.495n 0.0v 1879.505n 3.3v 1889.495n 3.3v 1889.505n 3.3v 1899.495n 3.3v 1899.505n 3.3v 1909.495n 3.3v 1909.505n 3.3v 1919.495n 3.3v 1919.505n 3.3v 1929.495n 3.3v 1929.505n 3.3v 1939.495n 3.3v 1939.505n 0.0v 1949.495n 0.0v 1949.505n 0.0v 1959.495n 0.0v 1959.505n 0.0v 1969.495n 0.0v 1969.505n 0.0v 1979.495n 0.0v 1979.505n 3.3v 1989.495n 3.3v 1989.505n 3.3v 1999.495n 3.3v 1999.505n 3.3v 2009.495n 3.3v 2009.505n 3.3v 2019.495n 3.3v 2019.505n 0.0v 2029.495n 0.0v 2029.505n 3.3v 2039.495n 3.3v 2039.505n 3.3v 2049.495n 3.3v 2049.505n 3.3v )
* (time, data): [(0, 0), (10, 0), (20, 0), (30, 0), (40, 0), (50, 0), (60, 0), (70, 1), (80, 0), (90, 0), (100, 0), (110, 0), (120, 1), (130, 1), (140, 1), (150, 1), (160, 1), (170, 1), (180, 1), (190, 1), (200, 1), (210, 1), (220, 1), (230, 1), (240, 0), (250, 0), (260, 0), (270, 0), (280, 0), (290, 0), (300, 0), (310, 0), (320, 0), (330, 0), (340, 0), (350, 0), (360, 0), (370, 0), (380, 0), (390, 0), (400, 1), (410, 1), (420, 1), (430, 1), (440, 1), (450, 1), (460, 1), (470, 1), (480, 1), (490, 1), (500, 0), (510, 0), (520, 0), (530, 0), (540, 0), (550, 0), (560, 0), (570, 0), (580, 0), (590, 0), (600, 0), (610, 0), (620, 0), (630, 0), (640, 0), (650, 0), (660, 1), (670, 1), (680, 0), (690, 0), (700, 0), (710, 0), (720, 1), (730, 1), (740, 1), (750, 1), (760, 1), (770, 1), (780, 1), (790, 1), (800, 1), (810, 1), (820, 1), (830, 1), (840, 1), (850, 1), (860, 0), (870, 1), (880, 1), (890, 1), (900, 1), (910, 1), (920, 1), (930, 1), (940, 1), (950, 0), (960, 0), (970, 0), (980, 0), (990, 0), (1000, 0), (1010, 0), (1020, 0), (1030, 0), (1040, 0), (1050, 0), (1060, 0), (1070, 0), (1080, 0), (1090, 0), (1100, 0), (1110, 0), (1120, 0), (1130, 0), (1140, 0), (1150, 0), (1160, 0), (1170, 0), (1180, 0), (1190, 0), (1200, 0), (1210, 1), (1220, 1), (1230, 1), (1240, 1), (1250, 1), (1260, 1), (1270, 1), (1280, 1), (1290, 1), (1300, 1), (1310, 1), (1320, 1), (1330, 1), (1340, 1), (1350, 1), (1360, 1), (1370, 1), (1380, 1), (1390, 1), (1400, 1), (1410, 1), (1420, 1), (1430, 1), (1440, 0), (1450, 0), (1460, 0), (1470, 0), (1480, 0), (1490, 1), (1500, 1), (1510, 1), (1520, 1), (1530, 1), (1540, 1), (1550, 0), (1560, 0), (1570, 0), (1580, 0), (1590, 0), (1600, 1), (1610, 1), (1620, 1), (1630, 1), (1640, 1), (1650, 1), (1660, 1), (1670, 1), (1680, 1), (1690, 1), (1700, 1), (1710, 1), (1720, 1), (1730, 0), (1740, 0), (1750, 1), (1760, 1), (1770, 1), (1780, 1), (1790, 1), (1800, 1), (1810, 1), (1820, 0), (1830, 0), (1840, 0), (1850, 0), (1860, 1), (1870, 1), (1880, 0), (1890, 0), (1900, 0), (1910, 0), (1920, 0), (1930, 0), (1940, 1), (1950, 1), (1960, 1), (1970, 1), (1980, 1), (1990, 1), (2000, 1), (2010, 1), (2020, 1), (2030, 1), (2040, 1), (2050, 1)]
Vdin1_30  din1_30  0 PWL (0n 0.0v 9.495n 0.0v 9.505n 0.0v 19.495n 0.0v 19.505n 0.0v 29.495n 0.0v 29.505n 0.0v 39.495n 0.0v 39.505n 0.0v 49.495n 0.0v 49.505n 0.0v 59.495n 0.0v 59.505n 0.0v 69.495n 0.0v 69.505n 3.3v 79.495n 3.3v 79.505n 0.0v 89.495n 0.0v 89.505n 0.0v 99.495n 0.0v 99.505n 0.0v 109.495n 0.0v 109.505n 0.0v 119.495n 0.0v 119.505n 3.3v 129.495n 3.3v 129.505n 3.3v 139.495n 3.3v 139.505n 3.3v 149.495n 3.3v 149.505n 3.3v 159.495n 3.3v 159.505n 3.3v 169.495n 3.3v 169.505n 3.3v 179.495n 3.3v 179.505n 3.3v 189.495n 3.3v 189.505n 3.3v 199.495n 3.3v 199.505n 3.3v 209.495n 3.3v 209.505n 3.3v 219.495n 3.3v 219.505n 3.3v 229.495n 3.3v 229.505n 3.3v 239.495n 3.3v 239.505n 0.0v 249.495n 0.0v 249.505n 0.0v 259.495n 0.0v 259.505n 0.0v 269.495n 0.0v 269.505n 0.0v 279.495n 0.0v 279.505n 0.0v 289.495n 0.0v 289.505n 0.0v 299.495n 0.0v 299.505n 0.0v 309.495n 0.0v 309.505n 0.0v 319.495n 0.0v 319.505n 0.0v 329.495n 0.0v 329.505n 0.0v 339.495n 0.0v 339.505n 0.0v 349.495n 0.0v 349.505n 0.0v 359.495n 0.0v 359.505n 0.0v 369.495n 0.0v 369.505n 0.0v 379.495n 0.0v 379.505n 0.0v 389.495n 0.0v 389.505n 0.0v 399.495n 0.0v 399.505n 3.3v 409.495n 3.3v 409.505n 3.3v 419.495n 3.3v 419.505n 3.3v 429.495n 3.3v 429.505n 3.3v 439.495n 3.3v 439.505n 3.3v 449.495n 3.3v 449.505n 3.3v 459.495n 3.3v 459.505n 3.3v 469.495n 3.3v 469.505n 3.3v 479.495n 3.3v 479.505n 3.3v 489.495n 3.3v 489.505n 3.3v 499.495n 3.3v 499.505n 0.0v 509.495n 0.0v 509.505n 0.0v 519.495n 0.0v 519.505n 0.0v 529.495n 0.0v 529.505n 0.0v 539.495n 0.0v 539.505n 0.0v 549.495n 0.0v 549.505n 0.0v 559.495n 0.0v 559.505n 0.0v 569.495n 0.0v 569.505n 0.0v 579.495n 0.0v 579.505n 0.0v 589.495n 0.0v 589.505n 0.0v 599.495n 0.0v 599.505n 0.0v 609.495n 0.0v 609.505n 0.0v 619.495n 0.0v 619.505n 0.0v 629.495n 0.0v 629.505n 0.0v 639.495n 0.0v 639.505n 0.0v 649.495n 0.0v 649.505n 0.0v 659.495n 0.0v 659.505n 3.3v 669.495n 3.3v 669.505n 3.3v 679.495n 3.3v 679.505n 0.0v 689.495n 0.0v 689.505n 0.0v 699.495n 0.0v 699.505n 0.0v 709.495n 0.0v 709.505n 0.0v 719.495n 0.0v 719.505n 3.3v 729.495n 3.3v 729.505n 3.3v 739.495n 3.3v 739.505n 3.3v 749.495n 3.3v 749.505n 3.3v 759.495n 3.3v 759.505n 3.3v 769.495n 3.3v 769.505n 3.3v 779.495n 3.3v 779.505n 3.3v 789.495n 3.3v 789.505n 3.3v 799.495n 3.3v 799.505n 3.3v 809.495n 3.3v 809.505n 3.3v 819.495n 3.3v 819.505n 3.3v 829.495n 3.3v 829.505n 3.3v 839.495n 3.3v 839.505n 3.3v 849.495n 3.3v 849.505n 3.3v 859.495n 3.3v 859.505n 0.0v 869.495n 0.0v 869.505n 3.3v 879.495n 3.3v 879.505n 3.3v 889.495n 3.3v 889.505n 3.3v 899.495n 3.3v 899.505n 3.3v 909.495n 3.3v 909.505n 3.3v 919.495n 3.3v 919.505n 3.3v 929.495n 3.3v 929.505n 3.3v 939.495n 3.3v 939.505n 3.3v 949.495n 3.3v 949.505n 0.0v 959.495n 0.0v 959.505n 0.0v 969.495n 0.0v 969.505n 0.0v 979.495n 0.0v 979.505n 0.0v 989.495n 0.0v 989.505n 0.0v 999.495n 0.0v 999.505n 0.0v 1009.495n 0.0v 1009.505n 0.0v 1019.495n 0.0v 1019.505n 0.0v 1029.495n 0.0v 1029.505n 0.0v 1039.495n 0.0v 1039.505n 0.0v 1049.495n 0.0v 1049.505n 0.0v 1059.495n 0.0v 1059.505n 0.0v 1069.495n 0.0v 1069.505n 0.0v 1079.495n 0.0v 1079.505n 0.0v 1089.495n 0.0v 1089.505n 0.0v 1099.495n 0.0v 1099.505n 0.0v 1109.495n 0.0v 1109.505n 0.0v 1119.495n 0.0v 1119.505n 0.0v 1129.495n 0.0v 1129.505n 0.0v 1139.495n 0.0v 1139.505n 0.0v 1149.495n 0.0v 1149.505n 0.0v 1159.495n 0.0v 1159.505n 0.0v 1169.495n 0.0v 1169.505n 0.0v 1179.495n 0.0v 1179.505n 0.0v 1189.495n 0.0v 1189.505n 0.0v 1199.495n 0.0v 1199.505n 0.0v 1209.495n 0.0v 1209.505n 3.3v 1219.495n 3.3v 1219.505n 3.3v 1229.495n 3.3v 1229.505n 3.3v 1239.495n 3.3v 1239.505n 3.3v 1249.495n 3.3v 1249.505n 3.3v 1259.495n 3.3v 1259.505n 3.3v 1269.495n 3.3v 1269.505n 3.3v 1279.495n 3.3v 1279.505n 3.3v 1289.495n 3.3v 1289.505n 3.3v 1299.495n 3.3v 1299.505n 3.3v 1309.495n 3.3v 1309.505n 3.3v 1319.495n 3.3v 1319.505n 3.3v 1329.495n 3.3v 1329.505n 3.3v 1339.495n 3.3v 1339.505n 3.3v 1349.495n 3.3v 1349.505n 3.3v 1359.495n 3.3v 1359.505n 3.3v 1369.495n 3.3v 1369.505n 3.3v 1379.495n 3.3v 1379.505n 3.3v 1389.495n 3.3v 1389.505n 3.3v 1399.495n 3.3v 1399.505n 3.3v 1409.495n 3.3v 1409.505n 3.3v 1419.495n 3.3v 1419.505n 3.3v 1429.495n 3.3v 1429.505n 3.3v 1439.495n 3.3v 1439.505n 0.0v 1449.495n 0.0v 1449.505n 0.0v 1459.495n 0.0v 1459.505n 0.0v 1469.495n 0.0v 1469.505n 0.0v 1479.495n 0.0v 1479.505n 0.0v 1489.495n 0.0v 1489.505n 3.3v 1499.495n 3.3v 1499.505n 3.3v 1509.495n 3.3v 1509.505n 3.3v 1519.495n 3.3v 1519.505n 3.3v 1529.495n 3.3v 1529.505n 3.3v 1539.495n 3.3v 1539.505n 3.3v 1549.495n 3.3v 1549.505n 0.0v 1559.495n 0.0v 1559.505n 0.0v 1569.495n 0.0v 1569.505n 0.0v 1579.495n 0.0v 1579.505n 0.0v 1589.495n 0.0v 1589.505n 0.0v 1599.495n 0.0v 1599.505n 3.3v 1609.495n 3.3v 1609.505n 3.3v 1619.495n 3.3v 1619.505n 3.3v 1629.495n 3.3v 1629.505n 3.3v 1639.495n 3.3v 1639.505n 3.3v 1649.495n 3.3v 1649.505n 3.3v 1659.495n 3.3v 1659.505n 3.3v 1669.495n 3.3v 1669.505n 3.3v 1679.495n 3.3v 1679.505n 3.3v 1689.495n 3.3v 1689.505n 3.3v 1699.495n 3.3v 1699.505n 3.3v 1709.495n 3.3v 1709.505n 3.3v 1719.495n 3.3v 1719.505n 3.3v 1729.495n 3.3v 1729.505n 0.0v 1739.495n 0.0v 1739.505n 0.0v 1749.495n 0.0v 1749.505n 3.3v 1759.495n 3.3v 1759.505n 3.3v 1769.495n 3.3v 1769.505n 3.3v 1779.495n 3.3v 1779.505n 3.3v 1789.495n 3.3v 1789.505n 3.3v 1799.495n 3.3v 1799.505n 3.3v 1809.495n 3.3v 1809.505n 3.3v 1819.495n 3.3v 1819.505n 0.0v 1829.495n 0.0v 1829.505n 0.0v 1839.495n 0.0v 1839.505n 0.0v 1849.495n 0.0v 1849.505n 0.0v 1859.495n 0.0v 1859.505n 3.3v 1869.495n 3.3v 1869.505n 3.3v 1879.495n 3.3v 1879.505n 0.0v 1889.495n 0.0v 1889.505n 0.0v 1899.495n 0.0v 1899.505n 0.0v 1909.495n 0.0v 1909.505n 0.0v 1919.495n 0.0v 1919.505n 0.0v 1929.495n 0.0v 1929.505n 0.0v 1939.495n 0.0v 1939.505n 3.3v 1949.495n 3.3v 1949.505n 3.3v 1959.495n 3.3v 1959.505n 3.3v 1969.495n 3.3v 1969.505n 3.3v 1979.495n 3.3v 1979.505n 3.3v 1989.495n 3.3v 1989.505n 3.3v 1999.495n 3.3v 1999.505n 3.3v 2009.495n 3.3v 2009.505n 3.3v 2019.495n 3.3v 2019.505n 3.3v 2029.495n 3.3v 2029.505n 3.3v 2039.495n 3.3v 2039.505n 3.3v 2049.495n 3.3v 2049.505n 3.3v )
* (time, data): [(0, 0), (10, 1), (20, 0), (30, 0), (40, 0), (50, 0), (60, 0), (70, 0), (80, 1), (90, 1), (100, 1), (110, 1), (120, 0), (130, 0), (140, 0), (150, 0), (160, 0), (170, 0), (180, 0), (190, 0), (200, 0), (210, 0), (220, 0), (230, 0), (240, 0), (250, 0), (260, 0), (270, 0), (280, 0), (290, 0), (300, 0), (310, 0), (320, 0), (330, 0), (340, 0), (350, 0), (360, 0), (370, 0), (380, 0), (390, 0), (400, 1), (410, 1), (420, 1), (430, 1), (440, 1), (450, 1), (460, 1), (470, 1), (480, 1), (490, 1), (500, 1), (510, 1), (520, 1), (530, 1), (540, 1), (550, 1), (560, 1), (570, 1), (580, 1), (590, 1), (600, 1), (610, 1), (620, 1), (630, 1), (640, 1), (650, 1), (660, 0), (670, 0), (680, 1), (690, 1), (700, 1), (710, 0), (720, 0), (730, 0), (740, 0), (750, 0), (760, 0), (770, 0), (780, 0), (790, 0), (800, 0), (810, 0), (820, 0), (830, 0), (840, 0), (850, 0), (860, 0), (870, 1), (880, 1), (890, 1), (900, 1), (910, 1), (920, 1), (930, 1), (940, 0), (950, 0), (960, 0), (970, 0), (980, 0), (990, 0), (1000, 0), (1010, 0), (1020, 0), (1030, 0), (1040, 0), (1050, 1), (1060, 1), (1070, 1), (1080, 1), (1090, 1), (1100, 0), (1110, 1), (1120, 1), (1130, 1), (1140, 0), (1150, 0), (1160, 0), (1170, 0), (1180, 0), (1190, 0), (1200, 0), (1210, 1), (1220, 1), (1230, 1), (1240, 1), (1250, 1), (1260, 1), (1270, 1), (1280, 1), (1290, 1), (1300, 1), (1310, 1), (1320, 1), (1330, 1), (1340, 1), (1350, 1), (1360, 1), (1370, 1), (1380, 1), (1390, 1), (1400, 1), (1410, 1), (1420, 1), (1430, 1), (1440, 0), (1450, 0), (1460, 0), (1470, 0), (1480, 0), (1490, 1), (1500, 1), (1510, 1), (1520, 1), (1530, 1), (1540, 1), (1550, 0), (1560, 0), (1570, 0), (1580, 0), (1590, 0), (1600, 1), (1610, 1), (1620, 1), (1630, 1), (1640, 1), (1650, 1), (1660, 1), (1670, 1), (1680, 1), (1690, 1), (1700, 1), (1710, 1), (1720, 1), (1730, 1), (1740, 1), (1750, 0), (1760, 0), (1770, 0), (1780, 0), (1790, 0), (1800, 0), (1810, 0), (1820, 1), (1830, 1), (1840, 1), (1850, 1), (1860, 0), (1870, 0), (1880, 1), (1890, 1), (1900, 1), (1910, 1), (1920, 1), (1930, 1), (1940, 1), (1950, 1), (1960, 1), (1970, 1), (1980, 0), (1990, 0), (2000, 0), (2010, 0), (2020, 0), (2030, 1), (2040, 1), (2050, 1)]
Vdin1_31  din1_31  0 PWL (0n 0.0v 9.495n 0.0v 9.505n 3.3v 19.495n 3.3v 19.505n 0.0v 29.495n 0.0v 29.505n 0.0v 39.495n 0.0v 39.505n 0.0v 49.495n 0.0v 49.505n 0.0v 59.495n 0.0v 59.505n 0.0v 69.495n 0.0v 69.505n 0.0v 79.495n 0.0v 79.505n 3.3v 89.495n 3.3v 89.505n 3.3v 99.495n 3.3v 99.505n 3.3v 109.495n 3.3v 109.505n 3.3v 119.495n 3.3v 119.505n 0.0v 129.495n 0.0v 129.505n 0.0v 139.495n 0.0v 139.505n 0.0v 149.495n 0.0v 149.505n 0.0v 159.495n 0.0v 159.505n 0.0v 169.495n 0.0v 169.505n 0.0v 179.495n 0.0v 179.505n 0.0v 189.495n 0.0v 189.505n 0.0v 199.495n 0.0v 199.505n 0.0v 209.495n 0.0v 209.505n 0.0v 219.495n 0.0v 219.505n 0.0v 229.495n 0.0v 229.505n 0.0v 239.495n 0.0v 239.505n 0.0v 249.495n 0.0v 249.505n 0.0v 259.495n 0.0v 259.505n 0.0v 269.495n 0.0v 269.505n 0.0v 279.495n 0.0v 279.505n 0.0v 289.495n 0.0v 289.505n 0.0v 299.495n 0.0v 299.505n 0.0v 309.495n 0.0v 309.505n 0.0v 319.495n 0.0v 319.505n 0.0v 329.495n 0.0v 329.505n 0.0v 339.495n 0.0v 339.505n 0.0v 349.495n 0.0v 349.505n 0.0v 359.495n 0.0v 359.505n 0.0v 369.495n 0.0v 369.505n 0.0v 379.495n 0.0v 379.505n 0.0v 389.495n 0.0v 389.505n 0.0v 399.495n 0.0v 399.505n 3.3v 409.495n 3.3v 409.505n 3.3v 419.495n 3.3v 419.505n 3.3v 429.495n 3.3v 429.505n 3.3v 439.495n 3.3v 439.505n 3.3v 449.495n 3.3v 449.505n 3.3v 459.495n 3.3v 459.505n 3.3v 469.495n 3.3v 469.505n 3.3v 479.495n 3.3v 479.505n 3.3v 489.495n 3.3v 489.505n 3.3v 499.495n 3.3v 499.505n 3.3v 509.495n 3.3v 509.505n 3.3v 519.495n 3.3v 519.505n 3.3v 529.495n 3.3v 529.505n 3.3v 539.495n 3.3v 539.505n 3.3v 549.495n 3.3v 549.505n 3.3v 559.495n 3.3v 559.505n 3.3v 569.495n 3.3v 569.505n 3.3v 579.495n 3.3v 579.505n 3.3v 589.495n 3.3v 589.505n 3.3v 599.495n 3.3v 599.505n 3.3v 609.495n 3.3v 609.505n 3.3v 619.495n 3.3v 619.505n 3.3v 629.495n 3.3v 629.505n 3.3v 639.495n 3.3v 639.505n 3.3v 649.495n 3.3v 649.505n 3.3v 659.495n 3.3v 659.505n 0.0v 669.495n 0.0v 669.505n 0.0v 679.495n 0.0v 679.505n 3.3v 689.495n 3.3v 689.505n 3.3v 699.495n 3.3v 699.505n 3.3v 709.495n 3.3v 709.505n 0.0v 719.495n 0.0v 719.505n 0.0v 729.495n 0.0v 729.505n 0.0v 739.495n 0.0v 739.505n 0.0v 749.495n 0.0v 749.505n 0.0v 759.495n 0.0v 759.505n 0.0v 769.495n 0.0v 769.505n 0.0v 779.495n 0.0v 779.505n 0.0v 789.495n 0.0v 789.505n 0.0v 799.495n 0.0v 799.505n 0.0v 809.495n 0.0v 809.505n 0.0v 819.495n 0.0v 819.505n 0.0v 829.495n 0.0v 829.505n 0.0v 839.495n 0.0v 839.505n 0.0v 849.495n 0.0v 849.505n 0.0v 859.495n 0.0v 859.505n 0.0v 869.495n 0.0v 869.505n 3.3v 879.495n 3.3v 879.505n 3.3v 889.495n 3.3v 889.505n 3.3v 899.495n 3.3v 899.505n 3.3v 909.495n 3.3v 909.505n 3.3v 919.495n 3.3v 919.505n 3.3v 929.495n 3.3v 929.505n 3.3v 939.495n 3.3v 939.505n 0.0v 949.495n 0.0v 949.505n 0.0v 959.495n 0.0v 959.505n 0.0v 969.495n 0.0v 969.505n 0.0v 979.495n 0.0v 979.505n 0.0v 989.495n 0.0v 989.505n 0.0v 999.495n 0.0v 999.505n 0.0v 1009.495n 0.0v 1009.505n 0.0v 1019.495n 0.0v 1019.505n 0.0v 1029.495n 0.0v 1029.505n 0.0v 1039.495n 0.0v 1039.505n 0.0v 1049.495n 0.0v 1049.505n 3.3v 1059.495n 3.3v 1059.505n 3.3v 1069.495n 3.3v 1069.505n 3.3v 1079.495n 3.3v 1079.505n 3.3v 1089.495n 3.3v 1089.505n 3.3v 1099.495n 3.3v 1099.505n 0.0v 1109.495n 0.0v 1109.505n 3.3v 1119.495n 3.3v 1119.505n 3.3v 1129.495n 3.3v 1129.505n 3.3v 1139.495n 3.3v 1139.505n 0.0v 1149.495n 0.0v 1149.505n 0.0v 1159.495n 0.0v 1159.505n 0.0v 1169.495n 0.0v 1169.505n 0.0v 1179.495n 0.0v 1179.505n 0.0v 1189.495n 0.0v 1189.505n 0.0v 1199.495n 0.0v 1199.505n 0.0v 1209.495n 0.0v 1209.505n 3.3v 1219.495n 3.3v 1219.505n 3.3v 1229.495n 3.3v 1229.505n 3.3v 1239.495n 3.3v 1239.505n 3.3v 1249.495n 3.3v 1249.505n 3.3v 1259.495n 3.3v 1259.505n 3.3v 1269.495n 3.3v 1269.505n 3.3v 1279.495n 3.3v 1279.505n 3.3v 1289.495n 3.3v 1289.505n 3.3v 1299.495n 3.3v 1299.505n 3.3v 1309.495n 3.3v 1309.505n 3.3v 1319.495n 3.3v 1319.505n 3.3v 1329.495n 3.3v 1329.505n 3.3v 1339.495n 3.3v 1339.505n 3.3v 1349.495n 3.3v 1349.505n 3.3v 1359.495n 3.3v 1359.505n 3.3v 1369.495n 3.3v 1369.505n 3.3v 1379.495n 3.3v 1379.505n 3.3v 1389.495n 3.3v 1389.505n 3.3v 1399.495n 3.3v 1399.505n 3.3v 1409.495n 3.3v 1409.505n 3.3v 1419.495n 3.3v 1419.505n 3.3v 1429.495n 3.3v 1429.505n 3.3v 1439.495n 3.3v 1439.505n 0.0v 1449.495n 0.0v 1449.505n 0.0v 1459.495n 0.0v 1459.505n 0.0v 1469.495n 0.0v 1469.505n 0.0v 1479.495n 0.0v 1479.505n 0.0v 1489.495n 0.0v 1489.505n 3.3v 1499.495n 3.3v 1499.505n 3.3v 1509.495n 3.3v 1509.505n 3.3v 1519.495n 3.3v 1519.505n 3.3v 1529.495n 3.3v 1529.505n 3.3v 1539.495n 3.3v 1539.505n 3.3v 1549.495n 3.3v 1549.505n 0.0v 1559.495n 0.0v 1559.505n 0.0v 1569.495n 0.0v 1569.505n 0.0v 1579.495n 0.0v 1579.505n 0.0v 1589.495n 0.0v 1589.505n 0.0v 1599.495n 0.0v 1599.505n 3.3v 1609.495n 3.3v 1609.505n 3.3v 1619.495n 3.3v 1619.505n 3.3v 1629.495n 3.3v 1629.505n 3.3v 1639.495n 3.3v 1639.505n 3.3v 1649.495n 3.3v 1649.505n 3.3v 1659.495n 3.3v 1659.505n 3.3v 1669.495n 3.3v 1669.505n 3.3v 1679.495n 3.3v 1679.505n 3.3v 1689.495n 3.3v 1689.505n 3.3v 1699.495n 3.3v 1699.505n 3.3v 1709.495n 3.3v 1709.505n 3.3v 1719.495n 3.3v 1719.505n 3.3v 1729.495n 3.3v 1729.505n 3.3v 1739.495n 3.3v 1739.505n 3.3v 1749.495n 3.3v 1749.505n 0.0v 1759.495n 0.0v 1759.505n 0.0v 1769.495n 0.0v 1769.505n 0.0v 1779.495n 0.0v 1779.505n 0.0v 1789.495n 0.0v 1789.505n 0.0v 1799.495n 0.0v 1799.505n 0.0v 1809.495n 0.0v 1809.505n 0.0v 1819.495n 0.0v 1819.505n 3.3v 1829.495n 3.3v 1829.505n 3.3v 1839.495n 3.3v 1839.505n 3.3v 1849.495n 3.3v 1849.505n 3.3v 1859.495n 3.3v 1859.505n 0.0v 1869.495n 0.0v 1869.505n 0.0v 1879.495n 0.0v 1879.505n 3.3v 1889.495n 3.3v 1889.505n 3.3v 1899.495n 3.3v 1899.505n 3.3v 1909.495n 3.3v 1909.505n 3.3v 1919.495n 3.3v 1919.505n 3.3v 1929.495n 3.3v 1929.505n 3.3v 1939.495n 3.3v 1939.505n 3.3v 1949.495n 3.3v 1949.505n 3.3v 1959.495n 3.3v 1959.505n 3.3v 1969.495n 3.3v 1969.505n 3.3v 1979.495n 3.3v 1979.505n 0.0v 1989.495n 0.0v 1989.505n 0.0v 1999.495n 0.0v 1999.505n 0.0v 2009.495n 0.0v 2009.505n 0.0v 2019.495n 0.0v 2019.505n 0.0v 2029.495n 0.0v 2029.505n 3.3v 2039.495n 3.3v 2039.505n 3.3v 2049.495n 3.3v 2049.505n 3.3v )
* (time, data): [(0, 0), (10, 0), (20, 0), (30, 0), (40, 0), (50, 0), (60, 0), (70, 0), (80, 0), (90, 0), (100, 0), (110, 0), (120, 0), (130, 0), (140, 0), (150, 0), (160, 0), (170, 0), (180, 0), (190, 0), (200, 0), (210, 0), (220, 0), (230, 0), (240, 0), (250, 0), (260, 0), (270, 0), (280, 0), (290, 0), (300, 0), (310, 0), (320, 0), (330, 0), (340, 0), (350, 0), (360, 0), (370, 0), (380, 0), (390, 0), (400, 0), (410, 0), (420, 0), (430, 0), (440, 0), (450, 0), (460, 0), (470, 0), (480, 0), (490, 0), (500, 0), (510, 0), (520, 0), (530, 0), (540, 0), (550, 0), (560, 0), (570, 0), (580, 0), (590, 0), (600, 0), (610, 0), (620, 0), (630, 0), (640, 0), (650, 0), (660, 0), (670, 0), (680, 0), (690, 0), (700, 0), (710, 0), (720, 0), (730, 0), (740, 0), (750, 0), (760, 0), (770, 0), (780, 0), (790, 0), (800, 0), (810, 0), (820, 0), (830, 0), (840, 0), (850, 0), (860, 0), (870, 0), (880, 0), (890, 0), (900, 0), (910, 0), (920, 0), (930, 0), (940, 0), (950, 0), (960, 0), (970, 0), (980, 0), (990, 0), (1000, 0), (1010, 0), (1020, 0), (1030, 0), (1040, 0), (1050, 0), (1060, 0), (1070, 0), (1080, 0), (1090, 0), (1100, 0), (1110, 0), (1120, 0), (1130, 0), (1140, 0), (1150, 0), (1160, 0), (1170, 0), (1180, 0), (1190, 0), (1200, 0), (1210, 0), (1220, 0), (1230, 0), (1240, 0), (1250, 0), (1260, 0), (1270, 0), (1280, 0), (1290, 0), (1300, 0), (1310, 0), (1320, 0), (1330, 0), (1340, 0), (1350, 0), (1360, 0), (1370, 0), (1380, 0), (1390, 0), (1400, 0), (1410, 0), (1420, 0), (1430, 0), (1440, 0), (1450, 0), (1460, 0), (1470, 0), (1480, 0), (1490, 0), (1500, 0), (1510, 0), (1520, 0), (1530, 0), (1540, 0), (1550, 0), (1560, 0), (1570, 0), (1580, 0), (1590, 0), (1600, 0), (1610, 0), (1620, 0), (1630, 0), (1640, 0), (1650, 0), (1660, 0), (1670, 0), (1680, 0), (1690, 0), (1700, 0), (1710, 0), (1720, 0), (1730, 0), (1740, 0), (1750, 0), (1760, 0), (1770, 0), (1780, 0), (1790, 0), (1800, 0), (1810, 0), (1820, 0), (1830, 0), (1840, 0), (1850, 0), (1860, 0), (1870, 0), (1880, 0), (1890, 0), (1900, 0), (1910, 0), (1920, 0), (1930, 0), (1940, 0), (1950, 0), (1960, 0), (1970, 0), (1980, 0), (1990, 0), (2000, 0), (2010, 0), (2020, 0), (2030, 0), (2040, 0), (2050, 0)]
Va0_0  a0_0  0 PWL (0n 0.0v 9.495n 0.0v 9.505n 0.0v 19.495n 0.0v 19.505n 0.0v 29.495n 0.0v 29.505n 0.0v 39.495n 0.0v 39.505n 0.0v 49.495n 0.0v 49.505n 0.0v 59.495n 0.0v 59.505n 0.0v 69.495n 0.0v 69.505n 0.0v 79.495n 0.0v 79.505n 0.0v 89.495n 0.0v 89.505n 0.0v 99.495n 0.0v 99.505n 0.0v 109.495n 0.0v 109.505n 0.0v 119.495n 0.0v 119.505n 0.0v 129.495n 0.0v 129.505n 0.0v 139.495n 0.0v 139.505n 0.0v 149.495n 0.0v 149.505n 0.0v 159.495n 0.0v 159.505n 0.0v 169.495n 0.0v 169.505n 0.0v 179.495n 0.0v 179.505n 0.0v 189.495n 0.0v 189.505n 0.0v 199.495n 0.0v 199.505n 0.0v 209.495n 0.0v 209.505n 0.0v 219.495n 0.0v 219.505n 0.0v 229.495n 0.0v 229.505n 0.0v 239.495n 0.0v 239.505n 0.0v 249.495n 0.0v 249.505n 0.0v 259.495n 0.0v 259.505n 0.0v 269.495n 0.0v 269.505n 0.0v 279.495n 0.0v 279.505n 0.0v 289.495n 0.0v 289.505n 0.0v 299.495n 0.0v 299.505n 0.0v 309.495n 0.0v 309.505n 0.0v 319.495n 0.0v 319.505n 0.0v 329.495n 0.0v 329.505n 0.0v 339.495n 0.0v 339.505n 0.0v 349.495n 0.0v 349.505n 0.0v 359.495n 0.0v 359.505n 0.0v 369.495n 0.0v 369.505n 0.0v 379.495n 0.0v 379.505n 0.0v 389.495n 0.0v 389.505n 0.0v 399.495n 0.0v 399.505n 0.0v 409.495n 0.0v 409.505n 0.0v 419.495n 0.0v 419.505n 0.0v 429.495n 0.0v 429.505n 0.0v 439.495n 0.0v 439.505n 0.0v 449.495n 0.0v 449.505n 0.0v 459.495n 0.0v 459.505n 0.0v 469.495n 0.0v 469.505n 0.0v 479.495n 0.0v 479.505n 0.0v 489.495n 0.0v 489.505n 0.0v 499.495n 0.0v 499.505n 0.0v 509.495n 0.0v 509.505n 0.0v 519.495n 0.0v 519.505n 0.0v 529.495n 0.0v 529.505n 0.0v 539.495n 0.0v 539.505n 0.0v 549.495n 0.0v 549.505n 0.0v 559.495n 0.0v 559.505n 0.0v 569.495n 0.0v 569.505n 0.0v 579.495n 0.0v 579.505n 0.0v 589.495n 0.0v 589.505n 0.0v 599.495n 0.0v 599.505n 0.0v 609.495n 0.0v 609.505n 0.0v 619.495n 0.0v 619.505n 0.0v 629.495n 0.0v 629.505n 0.0v 639.495n 0.0v 639.505n 0.0v 649.495n 0.0v 649.505n 0.0v 659.495n 0.0v 659.505n 0.0v 669.495n 0.0v 669.505n 0.0v 679.495n 0.0v 679.505n 0.0v 689.495n 0.0v 689.505n 0.0v 699.495n 0.0v 699.505n 0.0v 709.495n 0.0v 709.505n 0.0v 719.495n 0.0v 719.505n 0.0v 729.495n 0.0v 729.505n 0.0v 739.495n 0.0v 739.505n 0.0v 749.495n 0.0v 749.505n 0.0v 759.495n 0.0v 759.505n 0.0v 769.495n 0.0v 769.505n 0.0v 779.495n 0.0v 779.505n 0.0v 789.495n 0.0v 789.505n 0.0v 799.495n 0.0v 799.505n 0.0v 809.495n 0.0v 809.505n 0.0v 819.495n 0.0v 819.505n 0.0v 829.495n 0.0v 829.505n 0.0v 839.495n 0.0v 839.505n 0.0v 849.495n 0.0v 849.505n 0.0v 859.495n 0.0v 859.505n 0.0v 869.495n 0.0v 869.505n 0.0v 879.495n 0.0v 879.505n 0.0v 889.495n 0.0v 889.505n 0.0v 899.495n 0.0v 899.505n 0.0v 909.495n 0.0v 909.505n 0.0v 919.495n 0.0v 919.505n 0.0v 929.495n 0.0v 929.505n 0.0v 939.495n 0.0v 939.505n 0.0v 949.495n 0.0v 949.505n 0.0v 959.495n 0.0v 959.505n 0.0v 969.495n 0.0v 969.505n 0.0v 979.495n 0.0v 979.505n 0.0v 989.495n 0.0v 989.505n 0.0v 999.495n 0.0v 999.505n 0.0v 1009.495n 0.0v 1009.505n 0.0v 1019.495n 0.0v 1019.505n 0.0v 1029.495n 0.0v 1029.505n 0.0v 1039.495n 0.0v 1039.505n 0.0v 1049.495n 0.0v 1049.505n 0.0v 1059.495n 0.0v 1059.505n 0.0v 1069.495n 0.0v 1069.505n 0.0v 1079.495n 0.0v 1079.505n 0.0v 1089.495n 0.0v 1089.505n 0.0v 1099.495n 0.0v 1099.505n 0.0v 1109.495n 0.0v 1109.505n 0.0v 1119.495n 0.0v 1119.505n 0.0v 1129.495n 0.0v 1129.505n 0.0v 1139.495n 0.0v 1139.505n 0.0v 1149.495n 0.0v 1149.505n 0.0v 1159.495n 0.0v 1159.505n 0.0v 1169.495n 0.0v 1169.505n 0.0v 1179.495n 0.0v 1179.505n 0.0v 1189.495n 0.0v 1189.505n 0.0v 1199.495n 0.0v 1199.505n 0.0v 1209.495n 0.0v 1209.505n 0.0v 1219.495n 0.0v 1219.505n 0.0v 1229.495n 0.0v 1229.505n 0.0v 1239.495n 0.0v 1239.505n 0.0v 1249.495n 0.0v 1249.505n 0.0v 1259.495n 0.0v 1259.505n 0.0v 1269.495n 0.0v 1269.505n 0.0v 1279.495n 0.0v 1279.505n 0.0v 1289.495n 0.0v 1289.505n 0.0v 1299.495n 0.0v 1299.505n 0.0v 1309.495n 0.0v 1309.505n 0.0v 1319.495n 0.0v 1319.505n 0.0v 1329.495n 0.0v 1329.505n 0.0v 1339.495n 0.0v 1339.505n 0.0v 1349.495n 0.0v 1349.505n 0.0v 1359.495n 0.0v 1359.505n 0.0v 1369.495n 0.0v 1369.505n 0.0v 1379.495n 0.0v 1379.505n 0.0v 1389.495n 0.0v 1389.505n 0.0v 1399.495n 0.0v 1399.505n 0.0v 1409.495n 0.0v 1409.505n 0.0v 1419.495n 0.0v 1419.505n 0.0v 1429.495n 0.0v 1429.505n 0.0v 1439.495n 0.0v 1439.505n 0.0v 1449.495n 0.0v 1449.505n 0.0v 1459.495n 0.0v 1459.505n 0.0v 1469.495n 0.0v 1469.505n 0.0v 1479.495n 0.0v 1479.505n 0.0v 1489.495n 0.0v 1489.505n 0.0v 1499.495n 0.0v 1499.505n 0.0v 1509.495n 0.0v 1509.505n 0.0v 1519.495n 0.0v 1519.505n 0.0v 1529.495n 0.0v 1529.505n 0.0v 1539.495n 0.0v 1539.505n 0.0v 1549.495n 0.0v 1549.505n 0.0v 1559.495n 0.0v 1559.505n 0.0v 1569.495n 0.0v 1569.505n 0.0v 1579.495n 0.0v 1579.505n 0.0v 1589.495n 0.0v 1589.505n 0.0v 1599.495n 0.0v 1599.505n 0.0v 1609.495n 0.0v 1609.505n 0.0v 1619.495n 0.0v 1619.505n 0.0v 1629.495n 0.0v 1629.505n 0.0v 1639.495n 0.0v 1639.505n 0.0v 1649.495n 0.0v 1649.505n 0.0v 1659.495n 0.0v 1659.505n 0.0v 1669.495n 0.0v 1669.505n 0.0v 1679.495n 0.0v 1679.505n 0.0v 1689.495n 0.0v 1689.505n 0.0v 1699.495n 0.0v 1699.505n 0.0v 1709.495n 0.0v 1709.505n 0.0v 1719.495n 0.0v 1719.505n 0.0v 1729.495n 0.0v 1729.505n 0.0v 1739.495n 0.0v 1739.505n 0.0v 1749.495n 0.0v 1749.505n 0.0v 1759.495n 0.0v 1759.505n 0.0v 1769.495n 0.0v 1769.505n 0.0v 1779.495n 0.0v 1779.505n 0.0v 1789.495n 0.0v 1789.505n 0.0v 1799.495n 0.0v 1799.505n 0.0v 1809.495n 0.0v 1809.505n 0.0v 1819.495n 0.0v 1819.505n 0.0v 1829.495n 0.0v 1829.505n 0.0v 1839.495n 0.0v 1839.505n 0.0v 1849.495n 0.0v 1849.505n 0.0v 1859.495n 0.0v 1859.505n 0.0v 1869.495n 0.0v 1869.505n 0.0v 1879.495n 0.0v 1879.505n 0.0v 1889.495n 0.0v 1889.505n 0.0v 1899.495n 0.0v 1899.505n 0.0v 1909.495n 0.0v 1909.505n 0.0v 1919.495n 0.0v 1919.505n 0.0v 1929.495n 0.0v 1929.505n 0.0v 1939.495n 0.0v 1939.505n 0.0v 1949.495n 0.0v 1949.505n 0.0v 1959.495n 0.0v 1959.505n 0.0v 1969.495n 0.0v 1969.505n 0.0v 1979.495n 0.0v 1979.505n 0.0v 1989.495n 0.0v 1989.505n 0.0v 1999.495n 0.0v 1999.505n 0.0v 2009.495n 0.0v 2009.505n 0.0v 2019.495n 0.0v 2019.505n 0.0v 2029.495n 0.0v 2029.505n 0.0v 2039.495n 0.0v 2039.505n 0.0v 2049.495n 0.0v 2049.505n 0.0v )
* (time, data): [(0, 0), (10, 1), (20, 1), (30, 1), (40, 0), (50, 0), (60, 0), (70, 0), (80, 0), (90, 1), (100, 0), (110, 1), (120, 1), (130, 1), (140, 1), (150, 0), (160, 1), (170, 1), (180, 0), (190, 1), (200, 0), (210, 0), (220, 1), (230, 1), (240, 1), (250, 0), (260, 0), (270, 1), (280, 1), (290, 0), (300, 0), (310, 1), (320, 0), (330, 1), (340, 1), (350, 0), (360, 0), (370, 0), (380, 1), (390, 0), (400, 1), (410, 1), (420, 1), (430, 1), (440, 0), (450, 0), (460, 0), (470, 0), (480, 0), (490, 0), (500, 1), (510, 1), (520, 1), (530, 0), (540, 0), (550, 0), (560, 1), (570, 1), (580, 0), (590, 0), (600, 1), (610, 0), (620, 0), (630, 1), (640, 1), (650, 1), (660, 0), (670, 1), (680, 1), (690, 1), (700, 1), (710, 0), (720, 0), (730, 0), (740, 0), (750, 1), (760, 0), (770, 0), (780, 1), (790, 0), (800, 0), (810, 0), (820, 0), (830, 0), (840, 1), (850, 0), (860, 1), (870, 0), (880, 0), (890, 0), (900, 0), (910, 0), (920, 0), (930, 0), (940, 0), (950, 0), (960, 1), (970, 0), (980, 0), (990, 1), (1000, 1), (1010, 1), (1020, 1), (1030, 0), (1040, 1), (1050, 1), (1060, 1), (1070, 1), (1080, 1), (1090, 1), (1100, 1), (1110, 0), (1120, 0), (1130, 0), (1140, 0), (1150, 0), (1160, 1), (1170, 0), (1180, 0), (1190, 0), (1200, 0), (1210, 0), (1220, 0), (1230, 1), (1240, 0), (1250, 0), (1260, 0), (1270, 0), (1280, 1), (1290, 0), (1300, 0), (1310, 0), (1320, 0), (1330, 1), (1340, 1), (1350, 0), (1360, 1), (1370, 0), (1380, 0), (1390, 0), (1400, 0), (1410, 0), (1420, 1), (1430, 1), (1440, 1), (1450, 0), (1460, 0), (1470, 1), (1480, 1), (1490, 1), (1500, 1), (1510, 1), (1520, 1), (1530, 1), (1540, 0), (1550, 1), (1560, 0), (1570, 0), (1580, 1), (1590, 1), (1600, 0), (1610, 1), (1620, 1), (1630, 0), (1640, 0), (1650, 0), (1660, 1), (1670, 1), (1680, 0), (1690, 0), (1700, 0), (1710, 0), (1720, 0), (1730, 0), (1740, 1), (1750, 1), (1760, 1), (1770, 1), (1780, 1), (1790, 0), (1800, 1), (1810, 1), (1820, 0), (1830, 0), (1840, 0), (1850, 0), (1860, 1), (1870, 1), (1880, 0), (1890, 0), (1900, 1), (1910, 1), (1920, 1), (1930, 1), (1940, 1), (1950, 1), (1960, 1), (1970, 1), (1980, 0), (1990, 0), (2000, 0), (2010, 1), (2020, 0), (2030, 1), (2040, 0), (2050, 0)]
Va0_1  a0_1  0 PWL (0n 0.0v 9.495n 0.0v 9.505n 3.3v 19.495n 3.3v 19.505n 3.3v 29.495n 3.3v 29.505n 3.3v 39.495n 3.3v 39.505n 0.0v 49.495n 0.0v 49.505n 0.0v 59.495n 0.0v 59.505n 0.0v 69.495n 0.0v 69.505n 0.0v 79.495n 0.0v 79.505n 0.0v 89.495n 0.0v 89.505n 3.3v 99.495n 3.3v 99.505n 0.0v 109.495n 0.0v 109.505n 3.3v 119.495n 3.3v 119.505n 3.3v 129.495n 3.3v 129.505n 3.3v 139.495n 3.3v 139.505n 3.3v 149.495n 3.3v 149.505n 0.0v 159.495n 0.0v 159.505n 3.3v 169.495n 3.3v 169.505n 3.3v 179.495n 3.3v 179.505n 0.0v 189.495n 0.0v 189.505n 3.3v 199.495n 3.3v 199.505n 0.0v 209.495n 0.0v 209.505n 0.0v 219.495n 0.0v 219.505n 3.3v 229.495n 3.3v 229.505n 3.3v 239.495n 3.3v 239.505n 3.3v 249.495n 3.3v 249.505n 0.0v 259.495n 0.0v 259.505n 0.0v 269.495n 0.0v 269.505n 3.3v 279.495n 3.3v 279.505n 3.3v 289.495n 3.3v 289.505n 0.0v 299.495n 0.0v 299.505n 0.0v 309.495n 0.0v 309.505n 3.3v 319.495n 3.3v 319.505n 0.0v 329.495n 0.0v 329.505n 3.3v 339.495n 3.3v 339.505n 3.3v 349.495n 3.3v 349.505n 0.0v 359.495n 0.0v 359.505n 0.0v 369.495n 0.0v 369.505n 0.0v 379.495n 0.0v 379.505n 3.3v 389.495n 3.3v 389.505n 0.0v 399.495n 0.0v 399.505n 3.3v 409.495n 3.3v 409.505n 3.3v 419.495n 3.3v 419.505n 3.3v 429.495n 3.3v 429.505n 3.3v 439.495n 3.3v 439.505n 0.0v 449.495n 0.0v 449.505n 0.0v 459.495n 0.0v 459.505n 0.0v 469.495n 0.0v 469.505n 0.0v 479.495n 0.0v 479.505n 0.0v 489.495n 0.0v 489.505n 0.0v 499.495n 0.0v 499.505n 3.3v 509.495n 3.3v 509.505n 3.3v 519.495n 3.3v 519.505n 3.3v 529.495n 3.3v 529.505n 0.0v 539.495n 0.0v 539.505n 0.0v 549.495n 0.0v 549.505n 0.0v 559.495n 0.0v 559.505n 3.3v 569.495n 3.3v 569.505n 3.3v 579.495n 3.3v 579.505n 0.0v 589.495n 0.0v 589.505n 0.0v 599.495n 0.0v 599.505n 3.3v 609.495n 3.3v 609.505n 0.0v 619.495n 0.0v 619.505n 0.0v 629.495n 0.0v 629.505n 3.3v 639.495n 3.3v 639.505n 3.3v 649.495n 3.3v 649.505n 3.3v 659.495n 3.3v 659.505n 0.0v 669.495n 0.0v 669.505n 3.3v 679.495n 3.3v 679.505n 3.3v 689.495n 3.3v 689.505n 3.3v 699.495n 3.3v 699.505n 3.3v 709.495n 3.3v 709.505n 0.0v 719.495n 0.0v 719.505n 0.0v 729.495n 0.0v 729.505n 0.0v 739.495n 0.0v 739.505n 0.0v 749.495n 0.0v 749.505n 3.3v 759.495n 3.3v 759.505n 0.0v 769.495n 0.0v 769.505n 0.0v 779.495n 0.0v 779.505n 3.3v 789.495n 3.3v 789.505n 0.0v 799.495n 0.0v 799.505n 0.0v 809.495n 0.0v 809.505n 0.0v 819.495n 0.0v 819.505n 0.0v 829.495n 0.0v 829.505n 0.0v 839.495n 0.0v 839.505n 3.3v 849.495n 3.3v 849.505n 0.0v 859.495n 0.0v 859.505n 3.3v 869.495n 3.3v 869.505n 0.0v 879.495n 0.0v 879.505n 0.0v 889.495n 0.0v 889.505n 0.0v 899.495n 0.0v 899.505n 0.0v 909.495n 0.0v 909.505n 0.0v 919.495n 0.0v 919.505n 0.0v 929.495n 0.0v 929.505n 0.0v 939.495n 0.0v 939.505n 0.0v 949.495n 0.0v 949.505n 0.0v 959.495n 0.0v 959.505n 3.3v 969.495n 3.3v 969.505n 0.0v 979.495n 0.0v 979.505n 0.0v 989.495n 0.0v 989.505n 3.3v 999.495n 3.3v 999.505n 3.3v 1009.495n 3.3v 1009.505n 3.3v 1019.495n 3.3v 1019.505n 3.3v 1029.495n 3.3v 1029.505n 0.0v 1039.495n 0.0v 1039.505n 3.3v 1049.495n 3.3v 1049.505n 3.3v 1059.495n 3.3v 1059.505n 3.3v 1069.495n 3.3v 1069.505n 3.3v 1079.495n 3.3v 1079.505n 3.3v 1089.495n 3.3v 1089.505n 3.3v 1099.495n 3.3v 1099.505n 3.3v 1109.495n 3.3v 1109.505n 0.0v 1119.495n 0.0v 1119.505n 0.0v 1129.495n 0.0v 1129.505n 0.0v 1139.495n 0.0v 1139.505n 0.0v 1149.495n 0.0v 1149.505n 0.0v 1159.495n 0.0v 1159.505n 3.3v 1169.495n 3.3v 1169.505n 0.0v 1179.495n 0.0v 1179.505n 0.0v 1189.495n 0.0v 1189.505n 0.0v 1199.495n 0.0v 1199.505n 0.0v 1209.495n 0.0v 1209.505n 0.0v 1219.495n 0.0v 1219.505n 0.0v 1229.495n 0.0v 1229.505n 3.3v 1239.495n 3.3v 1239.505n 0.0v 1249.495n 0.0v 1249.505n 0.0v 1259.495n 0.0v 1259.505n 0.0v 1269.495n 0.0v 1269.505n 0.0v 1279.495n 0.0v 1279.505n 3.3v 1289.495n 3.3v 1289.505n 0.0v 1299.495n 0.0v 1299.505n 0.0v 1309.495n 0.0v 1309.505n 0.0v 1319.495n 0.0v 1319.505n 0.0v 1329.495n 0.0v 1329.505n 3.3v 1339.495n 3.3v 1339.505n 3.3v 1349.495n 3.3v 1349.505n 0.0v 1359.495n 0.0v 1359.505n 3.3v 1369.495n 3.3v 1369.505n 0.0v 1379.495n 0.0v 1379.505n 0.0v 1389.495n 0.0v 1389.505n 0.0v 1399.495n 0.0v 1399.505n 0.0v 1409.495n 0.0v 1409.505n 0.0v 1419.495n 0.0v 1419.505n 3.3v 1429.495n 3.3v 1429.505n 3.3v 1439.495n 3.3v 1439.505n 3.3v 1449.495n 3.3v 1449.505n 0.0v 1459.495n 0.0v 1459.505n 0.0v 1469.495n 0.0v 1469.505n 3.3v 1479.495n 3.3v 1479.505n 3.3v 1489.495n 3.3v 1489.505n 3.3v 1499.495n 3.3v 1499.505n 3.3v 1509.495n 3.3v 1509.505n 3.3v 1519.495n 3.3v 1519.505n 3.3v 1529.495n 3.3v 1529.505n 3.3v 1539.495n 3.3v 1539.505n 0.0v 1549.495n 0.0v 1549.505n 3.3v 1559.495n 3.3v 1559.505n 0.0v 1569.495n 0.0v 1569.505n 0.0v 1579.495n 0.0v 1579.505n 3.3v 1589.495n 3.3v 1589.505n 3.3v 1599.495n 3.3v 1599.505n 0.0v 1609.495n 0.0v 1609.505n 3.3v 1619.495n 3.3v 1619.505n 3.3v 1629.495n 3.3v 1629.505n 0.0v 1639.495n 0.0v 1639.505n 0.0v 1649.495n 0.0v 1649.505n 0.0v 1659.495n 0.0v 1659.505n 3.3v 1669.495n 3.3v 1669.505n 3.3v 1679.495n 3.3v 1679.505n 0.0v 1689.495n 0.0v 1689.505n 0.0v 1699.495n 0.0v 1699.505n 0.0v 1709.495n 0.0v 1709.505n 0.0v 1719.495n 0.0v 1719.505n 0.0v 1729.495n 0.0v 1729.505n 0.0v 1739.495n 0.0v 1739.505n 3.3v 1749.495n 3.3v 1749.505n 3.3v 1759.495n 3.3v 1759.505n 3.3v 1769.495n 3.3v 1769.505n 3.3v 1779.495n 3.3v 1779.505n 3.3v 1789.495n 3.3v 1789.505n 0.0v 1799.495n 0.0v 1799.505n 3.3v 1809.495n 3.3v 1809.505n 3.3v 1819.495n 3.3v 1819.505n 0.0v 1829.495n 0.0v 1829.505n 0.0v 1839.495n 0.0v 1839.505n 0.0v 1849.495n 0.0v 1849.505n 0.0v 1859.495n 0.0v 1859.505n 3.3v 1869.495n 3.3v 1869.505n 3.3v 1879.495n 3.3v 1879.505n 0.0v 1889.495n 0.0v 1889.505n 0.0v 1899.495n 0.0v 1899.505n 3.3v 1909.495n 3.3v 1909.505n 3.3v 1919.495n 3.3v 1919.505n 3.3v 1929.495n 3.3v 1929.505n 3.3v 1939.495n 3.3v 1939.505n 3.3v 1949.495n 3.3v 1949.505n 3.3v 1959.495n 3.3v 1959.505n 3.3v 1969.495n 3.3v 1969.505n 3.3v 1979.495n 3.3v 1979.505n 0.0v 1989.495n 0.0v 1989.505n 0.0v 1999.495n 0.0v 1999.505n 0.0v 2009.495n 0.0v 2009.505n 3.3v 2019.495n 3.3v 2019.505n 0.0v 2029.495n 0.0v 2029.505n 3.3v 2039.495n 3.3v 2039.505n 0.0v 2049.495n 0.0v 2049.505n 0.0v )
* (time, data): [(0, 0), (10, 1), (20, 1), (30, 1), (40, 0), (50, 0), (60, 0), (70, 0), (80, 0), (90, 1), (100, 0), (110, 1), (120, 1), (130, 1), (140, 1), (150, 0), (160, 1), (170, 1), (180, 0), (190, 1), (200, 0), (210, 0), (220, 1), (230, 1), (240, 1), (250, 0), (260, 0), (270, 1), (280, 1), (290, 0), (300, 0), (310, 1), (320, 0), (330, 1), (340, 1), (350, 0), (360, 0), (370, 0), (380, 1), (390, 0), (400, 1), (410, 1), (420, 1), (430, 1), (440, 0), (450, 0), (460, 0), (470, 0), (480, 0), (490, 0), (500, 1), (510, 1), (520, 1), (530, 0), (540, 0), (550, 0), (560, 1), (570, 1), (580, 0), (590, 0), (600, 1), (610, 0), (620, 0), (630, 1), (640, 1), (650, 1), (660, 0), (670, 1), (680, 1), (690, 1), (700, 1), (710, 0), (720, 0), (730, 0), (740, 0), (750, 1), (760, 0), (770, 0), (780, 1), (790, 0), (800, 0), (810, 0), (820, 0), (830, 0), (840, 1), (850, 0), (860, 1), (870, 0), (880, 0), (890, 0), (900, 0), (910, 0), (920, 0), (930, 0), (940, 0), (950, 0), (960, 1), (970, 0), (980, 0), (990, 1), (1000, 1), (1010, 1), (1020, 1), (1030, 0), (1040, 1), (1050, 1), (1060, 1), (1070, 1), (1080, 1), (1090, 1), (1100, 1), (1110, 0), (1120, 0), (1130, 0), (1140, 0), (1150, 0), (1160, 1), (1170, 0), (1180, 0), (1190, 0), (1200, 0), (1210, 0), (1220, 0), (1230, 1), (1240, 0), (1250, 0), (1260, 0), (1270, 0), (1280, 1), (1290, 0), (1300, 0), (1310, 0), (1320, 0), (1330, 1), (1340, 1), (1350, 0), (1360, 1), (1370, 0), (1380, 0), (1390, 0), (1400, 0), (1410, 0), (1420, 1), (1430, 1), (1440, 1), (1450, 0), (1460, 0), (1470, 1), (1480, 1), (1490, 1), (1500, 1), (1510, 1), (1520, 1), (1530, 1), (1540, 0), (1550, 1), (1560, 0), (1570, 0), (1580, 1), (1590, 1), (1600, 0), (1610, 1), (1620, 1), (1630, 0), (1640, 0), (1650, 0), (1660, 1), (1670, 1), (1680, 0), (1690, 0), (1700, 0), (1710, 0), (1720, 0), (1730, 0), (1740, 1), (1750, 1), (1760, 1), (1770, 1), (1780, 1), (1790, 0), (1800, 1), (1810, 1), (1820, 0), (1830, 0), (1840, 0), (1850, 0), (1860, 1), (1870, 1), (1880, 0), (1890, 0), (1900, 1), (1910, 1), (1920, 1), (1930, 1), (1940, 1), (1950, 1), (1960, 1), (1970, 1), (1980, 0), (1990, 0), (2000, 0), (2010, 1), (2020, 0), (2030, 1), (2040, 0), (2050, 0)]
Va0_2  a0_2  0 PWL (0n 0.0v 9.495n 0.0v 9.505n 3.3v 19.495n 3.3v 19.505n 3.3v 29.495n 3.3v 29.505n 3.3v 39.495n 3.3v 39.505n 0.0v 49.495n 0.0v 49.505n 0.0v 59.495n 0.0v 59.505n 0.0v 69.495n 0.0v 69.505n 0.0v 79.495n 0.0v 79.505n 0.0v 89.495n 0.0v 89.505n 3.3v 99.495n 3.3v 99.505n 0.0v 109.495n 0.0v 109.505n 3.3v 119.495n 3.3v 119.505n 3.3v 129.495n 3.3v 129.505n 3.3v 139.495n 3.3v 139.505n 3.3v 149.495n 3.3v 149.505n 0.0v 159.495n 0.0v 159.505n 3.3v 169.495n 3.3v 169.505n 3.3v 179.495n 3.3v 179.505n 0.0v 189.495n 0.0v 189.505n 3.3v 199.495n 3.3v 199.505n 0.0v 209.495n 0.0v 209.505n 0.0v 219.495n 0.0v 219.505n 3.3v 229.495n 3.3v 229.505n 3.3v 239.495n 3.3v 239.505n 3.3v 249.495n 3.3v 249.505n 0.0v 259.495n 0.0v 259.505n 0.0v 269.495n 0.0v 269.505n 3.3v 279.495n 3.3v 279.505n 3.3v 289.495n 3.3v 289.505n 0.0v 299.495n 0.0v 299.505n 0.0v 309.495n 0.0v 309.505n 3.3v 319.495n 3.3v 319.505n 0.0v 329.495n 0.0v 329.505n 3.3v 339.495n 3.3v 339.505n 3.3v 349.495n 3.3v 349.505n 0.0v 359.495n 0.0v 359.505n 0.0v 369.495n 0.0v 369.505n 0.0v 379.495n 0.0v 379.505n 3.3v 389.495n 3.3v 389.505n 0.0v 399.495n 0.0v 399.505n 3.3v 409.495n 3.3v 409.505n 3.3v 419.495n 3.3v 419.505n 3.3v 429.495n 3.3v 429.505n 3.3v 439.495n 3.3v 439.505n 0.0v 449.495n 0.0v 449.505n 0.0v 459.495n 0.0v 459.505n 0.0v 469.495n 0.0v 469.505n 0.0v 479.495n 0.0v 479.505n 0.0v 489.495n 0.0v 489.505n 0.0v 499.495n 0.0v 499.505n 3.3v 509.495n 3.3v 509.505n 3.3v 519.495n 3.3v 519.505n 3.3v 529.495n 3.3v 529.505n 0.0v 539.495n 0.0v 539.505n 0.0v 549.495n 0.0v 549.505n 0.0v 559.495n 0.0v 559.505n 3.3v 569.495n 3.3v 569.505n 3.3v 579.495n 3.3v 579.505n 0.0v 589.495n 0.0v 589.505n 0.0v 599.495n 0.0v 599.505n 3.3v 609.495n 3.3v 609.505n 0.0v 619.495n 0.0v 619.505n 0.0v 629.495n 0.0v 629.505n 3.3v 639.495n 3.3v 639.505n 3.3v 649.495n 3.3v 649.505n 3.3v 659.495n 3.3v 659.505n 0.0v 669.495n 0.0v 669.505n 3.3v 679.495n 3.3v 679.505n 3.3v 689.495n 3.3v 689.505n 3.3v 699.495n 3.3v 699.505n 3.3v 709.495n 3.3v 709.505n 0.0v 719.495n 0.0v 719.505n 0.0v 729.495n 0.0v 729.505n 0.0v 739.495n 0.0v 739.505n 0.0v 749.495n 0.0v 749.505n 3.3v 759.495n 3.3v 759.505n 0.0v 769.495n 0.0v 769.505n 0.0v 779.495n 0.0v 779.505n 3.3v 789.495n 3.3v 789.505n 0.0v 799.495n 0.0v 799.505n 0.0v 809.495n 0.0v 809.505n 0.0v 819.495n 0.0v 819.505n 0.0v 829.495n 0.0v 829.505n 0.0v 839.495n 0.0v 839.505n 3.3v 849.495n 3.3v 849.505n 0.0v 859.495n 0.0v 859.505n 3.3v 869.495n 3.3v 869.505n 0.0v 879.495n 0.0v 879.505n 0.0v 889.495n 0.0v 889.505n 0.0v 899.495n 0.0v 899.505n 0.0v 909.495n 0.0v 909.505n 0.0v 919.495n 0.0v 919.505n 0.0v 929.495n 0.0v 929.505n 0.0v 939.495n 0.0v 939.505n 0.0v 949.495n 0.0v 949.505n 0.0v 959.495n 0.0v 959.505n 3.3v 969.495n 3.3v 969.505n 0.0v 979.495n 0.0v 979.505n 0.0v 989.495n 0.0v 989.505n 3.3v 999.495n 3.3v 999.505n 3.3v 1009.495n 3.3v 1009.505n 3.3v 1019.495n 3.3v 1019.505n 3.3v 1029.495n 3.3v 1029.505n 0.0v 1039.495n 0.0v 1039.505n 3.3v 1049.495n 3.3v 1049.505n 3.3v 1059.495n 3.3v 1059.505n 3.3v 1069.495n 3.3v 1069.505n 3.3v 1079.495n 3.3v 1079.505n 3.3v 1089.495n 3.3v 1089.505n 3.3v 1099.495n 3.3v 1099.505n 3.3v 1109.495n 3.3v 1109.505n 0.0v 1119.495n 0.0v 1119.505n 0.0v 1129.495n 0.0v 1129.505n 0.0v 1139.495n 0.0v 1139.505n 0.0v 1149.495n 0.0v 1149.505n 0.0v 1159.495n 0.0v 1159.505n 3.3v 1169.495n 3.3v 1169.505n 0.0v 1179.495n 0.0v 1179.505n 0.0v 1189.495n 0.0v 1189.505n 0.0v 1199.495n 0.0v 1199.505n 0.0v 1209.495n 0.0v 1209.505n 0.0v 1219.495n 0.0v 1219.505n 0.0v 1229.495n 0.0v 1229.505n 3.3v 1239.495n 3.3v 1239.505n 0.0v 1249.495n 0.0v 1249.505n 0.0v 1259.495n 0.0v 1259.505n 0.0v 1269.495n 0.0v 1269.505n 0.0v 1279.495n 0.0v 1279.505n 3.3v 1289.495n 3.3v 1289.505n 0.0v 1299.495n 0.0v 1299.505n 0.0v 1309.495n 0.0v 1309.505n 0.0v 1319.495n 0.0v 1319.505n 0.0v 1329.495n 0.0v 1329.505n 3.3v 1339.495n 3.3v 1339.505n 3.3v 1349.495n 3.3v 1349.505n 0.0v 1359.495n 0.0v 1359.505n 3.3v 1369.495n 3.3v 1369.505n 0.0v 1379.495n 0.0v 1379.505n 0.0v 1389.495n 0.0v 1389.505n 0.0v 1399.495n 0.0v 1399.505n 0.0v 1409.495n 0.0v 1409.505n 0.0v 1419.495n 0.0v 1419.505n 3.3v 1429.495n 3.3v 1429.505n 3.3v 1439.495n 3.3v 1439.505n 3.3v 1449.495n 3.3v 1449.505n 0.0v 1459.495n 0.0v 1459.505n 0.0v 1469.495n 0.0v 1469.505n 3.3v 1479.495n 3.3v 1479.505n 3.3v 1489.495n 3.3v 1489.505n 3.3v 1499.495n 3.3v 1499.505n 3.3v 1509.495n 3.3v 1509.505n 3.3v 1519.495n 3.3v 1519.505n 3.3v 1529.495n 3.3v 1529.505n 3.3v 1539.495n 3.3v 1539.505n 0.0v 1549.495n 0.0v 1549.505n 3.3v 1559.495n 3.3v 1559.505n 0.0v 1569.495n 0.0v 1569.505n 0.0v 1579.495n 0.0v 1579.505n 3.3v 1589.495n 3.3v 1589.505n 3.3v 1599.495n 3.3v 1599.505n 0.0v 1609.495n 0.0v 1609.505n 3.3v 1619.495n 3.3v 1619.505n 3.3v 1629.495n 3.3v 1629.505n 0.0v 1639.495n 0.0v 1639.505n 0.0v 1649.495n 0.0v 1649.505n 0.0v 1659.495n 0.0v 1659.505n 3.3v 1669.495n 3.3v 1669.505n 3.3v 1679.495n 3.3v 1679.505n 0.0v 1689.495n 0.0v 1689.505n 0.0v 1699.495n 0.0v 1699.505n 0.0v 1709.495n 0.0v 1709.505n 0.0v 1719.495n 0.0v 1719.505n 0.0v 1729.495n 0.0v 1729.505n 0.0v 1739.495n 0.0v 1739.505n 3.3v 1749.495n 3.3v 1749.505n 3.3v 1759.495n 3.3v 1759.505n 3.3v 1769.495n 3.3v 1769.505n 3.3v 1779.495n 3.3v 1779.505n 3.3v 1789.495n 3.3v 1789.505n 0.0v 1799.495n 0.0v 1799.505n 3.3v 1809.495n 3.3v 1809.505n 3.3v 1819.495n 3.3v 1819.505n 0.0v 1829.495n 0.0v 1829.505n 0.0v 1839.495n 0.0v 1839.505n 0.0v 1849.495n 0.0v 1849.505n 0.0v 1859.495n 0.0v 1859.505n 3.3v 1869.495n 3.3v 1869.505n 3.3v 1879.495n 3.3v 1879.505n 0.0v 1889.495n 0.0v 1889.505n 0.0v 1899.495n 0.0v 1899.505n 3.3v 1909.495n 3.3v 1909.505n 3.3v 1919.495n 3.3v 1919.505n 3.3v 1929.495n 3.3v 1929.505n 3.3v 1939.495n 3.3v 1939.505n 3.3v 1949.495n 3.3v 1949.505n 3.3v 1959.495n 3.3v 1959.505n 3.3v 1969.495n 3.3v 1969.505n 3.3v 1979.495n 3.3v 1979.505n 0.0v 1989.495n 0.0v 1989.505n 0.0v 1999.495n 0.0v 1999.505n 0.0v 2009.495n 0.0v 2009.505n 3.3v 2019.495n 3.3v 2019.505n 0.0v 2029.495n 0.0v 2029.505n 3.3v 2039.495n 3.3v 2039.505n 0.0v 2049.495n 0.0v 2049.505n 0.0v )
* (time, data): [(0, 0), (10, 1), (20, 1), (30, 1), (40, 0), (50, 0), (60, 0), (70, 0), (80, 0), (90, 1), (100, 0), (110, 1), (120, 1), (130, 1), (140, 1), (150, 0), (160, 1), (170, 1), (180, 0), (190, 1), (200, 0), (210, 0), (220, 1), (230, 1), (240, 1), (250, 0), (260, 0), (270, 1), (280, 1), (290, 0), (300, 0), (310, 1), (320, 0), (330, 1), (340, 1), (350, 0), (360, 0), (370, 0), (380, 1), (390, 0), (400, 1), (410, 1), (420, 1), (430, 1), (440, 0), (450, 0), (460, 0), (470, 0), (480, 0), (490, 0), (500, 1), (510, 1), (520, 1), (530, 0), (540, 0), (550, 0), (560, 1), (570, 1), (580, 0), (590, 0), (600, 1), (610, 0), (620, 0), (630, 1), (640, 1), (650, 1), (660, 0), (670, 1), (680, 1), (690, 1), (700, 1), (710, 0), (720, 0), (730, 0), (740, 0), (750, 1), (760, 0), (770, 0), (780, 1), (790, 0), (800, 0), (810, 0), (820, 0), (830, 0), (840, 1), (850, 0), (860, 1), (870, 0), (880, 0), (890, 0), (900, 0), (910, 0), (920, 0), (930, 0), (940, 0), (950, 0), (960, 1), (970, 0), (980, 0), (990, 1), (1000, 1), (1010, 1), (1020, 1), (1030, 0), (1040, 1), (1050, 1), (1060, 1), (1070, 1), (1080, 1), (1090, 1), (1100, 1), (1110, 0), (1120, 0), (1130, 0), (1140, 0), (1150, 0), (1160, 1), (1170, 0), (1180, 0), (1190, 0), (1200, 0), (1210, 0), (1220, 0), (1230, 1), (1240, 0), (1250, 0), (1260, 0), (1270, 0), (1280, 1), (1290, 0), (1300, 0), (1310, 0), (1320, 0), (1330, 1), (1340, 1), (1350, 0), (1360, 1), (1370, 0), (1380, 0), (1390, 0), (1400, 0), (1410, 0), (1420, 1), (1430, 1), (1440, 1), (1450, 0), (1460, 0), (1470, 1), (1480, 1), (1490, 1), (1500, 1), (1510, 1), (1520, 1), (1530, 1), (1540, 0), (1550, 1), (1560, 0), (1570, 0), (1580, 1), (1590, 1), (1600, 0), (1610, 1), (1620, 1), (1630, 0), (1640, 0), (1650, 0), (1660, 1), (1670, 1), (1680, 0), (1690, 0), (1700, 0), (1710, 0), (1720, 0), (1730, 0), (1740, 1), (1750, 1), (1760, 1), (1770, 1), (1780, 1), (1790, 0), (1800, 1), (1810, 1), (1820, 0), (1830, 0), (1840, 0), (1850, 0), (1860, 1), (1870, 1), (1880, 0), (1890, 0), (1900, 1), (1910, 1), (1920, 1), (1930, 1), (1940, 1), (1950, 1), (1960, 1), (1970, 1), (1980, 0), (1990, 0), (2000, 0), (2010, 1), (2020, 0), (2030, 1), (2040, 0), (2050, 0)]
Va0_3  a0_3  0 PWL (0n 0.0v 9.495n 0.0v 9.505n 3.3v 19.495n 3.3v 19.505n 3.3v 29.495n 3.3v 29.505n 3.3v 39.495n 3.3v 39.505n 0.0v 49.495n 0.0v 49.505n 0.0v 59.495n 0.0v 59.505n 0.0v 69.495n 0.0v 69.505n 0.0v 79.495n 0.0v 79.505n 0.0v 89.495n 0.0v 89.505n 3.3v 99.495n 3.3v 99.505n 0.0v 109.495n 0.0v 109.505n 3.3v 119.495n 3.3v 119.505n 3.3v 129.495n 3.3v 129.505n 3.3v 139.495n 3.3v 139.505n 3.3v 149.495n 3.3v 149.505n 0.0v 159.495n 0.0v 159.505n 3.3v 169.495n 3.3v 169.505n 3.3v 179.495n 3.3v 179.505n 0.0v 189.495n 0.0v 189.505n 3.3v 199.495n 3.3v 199.505n 0.0v 209.495n 0.0v 209.505n 0.0v 219.495n 0.0v 219.505n 3.3v 229.495n 3.3v 229.505n 3.3v 239.495n 3.3v 239.505n 3.3v 249.495n 3.3v 249.505n 0.0v 259.495n 0.0v 259.505n 0.0v 269.495n 0.0v 269.505n 3.3v 279.495n 3.3v 279.505n 3.3v 289.495n 3.3v 289.505n 0.0v 299.495n 0.0v 299.505n 0.0v 309.495n 0.0v 309.505n 3.3v 319.495n 3.3v 319.505n 0.0v 329.495n 0.0v 329.505n 3.3v 339.495n 3.3v 339.505n 3.3v 349.495n 3.3v 349.505n 0.0v 359.495n 0.0v 359.505n 0.0v 369.495n 0.0v 369.505n 0.0v 379.495n 0.0v 379.505n 3.3v 389.495n 3.3v 389.505n 0.0v 399.495n 0.0v 399.505n 3.3v 409.495n 3.3v 409.505n 3.3v 419.495n 3.3v 419.505n 3.3v 429.495n 3.3v 429.505n 3.3v 439.495n 3.3v 439.505n 0.0v 449.495n 0.0v 449.505n 0.0v 459.495n 0.0v 459.505n 0.0v 469.495n 0.0v 469.505n 0.0v 479.495n 0.0v 479.505n 0.0v 489.495n 0.0v 489.505n 0.0v 499.495n 0.0v 499.505n 3.3v 509.495n 3.3v 509.505n 3.3v 519.495n 3.3v 519.505n 3.3v 529.495n 3.3v 529.505n 0.0v 539.495n 0.0v 539.505n 0.0v 549.495n 0.0v 549.505n 0.0v 559.495n 0.0v 559.505n 3.3v 569.495n 3.3v 569.505n 3.3v 579.495n 3.3v 579.505n 0.0v 589.495n 0.0v 589.505n 0.0v 599.495n 0.0v 599.505n 3.3v 609.495n 3.3v 609.505n 0.0v 619.495n 0.0v 619.505n 0.0v 629.495n 0.0v 629.505n 3.3v 639.495n 3.3v 639.505n 3.3v 649.495n 3.3v 649.505n 3.3v 659.495n 3.3v 659.505n 0.0v 669.495n 0.0v 669.505n 3.3v 679.495n 3.3v 679.505n 3.3v 689.495n 3.3v 689.505n 3.3v 699.495n 3.3v 699.505n 3.3v 709.495n 3.3v 709.505n 0.0v 719.495n 0.0v 719.505n 0.0v 729.495n 0.0v 729.505n 0.0v 739.495n 0.0v 739.505n 0.0v 749.495n 0.0v 749.505n 3.3v 759.495n 3.3v 759.505n 0.0v 769.495n 0.0v 769.505n 0.0v 779.495n 0.0v 779.505n 3.3v 789.495n 3.3v 789.505n 0.0v 799.495n 0.0v 799.505n 0.0v 809.495n 0.0v 809.505n 0.0v 819.495n 0.0v 819.505n 0.0v 829.495n 0.0v 829.505n 0.0v 839.495n 0.0v 839.505n 3.3v 849.495n 3.3v 849.505n 0.0v 859.495n 0.0v 859.505n 3.3v 869.495n 3.3v 869.505n 0.0v 879.495n 0.0v 879.505n 0.0v 889.495n 0.0v 889.505n 0.0v 899.495n 0.0v 899.505n 0.0v 909.495n 0.0v 909.505n 0.0v 919.495n 0.0v 919.505n 0.0v 929.495n 0.0v 929.505n 0.0v 939.495n 0.0v 939.505n 0.0v 949.495n 0.0v 949.505n 0.0v 959.495n 0.0v 959.505n 3.3v 969.495n 3.3v 969.505n 0.0v 979.495n 0.0v 979.505n 0.0v 989.495n 0.0v 989.505n 3.3v 999.495n 3.3v 999.505n 3.3v 1009.495n 3.3v 1009.505n 3.3v 1019.495n 3.3v 1019.505n 3.3v 1029.495n 3.3v 1029.505n 0.0v 1039.495n 0.0v 1039.505n 3.3v 1049.495n 3.3v 1049.505n 3.3v 1059.495n 3.3v 1059.505n 3.3v 1069.495n 3.3v 1069.505n 3.3v 1079.495n 3.3v 1079.505n 3.3v 1089.495n 3.3v 1089.505n 3.3v 1099.495n 3.3v 1099.505n 3.3v 1109.495n 3.3v 1109.505n 0.0v 1119.495n 0.0v 1119.505n 0.0v 1129.495n 0.0v 1129.505n 0.0v 1139.495n 0.0v 1139.505n 0.0v 1149.495n 0.0v 1149.505n 0.0v 1159.495n 0.0v 1159.505n 3.3v 1169.495n 3.3v 1169.505n 0.0v 1179.495n 0.0v 1179.505n 0.0v 1189.495n 0.0v 1189.505n 0.0v 1199.495n 0.0v 1199.505n 0.0v 1209.495n 0.0v 1209.505n 0.0v 1219.495n 0.0v 1219.505n 0.0v 1229.495n 0.0v 1229.505n 3.3v 1239.495n 3.3v 1239.505n 0.0v 1249.495n 0.0v 1249.505n 0.0v 1259.495n 0.0v 1259.505n 0.0v 1269.495n 0.0v 1269.505n 0.0v 1279.495n 0.0v 1279.505n 3.3v 1289.495n 3.3v 1289.505n 0.0v 1299.495n 0.0v 1299.505n 0.0v 1309.495n 0.0v 1309.505n 0.0v 1319.495n 0.0v 1319.505n 0.0v 1329.495n 0.0v 1329.505n 3.3v 1339.495n 3.3v 1339.505n 3.3v 1349.495n 3.3v 1349.505n 0.0v 1359.495n 0.0v 1359.505n 3.3v 1369.495n 3.3v 1369.505n 0.0v 1379.495n 0.0v 1379.505n 0.0v 1389.495n 0.0v 1389.505n 0.0v 1399.495n 0.0v 1399.505n 0.0v 1409.495n 0.0v 1409.505n 0.0v 1419.495n 0.0v 1419.505n 3.3v 1429.495n 3.3v 1429.505n 3.3v 1439.495n 3.3v 1439.505n 3.3v 1449.495n 3.3v 1449.505n 0.0v 1459.495n 0.0v 1459.505n 0.0v 1469.495n 0.0v 1469.505n 3.3v 1479.495n 3.3v 1479.505n 3.3v 1489.495n 3.3v 1489.505n 3.3v 1499.495n 3.3v 1499.505n 3.3v 1509.495n 3.3v 1509.505n 3.3v 1519.495n 3.3v 1519.505n 3.3v 1529.495n 3.3v 1529.505n 3.3v 1539.495n 3.3v 1539.505n 0.0v 1549.495n 0.0v 1549.505n 3.3v 1559.495n 3.3v 1559.505n 0.0v 1569.495n 0.0v 1569.505n 0.0v 1579.495n 0.0v 1579.505n 3.3v 1589.495n 3.3v 1589.505n 3.3v 1599.495n 3.3v 1599.505n 0.0v 1609.495n 0.0v 1609.505n 3.3v 1619.495n 3.3v 1619.505n 3.3v 1629.495n 3.3v 1629.505n 0.0v 1639.495n 0.0v 1639.505n 0.0v 1649.495n 0.0v 1649.505n 0.0v 1659.495n 0.0v 1659.505n 3.3v 1669.495n 3.3v 1669.505n 3.3v 1679.495n 3.3v 1679.505n 0.0v 1689.495n 0.0v 1689.505n 0.0v 1699.495n 0.0v 1699.505n 0.0v 1709.495n 0.0v 1709.505n 0.0v 1719.495n 0.0v 1719.505n 0.0v 1729.495n 0.0v 1729.505n 0.0v 1739.495n 0.0v 1739.505n 3.3v 1749.495n 3.3v 1749.505n 3.3v 1759.495n 3.3v 1759.505n 3.3v 1769.495n 3.3v 1769.505n 3.3v 1779.495n 3.3v 1779.505n 3.3v 1789.495n 3.3v 1789.505n 0.0v 1799.495n 0.0v 1799.505n 3.3v 1809.495n 3.3v 1809.505n 3.3v 1819.495n 3.3v 1819.505n 0.0v 1829.495n 0.0v 1829.505n 0.0v 1839.495n 0.0v 1839.505n 0.0v 1849.495n 0.0v 1849.505n 0.0v 1859.495n 0.0v 1859.505n 3.3v 1869.495n 3.3v 1869.505n 3.3v 1879.495n 3.3v 1879.505n 0.0v 1889.495n 0.0v 1889.505n 0.0v 1899.495n 0.0v 1899.505n 3.3v 1909.495n 3.3v 1909.505n 3.3v 1919.495n 3.3v 1919.505n 3.3v 1929.495n 3.3v 1929.505n 3.3v 1939.495n 3.3v 1939.505n 3.3v 1949.495n 3.3v 1949.505n 3.3v 1959.495n 3.3v 1959.505n 3.3v 1969.495n 3.3v 1969.505n 3.3v 1979.495n 3.3v 1979.505n 0.0v 1989.495n 0.0v 1989.505n 0.0v 1999.495n 0.0v 1999.505n 0.0v 2009.495n 0.0v 2009.505n 3.3v 2019.495n 3.3v 2019.505n 0.0v 2029.495n 0.0v 2029.505n 3.3v 2039.495n 3.3v 2039.505n 0.0v 2049.495n 0.0v 2049.505n 0.0v )
* (time, data): [(0, 0), (10, 0), (20, 0), (30, 0), (40, 0), (50, 0), (60, 0), (70, 0), (80, 0), (90, 0), (100, 0), (110, 0), (120, 0), (130, 0), (140, 0), (150, 0), (160, 0), (170, 0), (180, 0), (190, 0), (200, 0), (210, 0), (220, 0), (230, 0), (240, 0), (250, 0), (260, 0), (270, 0), (280, 0), (290, 0), (300, 0), (310, 0), (320, 0), (330, 0), (340, 0), (350, 0), (360, 0), (370, 0), (380, 0), (390, 0), (400, 0), (410, 0), (420, 0), (430, 0), (440, 0), (450, 0), (460, 0), (470, 0), (480, 0), (490, 0), (500, 0), (510, 0), (520, 0), (530, 0), (540, 0), (550, 0), (560, 0), (570, 0), (580, 0), (590, 0), (600, 0), (610, 0), (620, 0), (630, 0), (640, 0), (650, 0), (660, 0), (670, 0), (680, 0), (690, 0), (700, 0), (710, 0), (720, 0), (730, 0), (740, 0), (750, 0), (760, 0), (770, 0), (780, 0), (790, 0), (800, 0), (810, 0), (820, 0), (830, 0), (840, 0), (850, 0), (860, 0), (870, 0), (880, 0), (890, 0), (900, 0), (910, 0), (920, 0), (930, 0), (940, 0), (950, 0), (960, 0), (970, 0), (980, 0), (990, 0), (1000, 0), (1010, 0), (1020, 0), (1030, 0), (1040, 0), (1050, 0), (1060, 0), (1070, 0), (1080, 0), (1090, 0), (1100, 0), (1110, 0), (1120, 0), (1130, 0), (1140, 0), (1150, 0), (1160, 0), (1170, 0), (1180, 0), (1190, 0), (1200, 0), (1210, 0), (1220, 0), (1230, 0), (1240, 0), (1250, 0), (1260, 0), (1270, 0), (1280, 0), (1290, 0), (1300, 0), (1310, 0), (1320, 0), (1330, 0), (1340, 0), (1350, 0), (1360, 0), (1370, 0), (1380, 0), (1390, 0), (1400, 0), (1410, 0), (1420, 0), (1430, 0), (1440, 0), (1450, 0), (1460, 0), (1470, 0), (1480, 0), (1490, 0), (1500, 0), (1510, 0), (1520, 0), (1530, 0), (1540, 0), (1550, 0), (1560, 0), (1570, 0), (1580, 0), (1590, 0), (1600, 0), (1610, 0), (1620, 0), (1630, 0), (1640, 0), (1650, 0), (1660, 0), (1670, 0), (1680, 0), (1690, 0), (1700, 0), (1710, 0), (1720, 0), (1730, 0), (1740, 0), (1750, 0), (1760, 0), (1770, 0), (1780, 0), (1790, 0), (1800, 0), (1810, 0), (1820, 0), (1830, 0), (1840, 0), (1850, 0), (1860, 0), (1870, 0), (1880, 0), (1890, 0), (1900, 0), (1910, 0), (1920, 0), (1930, 0), (1940, 0), (1950, 0), (1960, 0), (1970, 0), (1980, 0), (1990, 0), (2000, 0), (2010, 0), (2020, 0), (2030, 0), (2040, 0), (2050, 0)]
Va1_0  a1_0  0 PWL (0n 0.0v 9.495n 0.0v 9.505n 0.0v 19.495n 0.0v 19.505n 0.0v 29.495n 0.0v 29.505n 0.0v 39.495n 0.0v 39.505n 0.0v 49.495n 0.0v 49.505n 0.0v 59.495n 0.0v 59.505n 0.0v 69.495n 0.0v 69.505n 0.0v 79.495n 0.0v 79.505n 0.0v 89.495n 0.0v 89.505n 0.0v 99.495n 0.0v 99.505n 0.0v 109.495n 0.0v 109.505n 0.0v 119.495n 0.0v 119.505n 0.0v 129.495n 0.0v 129.505n 0.0v 139.495n 0.0v 139.505n 0.0v 149.495n 0.0v 149.505n 0.0v 159.495n 0.0v 159.505n 0.0v 169.495n 0.0v 169.505n 0.0v 179.495n 0.0v 179.505n 0.0v 189.495n 0.0v 189.505n 0.0v 199.495n 0.0v 199.505n 0.0v 209.495n 0.0v 209.505n 0.0v 219.495n 0.0v 219.505n 0.0v 229.495n 0.0v 229.505n 0.0v 239.495n 0.0v 239.505n 0.0v 249.495n 0.0v 249.505n 0.0v 259.495n 0.0v 259.505n 0.0v 269.495n 0.0v 269.505n 0.0v 279.495n 0.0v 279.505n 0.0v 289.495n 0.0v 289.505n 0.0v 299.495n 0.0v 299.505n 0.0v 309.495n 0.0v 309.505n 0.0v 319.495n 0.0v 319.505n 0.0v 329.495n 0.0v 329.505n 0.0v 339.495n 0.0v 339.505n 0.0v 349.495n 0.0v 349.505n 0.0v 359.495n 0.0v 359.505n 0.0v 369.495n 0.0v 369.505n 0.0v 379.495n 0.0v 379.505n 0.0v 389.495n 0.0v 389.505n 0.0v 399.495n 0.0v 399.505n 0.0v 409.495n 0.0v 409.505n 0.0v 419.495n 0.0v 419.505n 0.0v 429.495n 0.0v 429.505n 0.0v 439.495n 0.0v 439.505n 0.0v 449.495n 0.0v 449.505n 0.0v 459.495n 0.0v 459.505n 0.0v 469.495n 0.0v 469.505n 0.0v 479.495n 0.0v 479.505n 0.0v 489.495n 0.0v 489.505n 0.0v 499.495n 0.0v 499.505n 0.0v 509.495n 0.0v 509.505n 0.0v 519.495n 0.0v 519.505n 0.0v 529.495n 0.0v 529.505n 0.0v 539.495n 0.0v 539.505n 0.0v 549.495n 0.0v 549.505n 0.0v 559.495n 0.0v 559.505n 0.0v 569.495n 0.0v 569.505n 0.0v 579.495n 0.0v 579.505n 0.0v 589.495n 0.0v 589.505n 0.0v 599.495n 0.0v 599.505n 0.0v 609.495n 0.0v 609.505n 0.0v 619.495n 0.0v 619.505n 0.0v 629.495n 0.0v 629.505n 0.0v 639.495n 0.0v 639.505n 0.0v 649.495n 0.0v 649.505n 0.0v 659.495n 0.0v 659.505n 0.0v 669.495n 0.0v 669.505n 0.0v 679.495n 0.0v 679.505n 0.0v 689.495n 0.0v 689.505n 0.0v 699.495n 0.0v 699.505n 0.0v 709.495n 0.0v 709.505n 0.0v 719.495n 0.0v 719.505n 0.0v 729.495n 0.0v 729.505n 0.0v 739.495n 0.0v 739.505n 0.0v 749.495n 0.0v 749.505n 0.0v 759.495n 0.0v 759.505n 0.0v 769.495n 0.0v 769.505n 0.0v 779.495n 0.0v 779.505n 0.0v 789.495n 0.0v 789.505n 0.0v 799.495n 0.0v 799.505n 0.0v 809.495n 0.0v 809.505n 0.0v 819.495n 0.0v 819.505n 0.0v 829.495n 0.0v 829.505n 0.0v 839.495n 0.0v 839.505n 0.0v 849.495n 0.0v 849.505n 0.0v 859.495n 0.0v 859.505n 0.0v 869.495n 0.0v 869.505n 0.0v 879.495n 0.0v 879.505n 0.0v 889.495n 0.0v 889.505n 0.0v 899.495n 0.0v 899.505n 0.0v 909.495n 0.0v 909.505n 0.0v 919.495n 0.0v 919.505n 0.0v 929.495n 0.0v 929.505n 0.0v 939.495n 0.0v 939.505n 0.0v 949.495n 0.0v 949.505n 0.0v 959.495n 0.0v 959.505n 0.0v 969.495n 0.0v 969.505n 0.0v 979.495n 0.0v 979.505n 0.0v 989.495n 0.0v 989.505n 0.0v 999.495n 0.0v 999.505n 0.0v 1009.495n 0.0v 1009.505n 0.0v 1019.495n 0.0v 1019.505n 0.0v 1029.495n 0.0v 1029.505n 0.0v 1039.495n 0.0v 1039.505n 0.0v 1049.495n 0.0v 1049.505n 0.0v 1059.495n 0.0v 1059.505n 0.0v 1069.495n 0.0v 1069.505n 0.0v 1079.495n 0.0v 1079.505n 0.0v 1089.495n 0.0v 1089.505n 0.0v 1099.495n 0.0v 1099.505n 0.0v 1109.495n 0.0v 1109.505n 0.0v 1119.495n 0.0v 1119.505n 0.0v 1129.495n 0.0v 1129.505n 0.0v 1139.495n 0.0v 1139.505n 0.0v 1149.495n 0.0v 1149.505n 0.0v 1159.495n 0.0v 1159.505n 0.0v 1169.495n 0.0v 1169.505n 0.0v 1179.495n 0.0v 1179.505n 0.0v 1189.495n 0.0v 1189.505n 0.0v 1199.495n 0.0v 1199.505n 0.0v 1209.495n 0.0v 1209.505n 0.0v 1219.495n 0.0v 1219.505n 0.0v 1229.495n 0.0v 1229.505n 0.0v 1239.495n 0.0v 1239.505n 0.0v 1249.495n 0.0v 1249.505n 0.0v 1259.495n 0.0v 1259.505n 0.0v 1269.495n 0.0v 1269.505n 0.0v 1279.495n 0.0v 1279.505n 0.0v 1289.495n 0.0v 1289.505n 0.0v 1299.495n 0.0v 1299.505n 0.0v 1309.495n 0.0v 1309.505n 0.0v 1319.495n 0.0v 1319.505n 0.0v 1329.495n 0.0v 1329.505n 0.0v 1339.495n 0.0v 1339.505n 0.0v 1349.495n 0.0v 1349.505n 0.0v 1359.495n 0.0v 1359.505n 0.0v 1369.495n 0.0v 1369.505n 0.0v 1379.495n 0.0v 1379.505n 0.0v 1389.495n 0.0v 1389.505n 0.0v 1399.495n 0.0v 1399.505n 0.0v 1409.495n 0.0v 1409.505n 0.0v 1419.495n 0.0v 1419.505n 0.0v 1429.495n 0.0v 1429.505n 0.0v 1439.495n 0.0v 1439.505n 0.0v 1449.495n 0.0v 1449.505n 0.0v 1459.495n 0.0v 1459.505n 0.0v 1469.495n 0.0v 1469.505n 0.0v 1479.495n 0.0v 1479.505n 0.0v 1489.495n 0.0v 1489.505n 0.0v 1499.495n 0.0v 1499.505n 0.0v 1509.495n 0.0v 1509.505n 0.0v 1519.495n 0.0v 1519.505n 0.0v 1529.495n 0.0v 1529.505n 0.0v 1539.495n 0.0v 1539.505n 0.0v 1549.495n 0.0v 1549.505n 0.0v 1559.495n 0.0v 1559.505n 0.0v 1569.495n 0.0v 1569.505n 0.0v 1579.495n 0.0v 1579.505n 0.0v 1589.495n 0.0v 1589.505n 0.0v 1599.495n 0.0v 1599.505n 0.0v 1609.495n 0.0v 1609.505n 0.0v 1619.495n 0.0v 1619.505n 0.0v 1629.495n 0.0v 1629.505n 0.0v 1639.495n 0.0v 1639.505n 0.0v 1649.495n 0.0v 1649.505n 0.0v 1659.495n 0.0v 1659.505n 0.0v 1669.495n 0.0v 1669.505n 0.0v 1679.495n 0.0v 1679.505n 0.0v 1689.495n 0.0v 1689.505n 0.0v 1699.495n 0.0v 1699.505n 0.0v 1709.495n 0.0v 1709.505n 0.0v 1719.495n 0.0v 1719.505n 0.0v 1729.495n 0.0v 1729.505n 0.0v 1739.495n 0.0v 1739.505n 0.0v 1749.495n 0.0v 1749.505n 0.0v 1759.495n 0.0v 1759.505n 0.0v 1769.495n 0.0v 1769.505n 0.0v 1779.495n 0.0v 1779.505n 0.0v 1789.495n 0.0v 1789.505n 0.0v 1799.495n 0.0v 1799.505n 0.0v 1809.495n 0.0v 1809.505n 0.0v 1819.495n 0.0v 1819.505n 0.0v 1829.495n 0.0v 1829.505n 0.0v 1839.495n 0.0v 1839.505n 0.0v 1849.495n 0.0v 1849.505n 0.0v 1859.495n 0.0v 1859.505n 0.0v 1869.495n 0.0v 1869.505n 0.0v 1879.495n 0.0v 1879.505n 0.0v 1889.495n 0.0v 1889.505n 0.0v 1899.495n 0.0v 1899.505n 0.0v 1909.495n 0.0v 1909.505n 0.0v 1919.495n 0.0v 1919.505n 0.0v 1929.495n 0.0v 1929.505n 0.0v 1939.495n 0.0v 1939.505n 0.0v 1949.495n 0.0v 1949.505n 0.0v 1959.495n 0.0v 1959.505n 0.0v 1969.495n 0.0v 1969.505n 0.0v 1979.495n 0.0v 1979.505n 0.0v 1989.495n 0.0v 1989.505n 0.0v 1999.495n 0.0v 1999.505n 0.0v 2009.495n 0.0v 2009.505n 0.0v 2019.495n 0.0v 2019.505n 0.0v 2029.495n 0.0v 2029.505n 0.0v 2039.495n 0.0v 2039.505n 0.0v 2049.495n 0.0v 2049.505n 0.0v )
* (time, data): [(0, 0), (10, 0), (20, 0), (30, 1), (40, 0), (50, 0), (60, 0), (70, 0), (80, 1), (90, 1), (100, 1), (110, 1), (120, 0), (130, 1), (140, 0), (150, 0), (160, 0), (170, 1), (180, 1), (190, 1), (200, 1), (210, 1), (220, 1), (230, 0), (240, 0), (250, 0), (260, 0), (270, 0), (280, 0), (290, 0), (300, 0), (310, 0), (320, 0), (330, 0), (340, 0), (350, 0), (360, 0), (370, 1), (380, 0), (390, 0), (400, 0), (410, 1), (420, 1), (430, 1), (440, 0), (450, 0), (460, 1), (470, 1), (480, 0), (490, 1), (500, 0), (510, 0), (520, 0), (530, 0), (540, 0), (550, 1), (560, 1), (570, 0), (580, 0), (590, 1), (600, 1), (610, 1), (620, 0), (630, 0), (640, 1), (650, 1), (660, 1), (670, 1), (680, 0), (690, 0), (700, 0), (710, 1), (720, 0), (730, 0), (740, 1), (750, 1), (760, 1), (770, 0), (780, 0), (790, 1), (800, 1), (810, 1), (820, 0), (830, 0), (840, 0), (850, 0), (860, 0), (870, 1), (880, 1), (890, 1), (900, 1), (910, 1), (920, 1), (930, 1), (940, 0), (950, 1), (960, 1), (970, 1), (980, 1), (990, 1), (1000, 1), (1010, 1), (1020, 1), (1030, 1), (1040, 0), (1050, 0), (1060, 0), (1070, 0), (1080, 1), (1090, 0), (1100, 1), (1110, 1), (1120, 1), (1130, 0), (1140, 1), (1150, 1), (1160, 1), (1170, 0), (1180, 0), (1190, 1), (1200, 0), (1210, 0), (1220, 0), (1230, 0), (1240, 0), (1250, 1), (1260, 1), (1270, 1), (1280, 1), (1290, 1), (1300, 1), (1310, 1), (1320, 1), (1330, 1), (1340, 0), (1350, 0), (1360, 0), (1370, 1), (1380, 1), (1390, 1), (1400, 1), (1410, 0), (1420, 1), (1430, 1), (1440, 0), (1450, 0), (1460, 0), (1470, 0), (1480, 0), (1490, 1), (1500, 1), (1510, 1), (1520, 1), (1530, 1), (1540, 0), (1550, 1), (1560, 0), (1570, 0), (1580, 0), (1590, 1), (1600, 0), (1610, 0), (1620, 0), (1630, 1), (1640, 1), (1650, 1), (1660, 1), (1670, 0), (1680, 0), (1690, 0), (1700, 0), (1710, 0), (1720, 1), (1730, 1), (1740, 1), (1750, 0), (1760, 1), (1770, 1), (1780, 1), (1790, 1), (1800, 0), (1810, 0), (1820, 1), (1830, 1), (1840, 1), (1850, 1), (1860, 1), (1870, 0), (1880, 1), (1890, 0), (1900, 0), (1910, 1), (1920, 1), (1930, 1), (1940, 0), (1950, 0), (1960, 0), (1970, 1), (1980, 1), (1990, 1), (2000, 1), (2010, 1), (2020, 1), (2030, 1), (2040, 1), (2050, 1)]
Va1_1  a1_1  0 PWL (0n 0.0v 9.495n 0.0v 9.505n 0.0v 19.495n 0.0v 19.505n 0.0v 29.495n 0.0v 29.505n 3.3v 39.495n 3.3v 39.505n 0.0v 49.495n 0.0v 49.505n 0.0v 59.495n 0.0v 59.505n 0.0v 69.495n 0.0v 69.505n 0.0v 79.495n 0.0v 79.505n 3.3v 89.495n 3.3v 89.505n 3.3v 99.495n 3.3v 99.505n 3.3v 109.495n 3.3v 109.505n 3.3v 119.495n 3.3v 119.505n 0.0v 129.495n 0.0v 129.505n 3.3v 139.495n 3.3v 139.505n 0.0v 149.495n 0.0v 149.505n 0.0v 159.495n 0.0v 159.505n 0.0v 169.495n 0.0v 169.505n 3.3v 179.495n 3.3v 179.505n 3.3v 189.495n 3.3v 189.505n 3.3v 199.495n 3.3v 199.505n 3.3v 209.495n 3.3v 209.505n 3.3v 219.495n 3.3v 219.505n 3.3v 229.495n 3.3v 229.505n 0.0v 239.495n 0.0v 239.505n 0.0v 249.495n 0.0v 249.505n 0.0v 259.495n 0.0v 259.505n 0.0v 269.495n 0.0v 269.505n 0.0v 279.495n 0.0v 279.505n 0.0v 289.495n 0.0v 289.505n 0.0v 299.495n 0.0v 299.505n 0.0v 309.495n 0.0v 309.505n 0.0v 319.495n 0.0v 319.505n 0.0v 329.495n 0.0v 329.505n 0.0v 339.495n 0.0v 339.505n 0.0v 349.495n 0.0v 349.505n 0.0v 359.495n 0.0v 359.505n 0.0v 369.495n 0.0v 369.505n 3.3v 379.495n 3.3v 379.505n 0.0v 389.495n 0.0v 389.505n 0.0v 399.495n 0.0v 399.505n 0.0v 409.495n 0.0v 409.505n 3.3v 419.495n 3.3v 419.505n 3.3v 429.495n 3.3v 429.505n 3.3v 439.495n 3.3v 439.505n 0.0v 449.495n 0.0v 449.505n 0.0v 459.495n 0.0v 459.505n 3.3v 469.495n 3.3v 469.505n 3.3v 479.495n 3.3v 479.505n 0.0v 489.495n 0.0v 489.505n 3.3v 499.495n 3.3v 499.505n 0.0v 509.495n 0.0v 509.505n 0.0v 519.495n 0.0v 519.505n 0.0v 529.495n 0.0v 529.505n 0.0v 539.495n 0.0v 539.505n 0.0v 549.495n 0.0v 549.505n 3.3v 559.495n 3.3v 559.505n 3.3v 569.495n 3.3v 569.505n 0.0v 579.495n 0.0v 579.505n 0.0v 589.495n 0.0v 589.505n 3.3v 599.495n 3.3v 599.505n 3.3v 609.495n 3.3v 609.505n 3.3v 619.495n 3.3v 619.505n 0.0v 629.495n 0.0v 629.505n 0.0v 639.495n 0.0v 639.505n 3.3v 649.495n 3.3v 649.505n 3.3v 659.495n 3.3v 659.505n 3.3v 669.495n 3.3v 669.505n 3.3v 679.495n 3.3v 679.505n 0.0v 689.495n 0.0v 689.505n 0.0v 699.495n 0.0v 699.505n 0.0v 709.495n 0.0v 709.505n 3.3v 719.495n 3.3v 719.505n 0.0v 729.495n 0.0v 729.505n 0.0v 739.495n 0.0v 739.505n 3.3v 749.495n 3.3v 749.505n 3.3v 759.495n 3.3v 759.505n 3.3v 769.495n 3.3v 769.505n 0.0v 779.495n 0.0v 779.505n 0.0v 789.495n 0.0v 789.505n 3.3v 799.495n 3.3v 799.505n 3.3v 809.495n 3.3v 809.505n 3.3v 819.495n 3.3v 819.505n 0.0v 829.495n 0.0v 829.505n 0.0v 839.495n 0.0v 839.505n 0.0v 849.495n 0.0v 849.505n 0.0v 859.495n 0.0v 859.505n 0.0v 869.495n 0.0v 869.505n 3.3v 879.495n 3.3v 879.505n 3.3v 889.495n 3.3v 889.505n 3.3v 899.495n 3.3v 899.505n 3.3v 909.495n 3.3v 909.505n 3.3v 919.495n 3.3v 919.505n 3.3v 929.495n 3.3v 929.505n 3.3v 939.495n 3.3v 939.505n 0.0v 949.495n 0.0v 949.505n 3.3v 959.495n 3.3v 959.505n 3.3v 969.495n 3.3v 969.505n 3.3v 979.495n 3.3v 979.505n 3.3v 989.495n 3.3v 989.505n 3.3v 999.495n 3.3v 999.505n 3.3v 1009.495n 3.3v 1009.505n 3.3v 1019.495n 3.3v 1019.505n 3.3v 1029.495n 3.3v 1029.505n 3.3v 1039.495n 3.3v 1039.505n 0.0v 1049.495n 0.0v 1049.505n 0.0v 1059.495n 0.0v 1059.505n 0.0v 1069.495n 0.0v 1069.505n 0.0v 1079.495n 0.0v 1079.505n 3.3v 1089.495n 3.3v 1089.505n 0.0v 1099.495n 0.0v 1099.505n 3.3v 1109.495n 3.3v 1109.505n 3.3v 1119.495n 3.3v 1119.505n 3.3v 1129.495n 3.3v 1129.505n 0.0v 1139.495n 0.0v 1139.505n 3.3v 1149.495n 3.3v 1149.505n 3.3v 1159.495n 3.3v 1159.505n 3.3v 1169.495n 3.3v 1169.505n 0.0v 1179.495n 0.0v 1179.505n 0.0v 1189.495n 0.0v 1189.505n 3.3v 1199.495n 3.3v 1199.505n 0.0v 1209.495n 0.0v 1209.505n 0.0v 1219.495n 0.0v 1219.505n 0.0v 1229.495n 0.0v 1229.505n 0.0v 1239.495n 0.0v 1239.505n 0.0v 1249.495n 0.0v 1249.505n 3.3v 1259.495n 3.3v 1259.505n 3.3v 1269.495n 3.3v 1269.505n 3.3v 1279.495n 3.3v 1279.505n 3.3v 1289.495n 3.3v 1289.505n 3.3v 1299.495n 3.3v 1299.505n 3.3v 1309.495n 3.3v 1309.505n 3.3v 1319.495n 3.3v 1319.505n 3.3v 1329.495n 3.3v 1329.505n 3.3v 1339.495n 3.3v 1339.505n 0.0v 1349.495n 0.0v 1349.505n 0.0v 1359.495n 0.0v 1359.505n 0.0v 1369.495n 0.0v 1369.505n 3.3v 1379.495n 3.3v 1379.505n 3.3v 1389.495n 3.3v 1389.505n 3.3v 1399.495n 3.3v 1399.505n 3.3v 1409.495n 3.3v 1409.505n 0.0v 1419.495n 0.0v 1419.505n 3.3v 1429.495n 3.3v 1429.505n 3.3v 1439.495n 3.3v 1439.505n 0.0v 1449.495n 0.0v 1449.505n 0.0v 1459.495n 0.0v 1459.505n 0.0v 1469.495n 0.0v 1469.505n 0.0v 1479.495n 0.0v 1479.505n 0.0v 1489.495n 0.0v 1489.505n 3.3v 1499.495n 3.3v 1499.505n 3.3v 1509.495n 3.3v 1509.505n 3.3v 1519.495n 3.3v 1519.505n 3.3v 1529.495n 3.3v 1529.505n 3.3v 1539.495n 3.3v 1539.505n 0.0v 1549.495n 0.0v 1549.505n 3.3v 1559.495n 3.3v 1559.505n 0.0v 1569.495n 0.0v 1569.505n 0.0v 1579.495n 0.0v 1579.505n 0.0v 1589.495n 0.0v 1589.505n 3.3v 1599.495n 3.3v 1599.505n 0.0v 1609.495n 0.0v 1609.505n 0.0v 1619.495n 0.0v 1619.505n 0.0v 1629.495n 0.0v 1629.505n 3.3v 1639.495n 3.3v 1639.505n 3.3v 1649.495n 3.3v 1649.505n 3.3v 1659.495n 3.3v 1659.505n 3.3v 1669.495n 3.3v 1669.505n 0.0v 1679.495n 0.0v 1679.505n 0.0v 1689.495n 0.0v 1689.505n 0.0v 1699.495n 0.0v 1699.505n 0.0v 1709.495n 0.0v 1709.505n 0.0v 1719.495n 0.0v 1719.505n 3.3v 1729.495n 3.3v 1729.505n 3.3v 1739.495n 3.3v 1739.505n 3.3v 1749.495n 3.3v 1749.505n 0.0v 1759.495n 0.0v 1759.505n 3.3v 1769.495n 3.3v 1769.505n 3.3v 1779.495n 3.3v 1779.505n 3.3v 1789.495n 3.3v 1789.505n 3.3v 1799.495n 3.3v 1799.505n 0.0v 1809.495n 0.0v 1809.505n 0.0v 1819.495n 0.0v 1819.505n 3.3v 1829.495n 3.3v 1829.505n 3.3v 1839.495n 3.3v 1839.505n 3.3v 1849.495n 3.3v 1849.505n 3.3v 1859.495n 3.3v 1859.505n 3.3v 1869.495n 3.3v 1869.505n 0.0v 1879.495n 0.0v 1879.505n 3.3v 1889.495n 3.3v 1889.505n 0.0v 1899.495n 0.0v 1899.505n 0.0v 1909.495n 0.0v 1909.505n 3.3v 1919.495n 3.3v 1919.505n 3.3v 1929.495n 3.3v 1929.505n 3.3v 1939.495n 3.3v 1939.505n 0.0v 1949.495n 0.0v 1949.505n 0.0v 1959.495n 0.0v 1959.505n 0.0v 1969.495n 0.0v 1969.505n 3.3v 1979.495n 3.3v 1979.505n 3.3v 1989.495n 3.3v 1989.505n 3.3v 1999.495n 3.3v 1999.505n 3.3v 2009.495n 3.3v 2009.505n 3.3v 2019.495n 3.3v 2019.505n 3.3v 2029.495n 3.3v 2029.505n 3.3v 2039.495n 3.3v 2039.505n 3.3v 2049.495n 3.3v 2049.505n 3.3v )
* (time, data): [(0, 0), (10, 0), (20, 0), (30, 1), (40, 0), (50, 0), (60, 0), (70, 0), (80, 1), (90, 1), (100, 1), (110, 1), (120, 0), (130, 1), (140, 0), (150, 0), (160, 0), (170, 1), (180, 1), (190, 1), (200, 1), (210, 1), (220, 1), (230, 0), (240, 0), (250, 0), (260, 0), (270, 0), (280, 0), (290, 0), (300, 0), (310, 0), (320, 0), (330, 0), (340, 0), (350, 0), (360, 0), (370, 1), (380, 0), (390, 0), (400, 0), (410, 1), (420, 1), (430, 1), (440, 0), (450, 0), (460, 1), (470, 1), (480, 0), (490, 1), (500, 0), (510, 0), (520, 0), (530, 0), (540, 0), (550, 1), (560, 1), (570, 0), (580, 0), (590, 1), (600, 1), (610, 1), (620, 0), (630, 0), (640, 1), (650, 1), (660, 1), (670, 1), (680, 0), (690, 0), (700, 0), (710, 1), (720, 0), (730, 0), (740, 1), (750, 1), (760, 1), (770, 0), (780, 0), (790, 1), (800, 1), (810, 1), (820, 0), (830, 0), (840, 0), (850, 0), (860, 0), (870, 1), (880, 1), (890, 1), (900, 1), (910, 1), (920, 1), (930, 1), (940, 0), (950, 1), (960, 1), (970, 1), (980, 1), (990, 1), (1000, 1), (1010, 1), (1020, 1), (1030, 1), (1040, 0), (1050, 0), (1060, 0), (1070, 0), (1080, 1), (1090, 0), (1100, 1), (1110, 1), (1120, 1), (1130, 0), (1140, 1), (1150, 1), (1160, 1), (1170, 0), (1180, 0), (1190, 1), (1200, 0), (1210, 0), (1220, 0), (1230, 0), (1240, 0), (1250, 1), (1260, 1), (1270, 1), (1280, 1), (1290, 1), (1300, 1), (1310, 1), (1320, 1), (1330, 1), (1340, 0), (1350, 0), (1360, 0), (1370, 1), (1380, 1), (1390, 1), (1400, 1), (1410, 0), (1420, 1), (1430, 1), (1440, 0), (1450, 0), (1460, 0), (1470, 0), (1480, 0), (1490, 1), (1500, 1), (1510, 1), (1520, 1), (1530, 1), (1540, 0), (1550, 1), (1560, 0), (1570, 0), (1580, 0), (1590, 1), (1600, 0), (1610, 0), (1620, 0), (1630, 1), (1640, 1), (1650, 1), (1660, 1), (1670, 0), (1680, 0), (1690, 0), (1700, 0), (1710, 0), (1720, 1), (1730, 1), (1740, 1), (1750, 0), (1760, 1), (1770, 1), (1780, 1), (1790, 1), (1800, 0), (1810, 0), (1820, 1), (1830, 1), (1840, 1), (1850, 1), (1860, 1), (1870, 0), (1880, 1), (1890, 0), (1900, 0), (1910, 1), (1920, 1), (1930, 1), (1940, 0), (1950, 0), (1960, 0), (1970, 1), (1980, 1), (1990, 1), (2000, 1), (2010, 1), (2020, 1), (2030, 1), (2040, 1), (2050, 1)]
Va1_2  a1_2  0 PWL (0n 0.0v 9.495n 0.0v 9.505n 0.0v 19.495n 0.0v 19.505n 0.0v 29.495n 0.0v 29.505n 3.3v 39.495n 3.3v 39.505n 0.0v 49.495n 0.0v 49.505n 0.0v 59.495n 0.0v 59.505n 0.0v 69.495n 0.0v 69.505n 0.0v 79.495n 0.0v 79.505n 3.3v 89.495n 3.3v 89.505n 3.3v 99.495n 3.3v 99.505n 3.3v 109.495n 3.3v 109.505n 3.3v 119.495n 3.3v 119.505n 0.0v 129.495n 0.0v 129.505n 3.3v 139.495n 3.3v 139.505n 0.0v 149.495n 0.0v 149.505n 0.0v 159.495n 0.0v 159.505n 0.0v 169.495n 0.0v 169.505n 3.3v 179.495n 3.3v 179.505n 3.3v 189.495n 3.3v 189.505n 3.3v 199.495n 3.3v 199.505n 3.3v 209.495n 3.3v 209.505n 3.3v 219.495n 3.3v 219.505n 3.3v 229.495n 3.3v 229.505n 0.0v 239.495n 0.0v 239.505n 0.0v 249.495n 0.0v 249.505n 0.0v 259.495n 0.0v 259.505n 0.0v 269.495n 0.0v 269.505n 0.0v 279.495n 0.0v 279.505n 0.0v 289.495n 0.0v 289.505n 0.0v 299.495n 0.0v 299.505n 0.0v 309.495n 0.0v 309.505n 0.0v 319.495n 0.0v 319.505n 0.0v 329.495n 0.0v 329.505n 0.0v 339.495n 0.0v 339.505n 0.0v 349.495n 0.0v 349.505n 0.0v 359.495n 0.0v 359.505n 0.0v 369.495n 0.0v 369.505n 3.3v 379.495n 3.3v 379.505n 0.0v 389.495n 0.0v 389.505n 0.0v 399.495n 0.0v 399.505n 0.0v 409.495n 0.0v 409.505n 3.3v 419.495n 3.3v 419.505n 3.3v 429.495n 3.3v 429.505n 3.3v 439.495n 3.3v 439.505n 0.0v 449.495n 0.0v 449.505n 0.0v 459.495n 0.0v 459.505n 3.3v 469.495n 3.3v 469.505n 3.3v 479.495n 3.3v 479.505n 0.0v 489.495n 0.0v 489.505n 3.3v 499.495n 3.3v 499.505n 0.0v 509.495n 0.0v 509.505n 0.0v 519.495n 0.0v 519.505n 0.0v 529.495n 0.0v 529.505n 0.0v 539.495n 0.0v 539.505n 0.0v 549.495n 0.0v 549.505n 3.3v 559.495n 3.3v 559.505n 3.3v 569.495n 3.3v 569.505n 0.0v 579.495n 0.0v 579.505n 0.0v 589.495n 0.0v 589.505n 3.3v 599.495n 3.3v 599.505n 3.3v 609.495n 3.3v 609.505n 3.3v 619.495n 3.3v 619.505n 0.0v 629.495n 0.0v 629.505n 0.0v 639.495n 0.0v 639.505n 3.3v 649.495n 3.3v 649.505n 3.3v 659.495n 3.3v 659.505n 3.3v 669.495n 3.3v 669.505n 3.3v 679.495n 3.3v 679.505n 0.0v 689.495n 0.0v 689.505n 0.0v 699.495n 0.0v 699.505n 0.0v 709.495n 0.0v 709.505n 3.3v 719.495n 3.3v 719.505n 0.0v 729.495n 0.0v 729.505n 0.0v 739.495n 0.0v 739.505n 3.3v 749.495n 3.3v 749.505n 3.3v 759.495n 3.3v 759.505n 3.3v 769.495n 3.3v 769.505n 0.0v 779.495n 0.0v 779.505n 0.0v 789.495n 0.0v 789.505n 3.3v 799.495n 3.3v 799.505n 3.3v 809.495n 3.3v 809.505n 3.3v 819.495n 3.3v 819.505n 0.0v 829.495n 0.0v 829.505n 0.0v 839.495n 0.0v 839.505n 0.0v 849.495n 0.0v 849.505n 0.0v 859.495n 0.0v 859.505n 0.0v 869.495n 0.0v 869.505n 3.3v 879.495n 3.3v 879.505n 3.3v 889.495n 3.3v 889.505n 3.3v 899.495n 3.3v 899.505n 3.3v 909.495n 3.3v 909.505n 3.3v 919.495n 3.3v 919.505n 3.3v 929.495n 3.3v 929.505n 3.3v 939.495n 3.3v 939.505n 0.0v 949.495n 0.0v 949.505n 3.3v 959.495n 3.3v 959.505n 3.3v 969.495n 3.3v 969.505n 3.3v 979.495n 3.3v 979.505n 3.3v 989.495n 3.3v 989.505n 3.3v 999.495n 3.3v 999.505n 3.3v 1009.495n 3.3v 1009.505n 3.3v 1019.495n 3.3v 1019.505n 3.3v 1029.495n 3.3v 1029.505n 3.3v 1039.495n 3.3v 1039.505n 0.0v 1049.495n 0.0v 1049.505n 0.0v 1059.495n 0.0v 1059.505n 0.0v 1069.495n 0.0v 1069.505n 0.0v 1079.495n 0.0v 1079.505n 3.3v 1089.495n 3.3v 1089.505n 0.0v 1099.495n 0.0v 1099.505n 3.3v 1109.495n 3.3v 1109.505n 3.3v 1119.495n 3.3v 1119.505n 3.3v 1129.495n 3.3v 1129.505n 0.0v 1139.495n 0.0v 1139.505n 3.3v 1149.495n 3.3v 1149.505n 3.3v 1159.495n 3.3v 1159.505n 3.3v 1169.495n 3.3v 1169.505n 0.0v 1179.495n 0.0v 1179.505n 0.0v 1189.495n 0.0v 1189.505n 3.3v 1199.495n 3.3v 1199.505n 0.0v 1209.495n 0.0v 1209.505n 0.0v 1219.495n 0.0v 1219.505n 0.0v 1229.495n 0.0v 1229.505n 0.0v 1239.495n 0.0v 1239.505n 0.0v 1249.495n 0.0v 1249.505n 3.3v 1259.495n 3.3v 1259.505n 3.3v 1269.495n 3.3v 1269.505n 3.3v 1279.495n 3.3v 1279.505n 3.3v 1289.495n 3.3v 1289.505n 3.3v 1299.495n 3.3v 1299.505n 3.3v 1309.495n 3.3v 1309.505n 3.3v 1319.495n 3.3v 1319.505n 3.3v 1329.495n 3.3v 1329.505n 3.3v 1339.495n 3.3v 1339.505n 0.0v 1349.495n 0.0v 1349.505n 0.0v 1359.495n 0.0v 1359.505n 0.0v 1369.495n 0.0v 1369.505n 3.3v 1379.495n 3.3v 1379.505n 3.3v 1389.495n 3.3v 1389.505n 3.3v 1399.495n 3.3v 1399.505n 3.3v 1409.495n 3.3v 1409.505n 0.0v 1419.495n 0.0v 1419.505n 3.3v 1429.495n 3.3v 1429.505n 3.3v 1439.495n 3.3v 1439.505n 0.0v 1449.495n 0.0v 1449.505n 0.0v 1459.495n 0.0v 1459.505n 0.0v 1469.495n 0.0v 1469.505n 0.0v 1479.495n 0.0v 1479.505n 0.0v 1489.495n 0.0v 1489.505n 3.3v 1499.495n 3.3v 1499.505n 3.3v 1509.495n 3.3v 1509.505n 3.3v 1519.495n 3.3v 1519.505n 3.3v 1529.495n 3.3v 1529.505n 3.3v 1539.495n 3.3v 1539.505n 0.0v 1549.495n 0.0v 1549.505n 3.3v 1559.495n 3.3v 1559.505n 0.0v 1569.495n 0.0v 1569.505n 0.0v 1579.495n 0.0v 1579.505n 0.0v 1589.495n 0.0v 1589.505n 3.3v 1599.495n 3.3v 1599.505n 0.0v 1609.495n 0.0v 1609.505n 0.0v 1619.495n 0.0v 1619.505n 0.0v 1629.495n 0.0v 1629.505n 3.3v 1639.495n 3.3v 1639.505n 3.3v 1649.495n 3.3v 1649.505n 3.3v 1659.495n 3.3v 1659.505n 3.3v 1669.495n 3.3v 1669.505n 0.0v 1679.495n 0.0v 1679.505n 0.0v 1689.495n 0.0v 1689.505n 0.0v 1699.495n 0.0v 1699.505n 0.0v 1709.495n 0.0v 1709.505n 0.0v 1719.495n 0.0v 1719.505n 3.3v 1729.495n 3.3v 1729.505n 3.3v 1739.495n 3.3v 1739.505n 3.3v 1749.495n 3.3v 1749.505n 0.0v 1759.495n 0.0v 1759.505n 3.3v 1769.495n 3.3v 1769.505n 3.3v 1779.495n 3.3v 1779.505n 3.3v 1789.495n 3.3v 1789.505n 3.3v 1799.495n 3.3v 1799.505n 0.0v 1809.495n 0.0v 1809.505n 0.0v 1819.495n 0.0v 1819.505n 3.3v 1829.495n 3.3v 1829.505n 3.3v 1839.495n 3.3v 1839.505n 3.3v 1849.495n 3.3v 1849.505n 3.3v 1859.495n 3.3v 1859.505n 3.3v 1869.495n 3.3v 1869.505n 0.0v 1879.495n 0.0v 1879.505n 3.3v 1889.495n 3.3v 1889.505n 0.0v 1899.495n 0.0v 1899.505n 0.0v 1909.495n 0.0v 1909.505n 3.3v 1919.495n 3.3v 1919.505n 3.3v 1929.495n 3.3v 1929.505n 3.3v 1939.495n 3.3v 1939.505n 0.0v 1949.495n 0.0v 1949.505n 0.0v 1959.495n 0.0v 1959.505n 0.0v 1969.495n 0.0v 1969.505n 3.3v 1979.495n 3.3v 1979.505n 3.3v 1989.495n 3.3v 1989.505n 3.3v 1999.495n 3.3v 1999.505n 3.3v 2009.495n 3.3v 2009.505n 3.3v 2019.495n 3.3v 2019.505n 3.3v 2029.495n 3.3v 2029.505n 3.3v 2039.495n 3.3v 2039.505n 3.3v 2049.495n 3.3v 2049.505n 3.3v )
* (time, data): [(0, 0), (10, 0), (20, 0), (30, 1), (40, 0), (50, 0), (60, 0), (70, 0), (80, 1), (90, 1), (100, 1), (110, 1), (120, 0), (130, 1), (140, 0), (150, 0), (160, 0), (170, 1), (180, 1), (190, 1), (200, 1), (210, 1), (220, 1), (230, 0), (240, 0), (250, 0), (260, 0), (270, 0), (280, 0), (290, 0), (300, 0), (310, 0), (320, 0), (330, 0), (340, 0), (350, 0), (360, 0), (370, 1), (380, 0), (390, 0), (400, 0), (410, 1), (420, 1), (430, 1), (440, 0), (450, 0), (460, 1), (470, 1), (480, 0), (490, 1), (500, 0), (510, 0), (520, 0), (530, 0), (540, 0), (550, 1), (560, 1), (570, 0), (580, 0), (590, 1), (600, 1), (610, 1), (620, 0), (630, 0), (640, 1), (650, 1), (660, 1), (670, 1), (680, 0), (690, 0), (700, 0), (710, 1), (720, 0), (730, 0), (740, 1), (750, 1), (760, 1), (770, 0), (780, 0), (790, 1), (800, 1), (810, 1), (820, 0), (830, 0), (840, 0), (850, 0), (860, 0), (870, 1), (880, 1), (890, 1), (900, 1), (910, 1), (920, 1), (930, 1), (940, 0), (950, 1), (960, 1), (970, 1), (980, 1), (990, 1), (1000, 1), (1010, 1), (1020, 1), (1030, 1), (1040, 0), (1050, 0), (1060, 0), (1070, 0), (1080, 1), (1090, 0), (1100, 1), (1110, 1), (1120, 1), (1130, 0), (1140, 1), (1150, 1), (1160, 1), (1170, 0), (1180, 0), (1190, 1), (1200, 0), (1210, 0), (1220, 0), (1230, 0), (1240, 0), (1250, 1), (1260, 1), (1270, 1), (1280, 1), (1290, 1), (1300, 1), (1310, 1), (1320, 1), (1330, 1), (1340, 0), (1350, 0), (1360, 0), (1370, 1), (1380, 1), (1390, 1), (1400, 1), (1410, 0), (1420, 1), (1430, 1), (1440, 0), (1450, 0), (1460, 0), (1470, 0), (1480, 0), (1490, 1), (1500, 1), (1510, 1), (1520, 1), (1530, 1), (1540, 0), (1550, 1), (1560, 0), (1570, 0), (1580, 0), (1590, 1), (1600, 0), (1610, 0), (1620, 0), (1630, 1), (1640, 1), (1650, 1), (1660, 1), (1670, 0), (1680, 0), (1690, 0), (1700, 0), (1710, 0), (1720, 1), (1730, 1), (1740, 1), (1750, 0), (1760, 1), (1770, 1), (1780, 1), (1790, 1), (1800, 0), (1810, 0), (1820, 1), (1830, 1), (1840, 1), (1850, 1), (1860, 1), (1870, 0), (1880, 1), (1890, 0), (1900, 0), (1910, 1), (1920, 1), (1930, 1), (1940, 0), (1950, 0), (1960, 0), (1970, 1), (1980, 1), (1990, 1), (2000, 1), (2010, 1), (2020, 1), (2030, 1), (2040, 1), (2050, 1)]
Va1_3  a1_3  0 PWL (0n 0.0v 9.495n 0.0v 9.505n 0.0v 19.495n 0.0v 19.505n 0.0v 29.495n 0.0v 29.505n 3.3v 39.495n 3.3v 39.505n 0.0v 49.495n 0.0v 49.505n 0.0v 59.495n 0.0v 59.505n 0.0v 69.495n 0.0v 69.505n 0.0v 79.495n 0.0v 79.505n 3.3v 89.495n 3.3v 89.505n 3.3v 99.495n 3.3v 99.505n 3.3v 109.495n 3.3v 109.505n 3.3v 119.495n 3.3v 119.505n 0.0v 129.495n 0.0v 129.505n 3.3v 139.495n 3.3v 139.505n 0.0v 149.495n 0.0v 149.505n 0.0v 159.495n 0.0v 159.505n 0.0v 169.495n 0.0v 169.505n 3.3v 179.495n 3.3v 179.505n 3.3v 189.495n 3.3v 189.505n 3.3v 199.495n 3.3v 199.505n 3.3v 209.495n 3.3v 209.505n 3.3v 219.495n 3.3v 219.505n 3.3v 229.495n 3.3v 229.505n 0.0v 239.495n 0.0v 239.505n 0.0v 249.495n 0.0v 249.505n 0.0v 259.495n 0.0v 259.505n 0.0v 269.495n 0.0v 269.505n 0.0v 279.495n 0.0v 279.505n 0.0v 289.495n 0.0v 289.505n 0.0v 299.495n 0.0v 299.505n 0.0v 309.495n 0.0v 309.505n 0.0v 319.495n 0.0v 319.505n 0.0v 329.495n 0.0v 329.505n 0.0v 339.495n 0.0v 339.505n 0.0v 349.495n 0.0v 349.505n 0.0v 359.495n 0.0v 359.505n 0.0v 369.495n 0.0v 369.505n 3.3v 379.495n 3.3v 379.505n 0.0v 389.495n 0.0v 389.505n 0.0v 399.495n 0.0v 399.505n 0.0v 409.495n 0.0v 409.505n 3.3v 419.495n 3.3v 419.505n 3.3v 429.495n 3.3v 429.505n 3.3v 439.495n 3.3v 439.505n 0.0v 449.495n 0.0v 449.505n 0.0v 459.495n 0.0v 459.505n 3.3v 469.495n 3.3v 469.505n 3.3v 479.495n 3.3v 479.505n 0.0v 489.495n 0.0v 489.505n 3.3v 499.495n 3.3v 499.505n 0.0v 509.495n 0.0v 509.505n 0.0v 519.495n 0.0v 519.505n 0.0v 529.495n 0.0v 529.505n 0.0v 539.495n 0.0v 539.505n 0.0v 549.495n 0.0v 549.505n 3.3v 559.495n 3.3v 559.505n 3.3v 569.495n 3.3v 569.505n 0.0v 579.495n 0.0v 579.505n 0.0v 589.495n 0.0v 589.505n 3.3v 599.495n 3.3v 599.505n 3.3v 609.495n 3.3v 609.505n 3.3v 619.495n 3.3v 619.505n 0.0v 629.495n 0.0v 629.505n 0.0v 639.495n 0.0v 639.505n 3.3v 649.495n 3.3v 649.505n 3.3v 659.495n 3.3v 659.505n 3.3v 669.495n 3.3v 669.505n 3.3v 679.495n 3.3v 679.505n 0.0v 689.495n 0.0v 689.505n 0.0v 699.495n 0.0v 699.505n 0.0v 709.495n 0.0v 709.505n 3.3v 719.495n 3.3v 719.505n 0.0v 729.495n 0.0v 729.505n 0.0v 739.495n 0.0v 739.505n 3.3v 749.495n 3.3v 749.505n 3.3v 759.495n 3.3v 759.505n 3.3v 769.495n 3.3v 769.505n 0.0v 779.495n 0.0v 779.505n 0.0v 789.495n 0.0v 789.505n 3.3v 799.495n 3.3v 799.505n 3.3v 809.495n 3.3v 809.505n 3.3v 819.495n 3.3v 819.505n 0.0v 829.495n 0.0v 829.505n 0.0v 839.495n 0.0v 839.505n 0.0v 849.495n 0.0v 849.505n 0.0v 859.495n 0.0v 859.505n 0.0v 869.495n 0.0v 869.505n 3.3v 879.495n 3.3v 879.505n 3.3v 889.495n 3.3v 889.505n 3.3v 899.495n 3.3v 899.505n 3.3v 909.495n 3.3v 909.505n 3.3v 919.495n 3.3v 919.505n 3.3v 929.495n 3.3v 929.505n 3.3v 939.495n 3.3v 939.505n 0.0v 949.495n 0.0v 949.505n 3.3v 959.495n 3.3v 959.505n 3.3v 969.495n 3.3v 969.505n 3.3v 979.495n 3.3v 979.505n 3.3v 989.495n 3.3v 989.505n 3.3v 999.495n 3.3v 999.505n 3.3v 1009.495n 3.3v 1009.505n 3.3v 1019.495n 3.3v 1019.505n 3.3v 1029.495n 3.3v 1029.505n 3.3v 1039.495n 3.3v 1039.505n 0.0v 1049.495n 0.0v 1049.505n 0.0v 1059.495n 0.0v 1059.505n 0.0v 1069.495n 0.0v 1069.505n 0.0v 1079.495n 0.0v 1079.505n 3.3v 1089.495n 3.3v 1089.505n 0.0v 1099.495n 0.0v 1099.505n 3.3v 1109.495n 3.3v 1109.505n 3.3v 1119.495n 3.3v 1119.505n 3.3v 1129.495n 3.3v 1129.505n 0.0v 1139.495n 0.0v 1139.505n 3.3v 1149.495n 3.3v 1149.505n 3.3v 1159.495n 3.3v 1159.505n 3.3v 1169.495n 3.3v 1169.505n 0.0v 1179.495n 0.0v 1179.505n 0.0v 1189.495n 0.0v 1189.505n 3.3v 1199.495n 3.3v 1199.505n 0.0v 1209.495n 0.0v 1209.505n 0.0v 1219.495n 0.0v 1219.505n 0.0v 1229.495n 0.0v 1229.505n 0.0v 1239.495n 0.0v 1239.505n 0.0v 1249.495n 0.0v 1249.505n 3.3v 1259.495n 3.3v 1259.505n 3.3v 1269.495n 3.3v 1269.505n 3.3v 1279.495n 3.3v 1279.505n 3.3v 1289.495n 3.3v 1289.505n 3.3v 1299.495n 3.3v 1299.505n 3.3v 1309.495n 3.3v 1309.505n 3.3v 1319.495n 3.3v 1319.505n 3.3v 1329.495n 3.3v 1329.505n 3.3v 1339.495n 3.3v 1339.505n 0.0v 1349.495n 0.0v 1349.505n 0.0v 1359.495n 0.0v 1359.505n 0.0v 1369.495n 0.0v 1369.505n 3.3v 1379.495n 3.3v 1379.505n 3.3v 1389.495n 3.3v 1389.505n 3.3v 1399.495n 3.3v 1399.505n 3.3v 1409.495n 3.3v 1409.505n 0.0v 1419.495n 0.0v 1419.505n 3.3v 1429.495n 3.3v 1429.505n 3.3v 1439.495n 3.3v 1439.505n 0.0v 1449.495n 0.0v 1449.505n 0.0v 1459.495n 0.0v 1459.505n 0.0v 1469.495n 0.0v 1469.505n 0.0v 1479.495n 0.0v 1479.505n 0.0v 1489.495n 0.0v 1489.505n 3.3v 1499.495n 3.3v 1499.505n 3.3v 1509.495n 3.3v 1509.505n 3.3v 1519.495n 3.3v 1519.505n 3.3v 1529.495n 3.3v 1529.505n 3.3v 1539.495n 3.3v 1539.505n 0.0v 1549.495n 0.0v 1549.505n 3.3v 1559.495n 3.3v 1559.505n 0.0v 1569.495n 0.0v 1569.505n 0.0v 1579.495n 0.0v 1579.505n 0.0v 1589.495n 0.0v 1589.505n 3.3v 1599.495n 3.3v 1599.505n 0.0v 1609.495n 0.0v 1609.505n 0.0v 1619.495n 0.0v 1619.505n 0.0v 1629.495n 0.0v 1629.505n 3.3v 1639.495n 3.3v 1639.505n 3.3v 1649.495n 3.3v 1649.505n 3.3v 1659.495n 3.3v 1659.505n 3.3v 1669.495n 3.3v 1669.505n 0.0v 1679.495n 0.0v 1679.505n 0.0v 1689.495n 0.0v 1689.505n 0.0v 1699.495n 0.0v 1699.505n 0.0v 1709.495n 0.0v 1709.505n 0.0v 1719.495n 0.0v 1719.505n 3.3v 1729.495n 3.3v 1729.505n 3.3v 1739.495n 3.3v 1739.505n 3.3v 1749.495n 3.3v 1749.505n 0.0v 1759.495n 0.0v 1759.505n 3.3v 1769.495n 3.3v 1769.505n 3.3v 1779.495n 3.3v 1779.505n 3.3v 1789.495n 3.3v 1789.505n 3.3v 1799.495n 3.3v 1799.505n 0.0v 1809.495n 0.0v 1809.505n 0.0v 1819.495n 0.0v 1819.505n 3.3v 1829.495n 3.3v 1829.505n 3.3v 1839.495n 3.3v 1839.505n 3.3v 1849.495n 3.3v 1849.505n 3.3v 1859.495n 3.3v 1859.505n 3.3v 1869.495n 3.3v 1869.505n 0.0v 1879.495n 0.0v 1879.505n 3.3v 1889.495n 3.3v 1889.505n 0.0v 1899.495n 0.0v 1899.505n 0.0v 1909.495n 0.0v 1909.505n 3.3v 1919.495n 3.3v 1919.505n 3.3v 1929.495n 3.3v 1929.505n 3.3v 1939.495n 3.3v 1939.505n 0.0v 1949.495n 0.0v 1949.505n 0.0v 1959.495n 0.0v 1959.505n 0.0v 1969.495n 0.0v 1969.505n 3.3v 1979.495n 3.3v 1979.505n 3.3v 1989.495n 3.3v 1989.505n 3.3v 1999.495n 3.3v 1999.505n 3.3v 2009.495n 3.3v 2009.505n 3.3v 2019.495n 3.3v 2019.505n 3.3v 2029.495n 3.3v 2029.505n 3.3v 2039.495n 3.3v 2039.505n 3.3v 2049.495n 3.3v 2049.505n 3.3v )

 * Generation of control signals
* (time, data): [(0, 1), (10, 0), (20, 0), (30, 0), (40, 0), (50, 0), (60, 0), (70, 1), (80, 1), (90, 0), (100, 0), (110, 0), (120, 0), (130, 1), (140, 1), (150, 0), (160, 0), (170, 0), (180, 0), (190, 0), (200, 0), (210, 0), (220, 0), (230, 0), (240, 0), (250, 0), (260, 0), (270, 0), (280, 0), (290, 0), (300, 1), (310, 0), (320, 0), (330, 0), (340, 0), (350, 0), (360, 0), (370, 0), (380, 0), (390, 0), (400, 0), (410, 1), (420, 0), (430, 0), (440, 0), (450, 1), (460, 0), (470, 0), (480, 1), (490, 1), (500, 0), (510, 0), (520, 0), (530, 0), (540, 0), (550, 1), (560, 0), (570, 0), (580, 0), (590, 0), (600, 0), (610, 0), (620, 1), (630, 0), (640, 1), (650, 1), (660, 0), (670, 0), (680, 1), (690, 0), (700, 0), (710, 0), (720, 0), (730, 0), (740, 1), (750, 0), (760, 0), (770, 0), (780, 0), (790, 0), (800, 1), (810, 1), (820, 0), (830, 1), (840, 0), (850, 0), (860, 0), (870, 0), (880, 1), (890, 1), (900, 0), (910, 0), (920, 0), (930, 0), (940, 0), (950, 0), (960, 0), (970, 0), (980, 1), (990, 0), (1000, 0), (1010, 0), (1020, 0), (1030, 0), (1040, 0), (1050, 0), (1060, 0), (1070, 0), (1080, 1), (1090, 1), (1100, 0), (1110, 0), (1120, 0), (1130, 0), (1140, 1), (1150, 0), (1160, 0), (1170, 0), (1180, 0), (1190, 1), (1200, 0), (1210, 0), (1220, 0), (1230, 0), (1240, 0), (1250, 0), (1260, 0), (1270, 1), (1280, 0), (1290, 0), (1300, 0), (1310, 0), (1320, 1), (1330, 0), (1340, 0), (1350, 0), (1360, 0), (1370, 0), (1380, 1), (1390, 1), (1400, 0), (1410, 1), (1420, 0), (1430, 1), (1440, 0), (1450, 0), (1460, 0), (1470, 0), (1480, 0), (1490, 0), (1500, 0), (1510, 0), (1520, 0), (1530, 0), (1540, 0), (1550, 0), (1560, 0), (1570, 1), (1580, 0), (1590, 0), (1600, 0), (1610, 0), (1620, 0), (1630, 0), (1640, 0), (1650, 1), (1660, 0), (1670, 0), (1680, 0), (1690, 0), (1700, 0), (1710, 0), (1720, 0), (1730, 0), (1740, 0), (1750, 0), (1760, 0), (1770, 1), (1780, 0), (1790, 0), (1800, 0), (1810, 0), (1820, 0), (1830, 0), (1840, 0), (1850, 0), (1860, 0), (1870, 0), (1880, 0), (1890, 1), (1900, 0), (1910, 0), (1920, 0), (1930, 0), (1940, 0), (1950, 0), (1960, 0), (1970, 1), (1980, 0), (1990, 0), (2000, 1), (2010, 0), (2020, 0), (2030, 0), (2040, 0), (2050, 1)]
VCSB0 CSB0 0 PWL (0n 3.3v 9.495n 3.3v 9.505n 0.0v 19.495n 0.0v 19.505n 0.0v 29.495n 0.0v 29.505n 0.0v 39.495n 0.0v 39.505n 0.0v 49.495n 0.0v 49.505n 0.0v 59.495n 0.0v 59.505n 0.0v 69.495n 0.0v 69.505n 3.3v 79.495n 3.3v 79.505n 3.3v 89.495n 3.3v 89.505n 0.0v 99.495n 0.0v 99.505n 0.0v 109.495n 0.0v 109.505n 0.0v 119.495n 0.0v 119.505n 0.0v 129.495n 0.0v 129.505n 3.3v 139.495n 3.3v 139.505n 3.3v 149.495n 3.3v 149.505n 0.0v 159.495n 0.0v 159.505n 0.0v 169.495n 0.0v 169.505n 0.0v 179.495n 0.0v 179.505n 0.0v 189.495n 0.0v 189.505n 0.0v 199.495n 0.0v 199.505n 0.0v 209.495n 0.0v 209.505n 0.0v 219.495n 0.0v 219.505n 0.0v 229.495n 0.0v 229.505n 0.0v 239.495n 0.0v 239.505n 0.0v 249.495n 0.0v 249.505n 0.0v 259.495n 0.0v 259.505n 0.0v 269.495n 0.0v 269.505n 0.0v 279.495n 0.0v 279.505n 0.0v 289.495n 0.0v 289.505n 0.0v 299.495n 0.0v 299.505n 3.3v 309.495n 3.3v 309.505n 0.0v 319.495n 0.0v 319.505n 0.0v 329.495n 0.0v 329.505n 0.0v 339.495n 0.0v 339.505n 0.0v 349.495n 0.0v 349.505n 0.0v 359.495n 0.0v 359.505n 0.0v 369.495n 0.0v 369.505n 0.0v 379.495n 0.0v 379.505n 0.0v 389.495n 0.0v 389.505n 0.0v 399.495n 0.0v 399.505n 0.0v 409.495n 0.0v 409.505n 3.3v 419.495n 3.3v 419.505n 0.0v 429.495n 0.0v 429.505n 0.0v 439.495n 0.0v 439.505n 0.0v 449.495n 0.0v 449.505n 3.3v 459.495n 3.3v 459.505n 0.0v 469.495n 0.0v 469.505n 0.0v 479.495n 0.0v 479.505n 3.3v 489.495n 3.3v 489.505n 3.3v 499.495n 3.3v 499.505n 0.0v 509.495n 0.0v 509.505n 0.0v 519.495n 0.0v 519.505n 0.0v 529.495n 0.0v 529.505n 0.0v 539.495n 0.0v 539.505n 0.0v 549.495n 0.0v 549.505n 3.3v 559.495n 3.3v 559.505n 0.0v 569.495n 0.0v 569.505n 0.0v 579.495n 0.0v 579.505n 0.0v 589.495n 0.0v 589.505n 0.0v 599.495n 0.0v 599.505n 0.0v 609.495n 0.0v 609.505n 0.0v 619.495n 0.0v 619.505n 3.3v 629.495n 3.3v 629.505n 0.0v 639.495n 0.0v 639.505n 3.3v 649.495n 3.3v 649.505n 3.3v 659.495n 3.3v 659.505n 0.0v 669.495n 0.0v 669.505n 0.0v 679.495n 0.0v 679.505n 3.3v 689.495n 3.3v 689.505n 0.0v 699.495n 0.0v 699.505n 0.0v 709.495n 0.0v 709.505n 0.0v 719.495n 0.0v 719.505n 0.0v 729.495n 0.0v 729.505n 0.0v 739.495n 0.0v 739.505n 3.3v 749.495n 3.3v 749.505n 0.0v 759.495n 0.0v 759.505n 0.0v 769.495n 0.0v 769.505n 0.0v 779.495n 0.0v 779.505n 0.0v 789.495n 0.0v 789.505n 0.0v 799.495n 0.0v 799.505n 3.3v 809.495n 3.3v 809.505n 3.3v 819.495n 3.3v 819.505n 0.0v 829.495n 0.0v 829.505n 3.3v 839.495n 3.3v 839.505n 0.0v 849.495n 0.0v 849.505n 0.0v 859.495n 0.0v 859.505n 0.0v 869.495n 0.0v 869.505n 0.0v 879.495n 0.0v 879.505n 3.3v 889.495n 3.3v 889.505n 3.3v 899.495n 3.3v 899.505n 0.0v 909.495n 0.0v 909.505n 0.0v 919.495n 0.0v 919.505n 0.0v 929.495n 0.0v 929.505n 0.0v 939.495n 0.0v 939.505n 0.0v 949.495n 0.0v 949.505n 0.0v 959.495n 0.0v 959.505n 0.0v 969.495n 0.0v 969.505n 0.0v 979.495n 0.0v 979.505n 3.3v 989.495n 3.3v 989.505n 0.0v 999.495n 0.0v 999.505n 0.0v 1009.495n 0.0v 1009.505n 0.0v 1019.495n 0.0v 1019.505n 0.0v 1029.495n 0.0v 1029.505n 0.0v 1039.495n 0.0v 1039.505n 0.0v 1049.495n 0.0v 1049.505n 0.0v 1059.495n 0.0v 1059.505n 0.0v 1069.495n 0.0v 1069.505n 0.0v 1079.495n 0.0v 1079.505n 3.3v 1089.495n 3.3v 1089.505n 3.3v 1099.495n 3.3v 1099.505n 0.0v 1109.495n 0.0v 1109.505n 0.0v 1119.495n 0.0v 1119.505n 0.0v 1129.495n 0.0v 1129.505n 0.0v 1139.495n 0.0v 1139.505n 3.3v 1149.495n 3.3v 1149.505n 0.0v 1159.495n 0.0v 1159.505n 0.0v 1169.495n 0.0v 1169.505n 0.0v 1179.495n 0.0v 1179.505n 0.0v 1189.495n 0.0v 1189.505n 3.3v 1199.495n 3.3v 1199.505n 0.0v 1209.495n 0.0v 1209.505n 0.0v 1219.495n 0.0v 1219.505n 0.0v 1229.495n 0.0v 1229.505n 0.0v 1239.495n 0.0v 1239.505n 0.0v 1249.495n 0.0v 1249.505n 0.0v 1259.495n 0.0v 1259.505n 0.0v 1269.495n 0.0v 1269.505n 3.3v 1279.495n 3.3v 1279.505n 0.0v 1289.495n 0.0v 1289.505n 0.0v 1299.495n 0.0v 1299.505n 0.0v 1309.495n 0.0v 1309.505n 0.0v 1319.495n 0.0v 1319.505n 3.3v 1329.495n 3.3v 1329.505n 0.0v 1339.495n 0.0v 1339.505n 0.0v 1349.495n 0.0v 1349.505n 0.0v 1359.495n 0.0v 1359.505n 0.0v 1369.495n 0.0v 1369.505n 0.0v 1379.495n 0.0v 1379.505n 3.3v 1389.495n 3.3v 1389.505n 3.3v 1399.495n 3.3v 1399.505n 0.0v 1409.495n 0.0v 1409.505n 3.3v 1419.495n 3.3v 1419.505n 0.0v 1429.495n 0.0v 1429.505n 3.3v 1439.495n 3.3v 1439.505n 0.0v 1449.495n 0.0v 1449.505n 0.0v 1459.495n 0.0v 1459.505n 0.0v 1469.495n 0.0v 1469.505n 0.0v 1479.495n 0.0v 1479.505n 0.0v 1489.495n 0.0v 1489.505n 0.0v 1499.495n 0.0v 1499.505n 0.0v 1509.495n 0.0v 1509.505n 0.0v 1519.495n 0.0v 1519.505n 0.0v 1529.495n 0.0v 1529.505n 0.0v 1539.495n 0.0v 1539.505n 0.0v 1549.495n 0.0v 1549.505n 0.0v 1559.495n 0.0v 1559.505n 0.0v 1569.495n 0.0v 1569.505n 3.3v 1579.495n 3.3v 1579.505n 0.0v 1589.495n 0.0v 1589.505n 0.0v 1599.495n 0.0v 1599.505n 0.0v 1609.495n 0.0v 1609.505n 0.0v 1619.495n 0.0v 1619.505n 0.0v 1629.495n 0.0v 1629.505n 0.0v 1639.495n 0.0v 1639.505n 0.0v 1649.495n 0.0v 1649.505n 3.3v 1659.495n 3.3v 1659.505n 0.0v 1669.495n 0.0v 1669.505n 0.0v 1679.495n 0.0v 1679.505n 0.0v 1689.495n 0.0v 1689.505n 0.0v 1699.495n 0.0v 1699.505n 0.0v 1709.495n 0.0v 1709.505n 0.0v 1719.495n 0.0v 1719.505n 0.0v 1729.495n 0.0v 1729.505n 0.0v 1739.495n 0.0v 1739.505n 0.0v 1749.495n 0.0v 1749.505n 0.0v 1759.495n 0.0v 1759.505n 0.0v 1769.495n 0.0v 1769.505n 3.3v 1779.495n 3.3v 1779.505n 0.0v 1789.495n 0.0v 1789.505n 0.0v 1799.495n 0.0v 1799.505n 0.0v 1809.495n 0.0v 1809.505n 0.0v 1819.495n 0.0v 1819.505n 0.0v 1829.495n 0.0v 1829.505n 0.0v 1839.495n 0.0v 1839.505n 0.0v 1849.495n 0.0v 1849.505n 0.0v 1859.495n 0.0v 1859.505n 0.0v 1869.495n 0.0v 1869.505n 0.0v 1879.495n 0.0v 1879.505n 0.0v 1889.495n 0.0v 1889.505n 3.3v 1899.495n 3.3v 1899.505n 0.0v 1909.495n 0.0v 1909.505n 0.0v 1919.495n 0.0v 1919.505n 0.0v 1929.495n 0.0v 1929.505n 0.0v 1939.495n 0.0v 1939.505n 0.0v 1949.495n 0.0v 1949.505n 0.0v 1959.495n 0.0v 1959.505n 0.0v 1969.495n 0.0v 1969.505n 3.3v 1979.495n 3.3v 1979.505n 0.0v 1989.495n 0.0v 1989.505n 0.0v 1999.495n 0.0v 1999.505n 3.3v 2009.495n 3.3v 2009.505n 0.0v 2019.495n 0.0v 2019.505n 0.0v 2029.495n 0.0v 2029.505n 0.0v 2039.495n 0.0v 2039.505n 0.0v 2049.495n 0.0v 2049.505n 3.3v )
* (time, data): [(0, 1), (10, 0), (20, 0), (30, 0), (40, 0), (50, 0), (60, 1), (70, 0), (80, 0), (90, 1), (100, 0), (110, 1), (120, 0), (130, 0), (140, 0), (150, 1), (160, 1), (170, 0), (180, 0), (190, 0), (200, 1), (210, 1), (220, 1), (230, 0), (240, 0), (250, 0), (260, 1), (270, 1), (280, 0), (290, 1), (300, 1), (310, 1), (320, 1), (330, 1), (340, 1), (350, 0), (360, 1), (370, 0), (380, 0), (390, 1), (400, 0), (410, 0), (420, 1), (430, 1), (440, 0), (450, 0), (460, 0), (470, 1), (480, 0), (490, 0), (500, 0), (510, 0), (520, 0), (530, 1), (540, 1), (550, 0), (560, 1), (570, 0), (580, 1), (590, 0), (600, 0), (610, 1), (620, 0), (630, 1), (640, 0), (650, 0), (660, 0), (670, 0), (680, 0), (690, 1), (700, 1), (710, 0), (720, 0), (730, 0), (740, 0), (750, 0), (760, 0), (770, 0), (780, 1), (790, 0), (800, 0), (810, 0), (820, 0), (830, 0), (840, 1), (850, 1), (860, 0), (870, 0), (880, 0), (890, 1), (900, 0), (910, 0), (920, 0), (930, 0), (940, 0), (950, 0), (960, 0), (970, 1), (980, 0), (990, 1), (1000, 1), (1010, 1), (1020, 1), (1030, 0), (1040, 0), (1050, 0), (1060, 0), (1070, 1), (1080, 0), (1090, 0), (1100, 0), (1110, 0), (1120, 0), (1130, 0), (1140, 0), (1150, 0), (1160, 1), (1170, 0), (1180, 1), (1190, 0), (1200, 0), (1210, 0), (1220, 0), (1230, 1), (1240, 1), (1250, 0), (1260, 1), (1270, 0), (1280, 1), (1290, 1), (1300, 0), (1310, 0), (1320, 0), (1330, 0), (1340, 0), (1350, 1), (1360, 1), (1370, 0), (1380, 1), (1390, 0), (1400, 0), (1410, 0), (1420, 0), (1430, 1), (1440, 0), (1450, 0), (1460, 1), (1470, 0), (1480, 0), (1490, 0), (1500, 1), (1510, 1), (1520, 1), (1530, 1), (1540, 0), (1550, 0), (1560, 0), (1570, 1), (1580, 0), (1590, 0), (1600, 0), (1610, 0), (1620, 1), (1630, 0), (1640, 0), (1650, 0), (1660, 1), (1670, 0), (1680, 0), (1690, 1), (1700, 1), (1710, 1), (1720, 0), (1730, 0), (1740, 0), (1750, 0), (1760, 0), (1770, 0), (1780, 1), (1790, 1), (1800, 0), (1810, 0), (1820, 0), (1830, 1), (1840, 0), (1850, 1), (1860, 0), (1870, 0), (1880, 0), (1890, 0), (1900, 0), (1910, 0), (1920, 1), (1930, 1), (1940, 0), (1950, 0), (1960, 1), (1970, 0), (1980, 0), (1990, 1), (2000, 0), (2010, 1), (2020, 0), (2030, 0), (2040, 1), (2050, 1)]
VCSB1 CSB1 0 PWL (0n 3.3v 9.495n 3.3v 9.505n 0.0v 19.495n 0.0v 19.505n 0.0v 29.495n 0.0v 29.505n 0.0v 39.495n 0.0v 39.505n 0.0v 49.495n 0.0v 49.505n 0.0v 59.495n 0.0v 59.505n 3.3v 69.495n 3.3v 69.505n 0.0v 79.495n 0.0v 79.505n 0.0v 89.495n 0.0v 89.505n 3.3v 99.495n 3.3v 99.505n 0.0v 109.495n 0.0v 109.505n 3.3v 119.495n 3.3v 119.505n 0.0v 129.495n 0.0v 129.505n 0.0v 139.495n 0.0v 139.505n 0.0v 149.495n 0.0v 149.505n 3.3v 159.495n 3.3v 159.505n 3.3v 169.495n 3.3v 169.505n 0.0v 179.495n 0.0v 179.505n 0.0v 189.495n 0.0v 189.505n 0.0v 199.495n 0.0v 199.505n 3.3v 209.495n 3.3v 209.505n 3.3v 219.495n 3.3v 219.505n 3.3v 229.495n 3.3v 229.505n 0.0v 239.495n 0.0v 239.505n 0.0v 249.495n 0.0v 249.505n 0.0v 259.495n 0.0v 259.505n 3.3v 269.495n 3.3v 269.505n 3.3v 279.495n 3.3v 279.505n 0.0v 289.495n 0.0v 289.505n 3.3v 299.495n 3.3v 299.505n 3.3v 309.495n 3.3v 309.505n 3.3v 319.495n 3.3v 319.505n 3.3v 329.495n 3.3v 329.505n 3.3v 339.495n 3.3v 339.505n 3.3v 349.495n 3.3v 349.505n 0.0v 359.495n 0.0v 359.505n 3.3v 369.495n 3.3v 369.505n 0.0v 379.495n 0.0v 379.505n 0.0v 389.495n 0.0v 389.505n 3.3v 399.495n 3.3v 399.505n 0.0v 409.495n 0.0v 409.505n 0.0v 419.495n 0.0v 419.505n 3.3v 429.495n 3.3v 429.505n 3.3v 439.495n 3.3v 439.505n 0.0v 449.495n 0.0v 449.505n 0.0v 459.495n 0.0v 459.505n 0.0v 469.495n 0.0v 469.505n 3.3v 479.495n 3.3v 479.505n 0.0v 489.495n 0.0v 489.505n 0.0v 499.495n 0.0v 499.505n 0.0v 509.495n 0.0v 509.505n 0.0v 519.495n 0.0v 519.505n 0.0v 529.495n 0.0v 529.505n 3.3v 539.495n 3.3v 539.505n 3.3v 549.495n 3.3v 549.505n 0.0v 559.495n 0.0v 559.505n 3.3v 569.495n 3.3v 569.505n 0.0v 579.495n 0.0v 579.505n 3.3v 589.495n 3.3v 589.505n 0.0v 599.495n 0.0v 599.505n 0.0v 609.495n 0.0v 609.505n 3.3v 619.495n 3.3v 619.505n 0.0v 629.495n 0.0v 629.505n 3.3v 639.495n 3.3v 639.505n 0.0v 649.495n 0.0v 649.505n 0.0v 659.495n 0.0v 659.505n 0.0v 669.495n 0.0v 669.505n 0.0v 679.495n 0.0v 679.505n 0.0v 689.495n 0.0v 689.505n 3.3v 699.495n 3.3v 699.505n 3.3v 709.495n 3.3v 709.505n 0.0v 719.495n 0.0v 719.505n 0.0v 729.495n 0.0v 729.505n 0.0v 739.495n 0.0v 739.505n 0.0v 749.495n 0.0v 749.505n 0.0v 759.495n 0.0v 759.505n 0.0v 769.495n 0.0v 769.505n 0.0v 779.495n 0.0v 779.505n 3.3v 789.495n 3.3v 789.505n 0.0v 799.495n 0.0v 799.505n 0.0v 809.495n 0.0v 809.505n 0.0v 819.495n 0.0v 819.505n 0.0v 829.495n 0.0v 829.505n 0.0v 839.495n 0.0v 839.505n 3.3v 849.495n 3.3v 849.505n 3.3v 859.495n 3.3v 859.505n 0.0v 869.495n 0.0v 869.505n 0.0v 879.495n 0.0v 879.505n 0.0v 889.495n 0.0v 889.505n 3.3v 899.495n 3.3v 899.505n 0.0v 909.495n 0.0v 909.505n 0.0v 919.495n 0.0v 919.505n 0.0v 929.495n 0.0v 929.505n 0.0v 939.495n 0.0v 939.505n 0.0v 949.495n 0.0v 949.505n 0.0v 959.495n 0.0v 959.505n 0.0v 969.495n 0.0v 969.505n 3.3v 979.495n 3.3v 979.505n 0.0v 989.495n 0.0v 989.505n 3.3v 999.495n 3.3v 999.505n 3.3v 1009.495n 3.3v 1009.505n 3.3v 1019.495n 3.3v 1019.505n 3.3v 1029.495n 3.3v 1029.505n 0.0v 1039.495n 0.0v 1039.505n 0.0v 1049.495n 0.0v 1049.505n 0.0v 1059.495n 0.0v 1059.505n 0.0v 1069.495n 0.0v 1069.505n 3.3v 1079.495n 3.3v 1079.505n 0.0v 1089.495n 0.0v 1089.505n 0.0v 1099.495n 0.0v 1099.505n 0.0v 1109.495n 0.0v 1109.505n 0.0v 1119.495n 0.0v 1119.505n 0.0v 1129.495n 0.0v 1129.505n 0.0v 1139.495n 0.0v 1139.505n 0.0v 1149.495n 0.0v 1149.505n 0.0v 1159.495n 0.0v 1159.505n 3.3v 1169.495n 3.3v 1169.505n 0.0v 1179.495n 0.0v 1179.505n 3.3v 1189.495n 3.3v 1189.505n 0.0v 1199.495n 0.0v 1199.505n 0.0v 1209.495n 0.0v 1209.505n 0.0v 1219.495n 0.0v 1219.505n 0.0v 1229.495n 0.0v 1229.505n 3.3v 1239.495n 3.3v 1239.505n 3.3v 1249.495n 3.3v 1249.505n 0.0v 1259.495n 0.0v 1259.505n 3.3v 1269.495n 3.3v 1269.505n 0.0v 1279.495n 0.0v 1279.505n 3.3v 1289.495n 3.3v 1289.505n 3.3v 1299.495n 3.3v 1299.505n 0.0v 1309.495n 0.0v 1309.505n 0.0v 1319.495n 0.0v 1319.505n 0.0v 1329.495n 0.0v 1329.505n 0.0v 1339.495n 0.0v 1339.505n 0.0v 1349.495n 0.0v 1349.505n 3.3v 1359.495n 3.3v 1359.505n 3.3v 1369.495n 3.3v 1369.505n 0.0v 1379.495n 0.0v 1379.505n 3.3v 1389.495n 3.3v 1389.505n 0.0v 1399.495n 0.0v 1399.505n 0.0v 1409.495n 0.0v 1409.505n 0.0v 1419.495n 0.0v 1419.505n 0.0v 1429.495n 0.0v 1429.505n 3.3v 1439.495n 3.3v 1439.505n 0.0v 1449.495n 0.0v 1449.505n 0.0v 1459.495n 0.0v 1459.505n 3.3v 1469.495n 3.3v 1469.505n 0.0v 1479.495n 0.0v 1479.505n 0.0v 1489.495n 0.0v 1489.505n 0.0v 1499.495n 0.0v 1499.505n 3.3v 1509.495n 3.3v 1509.505n 3.3v 1519.495n 3.3v 1519.505n 3.3v 1529.495n 3.3v 1529.505n 3.3v 1539.495n 3.3v 1539.505n 0.0v 1549.495n 0.0v 1549.505n 0.0v 1559.495n 0.0v 1559.505n 0.0v 1569.495n 0.0v 1569.505n 3.3v 1579.495n 3.3v 1579.505n 0.0v 1589.495n 0.0v 1589.505n 0.0v 1599.495n 0.0v 1599.505n 0.0v 1609.495n 0.0v 1609.505n 0.0v 1619.495n 0.0v 1619.505n 3.3v 1629.495n 3.3v 1629.505n 0.0v 1639.495n 0.0v 1639.505n 0.0v 1649.495n 0.0v 1649.505n 0.0v 1659.495n 0.0v 1659.505n 3.3v 1669.495n 3.3v 1669.505n 0.0v 1679.495n 0.0v 1679.505n 0.0v 1689.495n 0.0v 1689.505n 3.3v 1699.495n 3.3v 1699.505n 3.3v 1709.495n 3.3v 1709.505n 3.3v 1719.495n 3.3v 1719.505n 0.0v 1729.495n 0.0v 1729.505n 0.0v 1739.495n 0.0v 1739.505n 0.0v 1749.495n 0.0v 1749.505n 0.0v 1759.495n 0.0v 1759.505n 0.0v 1769.495n 0.0v 1769.505n 0.0v 1779.495n 0.0v 1779.505n 3.3v 1789.495n 3.3v 1789.505n 3.3v 1799.495n 3.3v 1799.505n 0.0v 1809.495n 0.0v 1809.505n 0.0v 1819.495n 0.0v 1819.505n 0.0v 1829.495n 0.0v 1829.505n 3.3v 1839.495n 3.3v 1839.505n 0.0v 1849.495n 0.0v 1849.505n 3.3v 1859.495n 3.3v 1859.505n 0.0v 1869.495n 0.0v 1869.505n 0.0v 1879.495n 0.0v 1879.505n 0.0v 1889.495n 0.0v 1889.505n 0.0v 1899.495n 0.0v 1899.505n 0.0v 1909.495n 0.0v 1909.505n 0.0v 1919.495n 0.0v 1919.505n 3.3v 1929.495n 3.3v 1929.505n 3.3v 1939.495n 3.3v 1939.505n 0.0v 1949.495n 0.0v 1949.505n 0.0v 1959.495n 0.0v 1959.505n 3.3v 1969.495n 3.3v 1969.505n 0.0v 1979.495n 0.0v 1979.505n 0.0v 1989.495n 0.0v 1989.505n 3.3v 1999.495n 3.3v 1999.505n 0.0v 2009.495n 0.0v 2009.505n 3.3v 2019.495n 3.3v 2019.505n 0.0v 2029.495n 0.0v 2029.505n 0.0v 2039.495n 0.0v 2039.505n 3.3v 2049.495n 3.3v 2049.505n 3.3v )
* (time, data): [(0, 1), (10, 0), (20, 0), (30, 0), (40, 1), (50, 1), (60, 0), (70, 1), (80, 1), (90, 1), (100, 0), (110, 1), (120, 1), (130, 1), (140, 1), (150, 1), (160, 0), (170, 1), (180, 1), (190, 1), (200, 1), (210, 1), (220, 0), (230, 1), (240, 1), (250, 1), (260, 0), (270, 0), (280, 0), (290, 0), (300, 1), (310, 0), (320, 1), (330, 0), (340, 0), (350, 1), (360, 1), (370, 1), (380, 1), (390, 0), (400, 1), (410, 1), (420, 0), (430, 0), (440, 1), (450, 1), (460, 0), (470, 0), (480, 1), (490, 1), (500, 1), (510, 1), (520, 1), (530, 0), (540, 0), (550, 1), (560, 0), (570, 1), (580, 0), (590, 1), (600, 1), (610, 0), (620, 1), (630, 1), (640, 1), (650, 1), (660, 1), (670, 1), (680, 1), (690, 1), (700, 1), (710, 0), (720, 1), (730, 1), (740, 1), (750, 1), (760, 1), (770, 1), (780, 0), (790, 0), (800, 1), (810, 1), (820, 1), (830, 1), (840, 1), (850, 0), (860, 1), (870, 1), (880, 1), (890, 1), (900, 1), (910, 1), (920, 1), (930, 1), (940, 1), (950, 1), (960, 1), (970, 1), (980, 1), (990, 0), (1000, 0), (1010, 0), (1020, 0), (1030, 1), (1040, 1), (1050, 0), (1060, 1), (1070, 0), (1080, 1), (1090, 1), (1100, 1), (1110, 1), (1120, 1), (1130, 1), (1140, 1), (1150, 0), (1160, 1), (1170, 1), (1180, 1), (1190, 1), (1200, 1), (1210, 1), (1220, 1), (1230, 1), (1240, 0), (1250, 1), (1260, 0), (1270, 1), (1280, 0), (1290, 0), (1300, 1), (1310, 1), (1320, 1), (1330, 1), (1340, 0), (1350, 1), (1360, 0), (1370, 0), (1380, 1), (1390, 1), (1400, 1), (1410, 1), (1420, 1), (1430, 1), (1440, 1), (1450, 1), (1460, 0), (1470, 1), (1480, 1), (1490, 1), (1500, 0), (1510, 1), (1520, 1), (1530, 0), (1540, 1), (1550, 1), (1560, 1), (1570, 1), (1580, 1), (1590, 1), (1600, 1), (1610, 1), (1620, 1), (1630, 1), (1640, 1), (1650, 1), (1660, 0), (1670, 1), (1680, 1), (1690, 1), (1700, 1), (1710, 0), (1720, 1), (1730, 1), (1740, 1), (1750, 1), (1760, 1), (1770, 1), (1780, 0), (1790, 0), (1800, 1), (1810, 1), (1820, 0), (1830, 1), (1840, 1), (1850, 0), (1860, 1), (1870, 1), (1880, 0), (1890, 1), (1900, 0), (1910, 1), (1920, 1), (1930, 1), (1940, 1), (1950, 1), (1960, 0), (1970, 1), (1980, 1), (1990, 0), (2000, 1), (2010, 1), (2020, 1), (2030, 1), (2040, 1), (2050, 1)]
VWEB0 WEB0 0 PWL (0n 3.3v 9.495n 3.3v 9.505n 0.0v 19.495n 0.0v 19.505n 0.0v 29.495n 0.0v 29.505n 0.0v 39.495n 0.0v 39.505n 3.3v 49.495n 3.3v 49.505n 3.3v 59.495n 3.3v 59.505n 0.0v 69.495n 0.0v 69.505n 3.3v 79.495n 3.3v 79.505n 3.3v 89.495n 3.3v 89.505n 3.3v 99.495n 3.3v 99.505n 0.0v 109.495n 0.0v 109.505n 3.3v 119.495n 3.3v 119.505n 3.3v 129.495n 3.3v 129.505n 3.3v 139.495n 3.3v 139.505n 3.3v 149.495n 3.3v 149.505n 3.3v 159.495n 3.3v 159.505n 0.0v 169.495n 0.0v 169.505n 3.3v 179.495n 3.3v 179.505n 3.3v 189.495n 3.3v 189.505n 3.3v 199.495n 3.3v 199.505n 3.3v 209.495n 3.3v 209.505n 3.3v 219.495n 3.3v 219.505n 0.0v 229.495n 0.0v 229.505n 3.3v 239.495n 3.3v 239.505n 3.3v 249.495n 3.3v 249.505n 3.3v 259.495n 3.3v 259.505n 0.0v 269.495n 0.0v 269.505n 0.0v 279.495n 0.0v 279.505n 0.0v 289.495n 0.0v 289.505n 0.0v 299.495n 0.0v 299.505n 3.3v 309.495n 3.3v 309.505n 0.0v 319.495n 0.0v 319.505n 3.3v 329.495n 3.3v 329.505n 0.0v 339.495n 0.0v 339.505n 0.0v 349.495n 0.0v 349.505n 3.3v 359.495n 3.3v 359.505n 3.3v 369.495n 3.3v 369.505n 3.3v 379.495n 3.3v 379.505n 3.3v 389.495n 3.3v 389.505n 0.0v 399.495n 0.0v 399.505n 3.3v 409.495n 3.3v 409.505n 3.3v 419.495n 3.3v 419.505n 0.0v 429.495n 0.0v 429.505n 0.0v 439.495n 0.0v 439.505n 3.3v 449.495n 3.3v 449.505n 3.3v 459.495n 3.3v 459.505n 0.0v 469.495n 0.0v 469.505n 0.0v 479.495n 0.0v 479.505n 3.3v 489.495n 3.3v 489.505n 3.3v 499.495n 3.3v 499.505n 3.3v 509.495n 3.3v 509.505n 3.3v 519.495n 3.3v 519.505n 3.3v 529.495n 3.3v 529.505n 0.0v 539.495n 0.0v 539.505n 0.0v 549.495n 0.0v 549.505n 3.3v 559.495n 3.3v 559.505n 0.0v 569.495n 0.0v 569.505n 3.3v 579.495n 3.3v 579.505n 0.0v 589.495n 0.0v 589.505n 3.3v 599.495n 3.3v 599.505n 3.3v 609.495n 3.3v 609.505n 0.0v 619.495n 0.0v 619.505n 3.3v 629.495n 3.3v 629.505n 3.3v 639.495n 3.3v 639.505n 3.3v 649.495n 3.3v 649.505n 3.3v 659.495n 3.3v 659.505n 3.3v 669.495n 3.3v 669.505n 3.3v 679.495n 3.3v 679.505n 3.3v 689.495n 3.3v 689.505n 3.3v 699.495n 3.3v 699.505n 3.3v 709.495n 3.3v 709.505n 0.0v 719.495n 0.0v 719.505n 3.3v 729.495n 3.3v 729.505n 3.3v 739.495n 3.3v 739.505n 3.3v 749.495n 3.3v 749.505n 3.3v 759.495n 3.3v 759.505n 3.3v 769.495n 3.3v 769.505n 3.3v 779.495n 3.3v 779.505n 0.0v 789.495n 0.0v 789.505n 0.0v 799.495n 0.0v 799.505n 3.3v 809.495n 3.3v 809.505n 3.3v 819.495n 3.3v 819.505n 3.3v 829.495n 3.3v 829.505n 3.3v 839.495n 3.3v 839.505n 3.3v 849.495n 3.3v 849.505n 0.0v 859.495n 0.0v 859.505n 3.3v 869.495n 3.3v 869.505n 3.3v 879.495n 3.3v 879.505n 3.3v 889.495n 3.3v 889.505n 3.3v 899.495n 3.3v 899.505n 3.3v 909.495n 3.3v 909.505n 3.3v 919.495n 3.3v 919.505n 3.3v 929.495n 3.3v 929.505n 3.3v 939.495n 3.3v 939.505n 3.3v 949.495n 3.3v 949.505n 3.3v 959.495n 3.3v 959.505n 3.3v 969.495n 3.3v 969.505n 3.3v 979.495n 3.3v 979.505n 3.3v 989.495n 3.3v 989.505n 0.0v 999.495n 0.0v 999.505n 0.0v 1009.495n 0.0v 1009.505n 0.0v 1019.495n 0.0v 1019.505n 0.0v 1029.495n 0.0v 1029.505n 3.3v 1039.495n 3.3v 1039.505n 3.3v 1049.495n 3.3v 1049.505n 0.0v 1059.495n 0.0v 1059.505n 3.3v 1069.495n 3.3v 1069.505n 0.0v 1079.495n 0.0v 1079.505n 3.3v 1089.495n 3.3v 1089.505n 3.3v 1099.495n 3.3v 1099.505n 3.3v 1109.495n 3.3v 1109.505n 3.3v 1119.495n 3.3v 1119.505n 3.3v 1129.495n 3.3v 1129.505n 3.3v 1139.495n 3.3v 1139.505n 3.3v 1149.495n 3.3v 1149.505n 0.0v 1159.495n 0.0v 1159.505n 3.3v 1169.495n 3.3v 1169.505n 3.3v 1179.495n 3.3v 1179.505n 3.3v 1189.495n 3.3v 1189.505n 3.3v 1199.495n 3.3v 1199.505n 3.3v 1209.495n 3.3v 1209.505n 3.3v 1219.495n 3.3v 1219.505n 3.3v 1229.495n 3.3v 1229.505n 3.3v 1239.495n 3.3v 1239.505n 0.0v 1249.495n 0.0v 1249.505n 3.3v 1259.495n 3.3v 1259.505n 0.0v 1269.495n 0.0v 1269.505n 3.3v 1279.495n 3.3v 1279.505n 0.0v 1289.495n 0.0v 1289.505n 0.0v 1299.495n 0.0v 1299.505n 3.3v 1309.495n 3.3v 1309.505n 3.3v 1319.495n 3.3v 1319.505n 3.3v 1329.495n 3.3v 1329.505n 3.3v 1339.495n 3.3v 1339.505n 0.0v 1349.495n 0.0v 1349.505n 3.3v 1359.495n 3.3v 1359.505n 0.0v 1369.495n 0.0v 1369.505n 0.0v 1379.495n 0.0v 1379.505n 3.3v 1389.495n 3.3v 1389.505n 3.3v 1399.495n 3.3v 1399.505n 3.3v 1409.495n 3.3v 1409.505n 3.3v 1419.495n 3.3v 1419.505n 3.3v 1429.495n 3.3v 1429.505n 3.3v 1439.495n 3.3v 1439.505n 3.3v 1449.495n 3.3v 1449.505n 3.3v 1459.495n 3.3v 1459.505n 0.0v 1469.495n 0.0v 1469.505n 3.3v 1479.495n 3.3v 1479.505n 3.3v 1489.495n 3.3v 1489.505n 3.3v 1499.495n 3.3v 1499.505n 0.0v 1509.495n 0.0v 1509.505n 3.3v 1519.495n 3.3v 1519.505n 3.3v 1529.495n 3.3v 1529.505n 0.0v 1539.495n 0.0v 1539.505n 3.3v 1549.495n 3.3v 1549.505n 3.3v 1559.495n 3.3v 1559.505n 3.3v 1569.495n 3.3v 1569.505n 3.3v 1579.495n 3.3v 1579.505n 3.3v 1589.495n 3.3v 1589.505n 3.3v 1599.495n 3.3v 1599.505n 3.3v 1609.495n 3.3v 1609.505n 3.3v 1619.495n 3.3v 1619.505n 3.3v 1629.495n 3.3v 1629.505n 3.3v 1639.495n 3.3v 1639.505n 3.3v 1649.495n 3.3v 1649.505n 3.3v 1659.495n 3.3v 1659.505n 0.0v 1669.495n 0.0v 1669.505n 3.3v 1679.495n 3.3v 1679.505n 3.3v 1689.495n 3.3v 1689.505n 3.3v 1699.495n 3.3v 1699.505n 3.3v 1709.495n 3.3v 1709.505n 0.0v 1719.495n 0.0v 1719.505n 3.3v 1729.495n 3.3v 1729.505n 3.3v 1739.495n 3.3v 1739.505n 3.3v 1749.495n 3.3v 1749.505n 3.3v 1759.495n 3.3v 1759.505n 3.3v 1769.495n 3.3v 1769.505n 3.3v 1779.495n 3.3v 1779.505n 0.0v 1789.495n 0.0v 1789.505n 0.0v 1799.495n 0.0v 1799.505n 3.3v 1809.495n 3.3v 1809.505n 3.3v 1819.495n 3.3v 1819.505n 0.0v 1829.495n 0.0v 1829.505n 3.3v 1839.495n 3.3v 1839.505n 3.3v 1849.495n 3.3v 1849.505n 0.0v 1859.495n 0.0v 1859.505n 3.3v 1869.495n 3.3v 1869.505n 3.3v 1879.495n 3.3v 1879.505n 0.0v 1889.495n 0.0v 1889.505n 3.3v 1899.495n 3.3v 1899.505n 0.0v 1909.495n 0.0v 1909.505n 3.3v 1919.495n 3.3v 1919.505n 3.3v 1929.495n 3.3v 1929.505n 3.3v 1939.495n 3.3v 1939.505n 3.3v 1949.495n 3.3v 1949.505n 3.3v 1959.495n 3.3v 1959.505n 0.0v 1969.495n 0.0v 1969.505n 3.3v 1979.495n 3.3v 1979.505n 3.3v 1989.495n 3.3v 1989.505n 0.0v 1999.495n 0.0v 1999.505n 3.3v 2009.495n 3.3v 2009.505n 3.3v 2019.495n 3.3v 2019.505n 3.3v 2029.495n 3.3v 2029.505n 3.3v 2039.495n 3.3v 2039.505n 3.3v 2049.495n 3.3v 2049.505n 3.3v )
* (time, data): [(0, 1), (10, 0), (20, 0), (30, 0), (40, 1), (50, 1), (60, 1), (70, 0), (80, 0), (90, 1), (100, 1), (110, 1), (120, 0), (130, 1), (140, 0), (150, 1), (160, 1), (170, 0), (180, 1), (190, 1), (200, 1), (210, 1), (220, 1), (230, 1), (240, 0), (250, 1), (260, 1), (270, 1), (280, 1), (290, 1), (300, 1), (310, 1), (320, 1), (330, 1), (340, 1), (350, 1), (360, 1), (370, 0), (380, 0), (390, 1), (400, 0), (410, 1), (420, 1), (430, 1), (440, 1), (450, 1), (460, 1), (470, 1), (480, 1), (490, 1), (500, 0), (510, 1), (520, 1), (530, 1), (540, 1), (550, 1), (560, 1), (570, 1), (580, 1), (590, 1), (600, 1), (610, 1), (620, 1), (630, 1), (640, 1), (650, 1), (660, 0), (670, 1), (680, 0), (690, 1), (700, 1), (710, 0), (720, 0), (730, 1), (740, 1), (750, 1), (760, 1), (770, 1), (780, 1), (790, 1), (800, 1), (810, 1), (820, 1), (830, 1), (840, 1), (850, 1), (860, 0), (870, 0), (880, 1), (890, 1), (900, 1), (910, 1), (920, 1), (930, 1), (940, 0), (950, 0), (960, 1), (970, 1), (980, 1), (990, 1), (1000, 1), (1010, 1), (1020, 1), (1030, 1), (1040, 0), (1050, 0), (1060, 1), (1070, 1), (1080, 1), (1090, 1), (1100, 0), (1110, 0), (1120, 1), (1130, 1), (1140, 0), (1150, 1), (1160, 1), (1170, 1), (1180, 1), (1190, 1), (1200, 1), (1210, 0), (1220, 1), (1230, 1), (1240, 1), (1250, 0), (1260, 1), (1270, 1), (1280, 1), (1290, 1), (1300, 1), (1310, 0), (1320, 1), (1330, 1), (1340, 1), (1350, 1), (1360, 1), (1370, 1), (1380, 1), (1390, 1), (1400, 1), (1410, 1), (1420, 1), (1430, 1), (1440, 0), (1450, 1), (1460, 1), (1470, 1), (1480, 1), (1490, 0), (1500, 1), (1510, 1), (1520, 1), (1530, 1), (1540, 1), (1550, 0), (1560, 0), (1570, 1), (1580, 1), (1590, 1), (1600, 0), (1610, 1), (1620, 1), (1630, 1), (1640, 1), (1650, 1), (1660, 1), (1670, 1), (1680, 1), (1690, 1), (1700, 1), (1710, 1), (1720, 1), (1730, 0), (1740, 1), (1750, 0), (1760, 1), (1770, 0), (1780, 1), (1790, 1), (1800, 1), (1810, 1), (1820, 0), (1830, 1), (1840, 1), (1850, 1), (1860, 0), (1870, 1), (1880, 0), (1890, 1), (1900, 1), (1910, 0), (1920, 1), (1930, 1), (1940, 0), (1950, 1), (1960, 1), (1970, 1), (1980, 0), (1990, 1), (2000, 0), (2010, 1), (2020, 0), (2030, 0), (2040, 1), (2050, 1)]
VWEB1 WEB1 0 PWL (0n 3.3v 9.495n 3.3v 9.505n 0.0v 19.495n 0.0v 19.505n 0.0v 29.495n 0.0v 29.505n 0.0v 39.495n 0.0v 39.505n 3.3v 49.495n 3.3v 49.505n 3.3v 59.495n 3.3v 59.505n 3.3v 69.495n 3.3v 69.505n 0.0v 79.495n 0.0v 79.505n 0.0v 89.495n 0.0v 89.505n 3.3v 99.495n 3.3v 99.505n 3.3v 109.495n 3.3v 109.505n 3.3v 119.495n 3.3v 119.505n 0.0v 129.495n 0.0v 129.505n 3.3v 139.495n 3.3v 139.505n 0.0v 149.495n 0.0v 149.505n 3.3v 159.495n 3.3v 159.505n 3.3v 169.495n 3.3v 169.505n 0.0v 179.495n 0.0v 179.505n 3.3v 189.495n 3.3v 189.505n 3.3v 199.495n 3.3v 199.505n 3.3v 209.495n 3.3v 209.505n 3.3v 219.495n 3.3v 219.505n 3.3v 229.495n 3.3v 229.505n 3.3v 239.495n 3.3v 239.505n 0.0v 249.495n 0.0v 249.505n 3.3v 259.495n 3.3v 259.505n 3.3v 269.495n 3.3v 269.505n 3.3v 279.495n 3.3v 279.505n 3.3v 289.495n 3.3v 289.505n 3.3v 299.495n 3.3v 299.505n 3.3v 309.495n 3.3v 309.505n 3.3v 319.495n 3.3v 319.505n 3.3v 329.495n 3.3v 329.505n 3.3v 339.495n 3.3v 339.505n 3.3v 349.495n 3.3v 349.505n 3.3v 359.495n 3.3v 359.505n 3.3v 369.495n 3.3v 369.505n 0.0v 379.495n 0.0v 379.505n 0.0v 389.495n 0.0v 389.505n 3.3v 399.495n 3.3v 399.505n 0.0v 409.495n 0.0v 409.505n 3.3v 419.495n 3.3v 419.505n 3.3v 429.495n 3.3v 429.505n 3.3v 439.495n 3.3v 439.505n 3.3v 449.495n 3.3v 449.505n 3.3v 459.495n 3.3v 459.505n 3.3v 469.495n 3.3v 469.505n 3.3v 479.495n 3.3v 479.505n 3.3v 489.495n 3.3v 489.505n 3.3v 499.495n 3.3v 499.505n 0.0v 509.495n 0.0v 509.505n 3.3v 519.495n 3.3v 519.505n 3.3v 529.495n 3.3v 529.505n 3.3v 539.495n 3.3v 539.505n 3.3v 549.495n 3.3v 549.505n 3.3v 559.495n 3.3v 559.505n 3.3v 569.495n 3.3v 569.505n 3.3v 579.495n 3.3v 579.505n 3.3v 589.495n 3.3v 589.505n 3.3v 599.495n 3.3v 599.505n 3.3v 609.495n 3.3v 609.505n 3.3v 619.495n 3.3v 619.505n 3.3v 629.495n 3.3v 629.505n 3.3v 639.495n 3.3v 639.505n 3.3v 649.495n 3.3v 649.505n 3.3v 659.495n 3.3v 659.505n 0.0v 669.495n 0.0v 669.505n 3.3v 679.495n 3.3v 679.505n 0.0v 689.495n 0.0v 689.505n 3.3v 699.495n 3.3v 699.505n 3.3v 709.495n 3.3v 709.505n 0.0v 719.495n 0.0v 719.505n 0.0v 729.495n 0.0v 729.505n 3.3v 739.495n 3.3v 739.505n 3.3v 749.495n 3.3v 749.505n 3.3v 759.495n 3.3v 759.505n 3.3v 769.495n 3.3v 769.505n 3.3v 779.495n 3.3v 779.505n 3.3v 789.495n 3.3v 789.505n 3.3v 799.495n 3.3v 799.505n 3.3v 809.495n 3.3v 809.505n 3.3v 819.495n 3.3v 819.505n 3.3v 829.495n 3.3v 829.505n 3.3v 839.495n 3.3v 839.505n 3.3v 849.495n 3.3v 849.505n 3.3v 859.495n 3.3v 859.505n 0.0v 869.495n 0.0v 869.505n 0.0v 879.495n 0.0v 879.505n 3.3v 889.495n 3.3v 889.505n 3.3v 899.495n 3.3v 899.505n 3.3v 909.495n 3.3v 909.505n 3.3v 919.495n 3.3v 919.505n 3.3v 929.495n 3.3v 929.505n 3.3v 939.495n 3.3v 939.505n 0.0v 949.495n 0.0v 949.505n 0.0v 959.495n 0.0v 959.505n 3.3v 969.495n 3.3v 969.505n 3.3v 979.495n 3.3v 979.505n 3.3v 989.495n 3.3v 989.505n 3.3v 999.495n 3.3v 999.505n 3.3v 1009.495n 3.3v 1009.505n 3.3v 1019.495n 3.3v 1019.505n 3.3v 1029.495n 3.3v 1029.505n 3.3v 1039.495n 3.3v 1039.505n 0.0v 1049.495n 0.0v 1049.505n 0.0v 1059.495n 0.0v 1059.505n 3.3v 1069.495n 3.3v 1069.505n 3.3v 1079.495n 3.3v 1079.505n 3.3v 1089.495n 3.3v 1089.505n 3.3v 1099.495n 3.3v 1099.505n 0.0v 1109.495n 0.0v 1109.505n 0.0v 1119.495n 0.0v 1119.505n 3.3v 1129.495n 3.3v 1129.505n 3.3v 1139.495n 3.3v 1139.505n 0.0v 1149.495n 0.0v 1149.505n 3.3v 1159.495n 3.3v 1159.505n 3.3v 1169.495n 3.3v 1169.505n 3.3v 1179.495n 3.3v 1179.505n 3.3v 1189.495n 3.3v 1189.505n 3.3v 1199.495n 3.3v 1199.505n 3.3v 1209.495n 3.3v 1209.505n 0.0v 1219.495n 0.0v 1219.505n 3.3v 1229.495n 3.3v 1229.505n 3.3v 1239.495n 3.3v 1239.505n 3.3v 1249.495n 3.3v 1249.505n 0.0v 1259.495n 0.0v 1259.505n 3.3v 1269.495n 3.3v 1269.505n 3.3v 1279.495n 3.3v 1279.505n 3.3v 1289.495n 3.3v 1289.505n 3.3v 1299.495n 3.3v 1299.505n 3.3v 1309.495n 3.3v 1309.505n 0.0v 1319.495n 0.0v 1319.505n 3.3v 1329.495n 3.3v 1329.505n 3.3v 1339.495n 3.3v 1339.505n 3.3v 1349.495n 3.3v 1349.505n 3.3v 1359.495n 3.3v 1359.505n 3.3v 1369.495n 3.3v 1369.505n 3.3v 1379.495n 3.3v 1379.505n 3.3v 1389.495n 3.3v 1389.505n 3.3v 1399.495n 3.3v 1399.505n 3.3v 1409.495n 3.3v 1409.505n 3.3v 1419.495n 3.3v 1419.505n 3.3v 1429.495n 3.3v 1429.505n 3.3v 1439.495n 3.3v 1439.505n 0.0v 1449.495n 0.0v 1449.505n 3.3v 1459.495n 3.3v 1459.505n 3.3v 1469.495n 3.3v 1469.505n 3.3v 1479.495n 3.3v 1479.505n 3.3v 1489.495n 3.3v 1489.505n 0.0v 1499.495n 0.0v 1499.505n 3.3v 1509.495n 3.3v 1509.505n 3.3v 1519.495n 3.3v 1519.505n 3.3v 1529.495n 3.3v 1529.505n 3.3v 1539.495n 3.3v 1539.505n 3.3v 1549.495n 3.3v 1549.505n 0.0v 1559.495n 0.0v 1559.505n 0.0v 1569.495n 0.0v 1569.505n 3.3v 1579.495n 3.3v 1579.505n 3.3v 1589.495n 3.3v 1589.505n 3.3v 1599.495n 3.3v 1599.505n 0.0v 1609.495n 0.0v 1609.505n 3.3v 1619.495n 3.3v 1619.505n 3.3v 1629.495n 3.3v 1629.505n 3.3v 1639.495n 3.3v 1639.505n 3.3v 1649.495n 3.3v 1649.505n 3.3v 1659.495n 3.3v 1659.505n 3.3v 1669.495n 3.3v 1669.505n 3.3v 1679.495n 3.3v 1679.505n 3.3v 1689.495n 3.3v 1689.505n 3.3v 1699.495n 3.3v 1699.505n 3.3v 1709.495n 3.3v 1709.505n 3.3v 1719.495n 3.3v 1719.505n 3.3v 1729.495n 3.3v 1729.505n 0.0v 1739.495n 0.0v 1739.505n 3.3v 1749.495n 3.3v 1749.505n 0.0v 1759.495n 0.0v 1759.505n 3.3v 1769.495n 3.3v 1769.505n 0.0v 1779.495n 0.0v 1779.505n 3.3v 1789.495n 3.3v 1789.505n 3.3v 1799.495n 3.3v 1799.505n 3.3v 1809.495n 3.3v 1809.505n 3.3v 1819.495n 3.3v 1819.505n 0.0v 1829.495n 0.0v 1829.505n 3.3v 1839.495n 3.3v 1839.505n 3.3v 1849.495n 3.3v 1849.505n 3.3v 1859.495n 3.3v 1859.505n 0.0v 1869.495n 0.0v 1869.505n 3.3v 1879.495n 3.3v 1879.505n 0.0v 1889.495n 0.0v 1889.505n 3.3v 1899.495n 3.3v 1899.505n 3.3v 1909.495n 3.3v 1909.505n 0.0v 1919.495n 0.0v 1919.505n 3.3v 1929.495n 3.3v 1929.505n 3.3v 1939.495n 3.3v 1939.505n 0.0v 1949.495n 0.0v 1949.505n 3.3v 1959.495n 3.3v 1959.505n 3.3v 1969.495n 3.3v 1969.505n 3.3v 1979.495n 3.3v 1979.505n 0.0v 1989.495n 0.0v 1989.505n 3.3v 1999.495n 3.3v 1999.505n 0.0v 2009.495n 0.0v 2009.505n 3.3v 2019.495n 3.3v 2019.505n 0.0v 2029.495n 0.0v 2029.505n 0.0v 2039.495n 0.0v 2039.505n 3.3v 2049.495n 3.3v 2049.505n 3.3v )
* PULSE: period=10
Vclk0 clk0 0 PULSE (0 3.3 9.995n 0.01n 0.01n 4.99n 10n)
* PULSE: period=10
Vclk1 clk1 0 PULSE (0 3.3 9.995n 0.01n 0.01n 4.99n 10n)

 * Generation of dout measurements
* CHECK dout0_0 vdout0_0ck4 = 3.3 time = 50
* CHECK dout0_1 vdout0_1ck4 = 3.3 time = 50
* CHECK dout0_2 vdout0_2ck4 = 0 time = 50
* CHECK dout0_3 vdout0_3ck4 = 3.3 time = 50
* CHECK dout0_4 vdout0_4ck4 = 3.3 time = 50
* CHECK dout0_5 vdout0_5ck4 = 0 time = 50
* CHECK dout0_6 vdout0_6ck4 = 3.3 time = 50
* CHECK dout0_7 vdout0_7ck4 = 0 time = 50
* CHECK dout0_8 vdout0_8ck4 = 0 time = 50
* CHECK dout0_9 vdout0_9ck4 = 3.3 time = 50
* CHECK dout0_10 vdout0_10ck4 = 3.3 time = 50
* CHECK dout0_11 vdout0_11ck4 = 3.3 time = 50
* CHECK dout0_12 vdout0_12ck4 = 0 time = 50
* CHECK dout0_13 vdout0_13ck4 = 3.3 time = 50
* CHECK dout0_14 vdout0_14ck4 = 0 time = 50
* CHECK dout0_15 vdout0_15ck4 = 3.3 time = 50
* CHECK dout0_16 vdout0_16ck4 = 0 time = 50
* CHECK dout0_17 vdout0_17ck4 = 0 time = 50
* CHECK dout0_18 vdout0_18ck4 = 0 time = 50
* CHECK dout0_19 vdout0_19ck4 = 3.3 time = 50
* CHECK dout0_20 vdout0_20ck4 = 0 time = 50
* CHECK dout0_21 vdout0_21ck4 = 0 time = 50
* CHECK dout0_22 vdout0_22ck4 = 3.3 time = 50
* CHECK dout0_23 vdout0_23ck4 = 0 time = 50
* CHECK dout0_24 vdout0_24ck4 = 0 time = 50
* CHECK dout0_25 vdout0_25ck4 = 0 time = 50
* CHECK dout0_26 vdout0_26ck4 = 3.3 time = 50
* CHECK dout0_27 vdout0_27ck4 = 0 time = 50
* CHECK dout0_28 vdout0_28ck4 = 3.3 time = 50
* CHECK dout0_29 vdout0_29ck4 = 3.3 time = 50
* CHECK dout0_30 vdout0_30ck4 = 0 time = 50
* CHECK dout0_31 vdout0_31ck4 = 0 time = 50
* CHECK dout1_0 vdout1_0ck4 = 3.3 time = 50
* CHECK dout1_1 vdout1_1ck4 = 3.3 time = 50
* CHECK dout1_2 vdout1_2ck4 = 0 time = 50
* CHECK dout1_3 vdout1_3ck4 = 3.3 time = 50
* CHECK dout1_4 vdout1_4ck4 = 3.3 time = 50
* CHECK dout1_5 vdout1_5ck4 = 0 time = 50
* CHECK dout1_6 vdout1_6ck4 = 3.3 time = 50
* CHECK dout1_7 vdout1_7ck4 = 0 time = 50
* CHECK dout1_8 vdout1_8ck4 = 0 time = 50
* CHECK dout1_9 vdout1_9ck4 = 3.3 time = 50
* CHECK dout1_10 vdout1_10ck4 = 3.3 time = 50
* CHECK dout1_11 vdout1_11ck4 = 3.3 time = 50
* CHECK dout1_12 vdout1_12ck4 = 0 time = 50
* CHECK dout1_13 vdout1_13ck4 = 3.3 time = 50
* CHECK dout1_14 vdout1_14ck4 = 0 time = 50
* CHECK dout1_15 vdout1_15ck4 = 3.3 time = 50
* CHECK dout1_16 vdout1_16ck4 = 0 time = 50
* CHECK dout1_17 vdout1_17ck4 = 0 time = 50
* CHECK dout1_18 vdout1_18ck4 = 0 time = 50
* CHECK dout1_19 vdout1_19ck4 = 3.3 time = 50
* CHECK dout1_20 vdout1_20ck4 = 0 time = 50
* CHECK dout1_21 vdout1_21ck4 = 0 time = 50
* CHECK dout1_22 vdout1_22ck4 = 3.3 time = 50
* CHECK dout1_23 vdout1_23ck4 = 0 time = 50
* CHECK dout1_24 vdout1_24ck4 = 0 time = 50
* CHECK dout1_25 vdout1_25ck4 = 0 time = 50
* CHECK dout1_26 vdout1_26ck4 = 3.3 time = 50
* CHECK dout1_27 vdout1_27ck4 = 0 time = 50
* CHECK dout1_28 vdout1_28ck4 = 3.3 time = 50
* CHECK dout1_29 vdout1_29ck4 = 3.3 time = 50
* CHECK dout1_30 vdout1_30ck4 = 0 time = 50
* CHECK dout1_31 vdout1_31ck4 = 0 time = 50
* CHECK dout0_0 vdout0_0ck5 = 3.3 time = 60
* CHECK dout0_1 vdout0_1ck5 = 3.3 time = 60
* CHECK dout0_2 vdout0_2ck5 = 0 time = 60
* CHECK dout0_3 vdout0_3ck5 = 3.3 time = 60
* CHECK dout0_4 vdout0_4ck5 = 3.3 time = 60
* CHECK dout0_5 vdout0_5ck5 = 0 time = 60
* CHECK dout0_6 vdout0_6ck5 = 3.3 time = 60
* CHECK dout0_7 vdout0_7ck5 = 0 time = 60
* CHECK dout0_8 vdout0_8ck5 = 0 time = 60
* CHECK dout0_9 vdout0_9ck5 = 3.3 time = 60
* CHECK dout0_10 vdout0_10ck5 = 3.3 time = 60
* CHECK dout0_11 vdout0_11ck5 = 3.3 time = 60
* CHECK dout0_12 vdout0_12ck5 = 0 time = 60
* CHECK dout0_13 vdout0_13ck5 = 3.3 time = 60
* CHECK dout0_14 vdout0_14ck5 = 0 time = 60
* CHECK dout0_15 vdout0_15ck5 = 3.3 time = 60
* CHECK dout0_16 vdout0_16ck5 = 0 time = 60
* CHECK dout0_17 vdout0_17ck5 = 0 time = 60
* CHECK dout0_18 vdout0_18ck5 = 0 time = 60
* CHECK dout0_19 vdout0_19ck5 = 3.3 time = 60
* CHECK dout0_20 vdout0_20ck5 = 0 time = 60
* CHECK dout0_21 vdout0_21ck5 = 0 time = 60
* CHECK dout0_22 vdout0_22ck5 = 3.3 time = 60
* CHECK dout0_23 vdout0_23ck5 = 0 time = 60
* CHECK dout0_24 vdout0_24ck5 = 0 time = 60
* CHECK dout0_25 vdout0_25ck5 = 0 time = 60
* CHECK dout0_26 vdout0_26ck5 = 3.3 time = 60
* CHECK dout0_27 vdout0_27ck5 = 0 time = 60
* CHECK dout0_28 vdout0_28ck5 = 3.3 time = 60
* CHECK dout0_29 vdout0_29ck5 = 3.3 time = 60
* CHECK dout0_30 vdout0_30ck5 = 0 time = 60
* CHECK dout0_31 vdout0_31ck5 = 0 time = 60
* CHECK dout1_0 vdout1_0ck5 = 3.3 time = 60
* CHECK dout1_1 vdout1_1ck5 = 3.3 time = 60
* CHECK dout1_2 vdout1_2ck5 = 0 time = 60
* CHECK dout1_3 vdout1_3ck5 = 3.3 time = 60
* CHECK dout1_4 vdout1_4ck5 = 3.3 time = 60
* CHECK dout1_5 vdout1_5ck5 = 0 time = 60
* CHECK dout1_6 vdout1_6ck5 = 3.3 time = 60
* CHECK dout1_7 vdout1_7ck5 = 0 time = 60
* CHECK dout1_8 vdout1_8ck5 = 0 time = 60
* CHECK dout1_9 vdout1_9ck5 = 3.3 time = 60
* CHECK dout1_10 vdout1_10ck5 = 3.3 time = 60
* CHECK dout1_11 vdout1_11ck5 = 3.3 time = 60
* CHECK dout1_12 vdout1_12ck5 = 0 time = 60
* CHECK dout1_13 vdout1_13ck5 = 3.3 time = 60
* CHECK dout1_14 vdout1_14ck5 = 0 time = 60
* CHECK dout1_15 vdout1_15ck5 = 3.3 time = 60
* CHECK dout1_16 vdout1_16ck5 = 0 time = 60
* CHECK dout1_17 vdout1_17ck5 = 0 time = 60
* CHECK dout1_18 vdout1_18ck5 = 0 time = 60
* CHECK dout1_19 vdout1_19ck5 = 3.3 time = 60
* CHECK dout1_20 vdout1_20ck5 = 0 time = 60
* CHECK dout1_21 vdout1_21ck5 = 0 time = 60
* CHECK dout1_22 vdout1_22ck5 = 3.3 time = 60
* CHECK dout1_23 vdout1_23ck5 = 0 time = 60
* CHECK dout1_24 vdout1_24ck5 = 0 time = 60
* CHECK dout1_25 vdout1_25ck5 = 0 time = 60
* CHECK dout1_26 vdout1_26ck5 = 3.3 time = 60
* CHECK dout1_27 vdout1_27ck5 = 0 time = 60
* CHECK dout1_28 vdout1_28ck5 = 3.3 time = 60
* CHECK dout1_29 vdout1_29ck5 = 3.3 time = 60
* CHECK dout1_30 vdout1_30ck5 = 0 time = 60
* CHECK dout1_31 vdout1_31ck5 = 0 time = 60
* CHECK dout0_0 vdout0_0ck9 = 3.3 time = 100
* CHECK dout0_1 vdout0_1ck9 = 3.3 time = 100
* CHECK dout0_2 vdout0_2ck9 = 3.3 time = 100
* CHECK dout0_3 vdout0_3ck9 = 0 time = 100
* CHECK dout0_4 vdout0_4ck9 = 0 time = 100
* CHECK dout0_5 vdout0_5ck9 = 3.3 time = 100
* CHECK dout0_6 vdout0_6ck9 = 3.3 time = 100
* CHECK dout0_7 vdout0_7ck9 = 3.3 time = 100
* CHECK dout0_8 vdout0_8ck9 = 0 time = 100
* CHECK dout0_9 vdout0_9ck9 = 3.3 time = 100
* CHECK dout0_10 vdout0_10ck9 = 0 time = 100
* CHECK dout0_11 vdout0_11ck9 = 3.3 time = 100
* CHECK dout0_12 vdout0_12ck9 = 3.3 time = 100
* CHECK dout0_13 vdout0_13ck9 = 0 time = 100
* CHECK dout0_14 vdout0_14ck9 = 0 time = 100
* CHECK dout0_15 vdout0_15ck9 = 0 time = 100
* CHECK dout0_16 vdout0_16ck9 = 0 time = 100
* CHECK dout0_17 vdout0_17ck9 = 3.3 time = 100
* CHECK dout0_18 vdout0_18ck9 = 0 time = 100
* CHECK dout0_19 vdout0_19ck9 = 0 time = 100
* CHECK dout0_20 vdout0_20ck9 = 3.3 time = 100
* CHECK dout0_21 vdout0_21ck9 = 0 time = 100
* CHECK dout0_22 vdout0_22ck9 = 0 time = 100
* CHECK dout0_23 vdout0_23ck9 = 0 time = 100
* CHECK dout0_24 vdout0_24ck9 = 0 time = 100
* CHECK dout0_25 vdout0_25ck9 = 0 time = 100
* CHECK dout0_26 vdout0_26ck9 = 3.3 time = 100
* CHECK dout0_27 vdout0_27ck9 = 0 time = 100
* CHECK dout0_28 vdout0_28ck9 = 0 time = 100
* CHECK dout0_29 vdout0_29ck9 = 0 time = 100
* CHECK dout0_30 vdout0_30ck9 = 0 time = 100
* CHECK dout0_31 vdout0_31ck9 = 3.3 time = 100
* CHECK dout1_0 vdout1_0ck10 = 3.3 time = 110
* CHECK dout1_1 vdout1_1ck10 = 3.3 time = 110
* CHECK dout1_2 vdout1_2ck10 = 3.3 time = 110
* CHECK dout1_3 vdout1_3ck10 = 0 time = 110
* CHECK dout1_4 vdout1_4ck10 = 0 time = 110
* CHECK dout1_5 vdout1_5ck10 = 3.3 time = 110
* CHECK dout1_6 vdout1_6ck10 = 3.3 time = 110
* CHECK dout1_7 vdout1_7ck10 = 3.3 time = 110
* CHECK dout1_8 vdout1_8ck10 = 0 time = 110
* CHECK dout1_9 vdout1_9ck10 = 3.3 time = 110
* CHECK dout1_10 vdout1_10ck10 = 0 time = 110
* CHECK dout1_11 vdout1_11ck10 = 3.3 time = 110
* CHECK dout1_12 vdout1_12ck10 = 3.3 time = 110
* CHECK dout1_13 vdout1_13ck10 = 0 time = 110
* CHECK dout1_14 vdout1_14ck10 = 0 time = 110
* CHECK dout1_15 vdout1_15ck10 = 0 time = 110
* CHECK dout1_16 vdout1_16ck10 = 0 time = 110
* CHECK dout1_17 vdout1_17ck10 = 3.3 time = 110
* CHECK dout1_18 vdout1_18ck10 = 0 time = 110
* CHECK dout1_19 vdout1_19ck10 = 0 time = 110
* CHECK dout1_20 vdout1_20ck10 = 3.3 time = 110
* CHECK dout1_21 vdout1_21ck10 = 0 time = 110
* CHECK dout1_22 vdout1_22ck10 = 0 time = 110
* CHECK dout1_23 vdout1_23ck10 = 0 time = 110
* CHECK dout1_24 vdout1_24ck10 = 0 time = 110
* CHECK dout1_25 vdout1_25ck10 = 0 time = 110
* CHECK dout1_26 vdout1_26ck10 = 3.3 time = 110
* CHECK dout1_27 vdout1_27ck10 = 0 time = 110
* CHECK dout1_28 vdout1_28ck10 = 0 time = 110
* CHECK dout1_29 vdout1_29ck10 = 0 time = 110
* CHECK dout1_30 vdout1_30ck10 = 0 time = 110
* CHECK dout1_31 vdout1_31ck10 = 3.3 time = 110
* CHECK dout0_0 vdout0_0ck11 = 3.3 time = 120
* CHECK dout0_1 vdout0_1ck11 = 3.3 time = 120
* CHECK dout0_2 vdout0_2ck11 = 3.3 time = 120
* CHECK dout0_3 vdout0_3ck11 = 0 time = 120
* CHECK dout0_4 vdout0_4ck11 = 0 time = 120
* CHECK dout0_5 vdout0_5ck11 = 3.3 time = 120
* CHECK dout0_6 vdout0_6ck11 = 3.3 time = 120
* CHECK dout0_7 vdout0_7ck11 = 3.3 time = 120
* CHECK dout0_8 vdout0_8ck11 = 0 time = 120
* CHECK dout0_9 vdout0_9ck11 = 3.3 time = 120
* CHECK dout0_10 vdout0_10ck11 = 0 time = 120
* CHECK dout0_11 vdout0_11ck11 = 3.3 time = 120
* CHECK dout0_12 vdout0_12ck11 = 3.3 time = 120
* CHECK dout0_13 vdout0_13ck11 = 0 time = 120
* CHECK dout0_14 vdout0_14ck11 = 0 time = 120
* CHECK dout0_15 vdout0_15ck11 = 0 time = 120
* CHECK dout0_16 vdout0_16ck11 = 0 time = 120
* CHECK dout0_17 vdout0_17ck11 = 3.3 time = 120
* CHECK dout0_18 vdout0_18ck11 = 0 time = 120
* CHECK dout0_19 vdout0_19ck11 = 0 time = 120
* CHECK dout0_20 vdout0_20ck11 = 3.3 time = 120
* CHECK dout0_21 vdout0_21ck11 = 0 time = 120
* CHECK dout0_22 vdout0_22ck11 = 0 time = 120
* CHECK dout0_23 vdout0_23ck11 = 0 time = 120
* CHECK dout0_24 vdout0_24ck11 = 0 time = 120
* CHECK dout0_25 vdout0_25ck11 = 0 time = 120
* CHECK dout0_26 vdout0_26ck11 = 3.3 time = 120
* CHECK dout0_27 vdout0_27ck11 = 0 time = 120
* CHECK dout0_28 vdout0_28ck11 = 0 time = 120
* CHECK dout0_29 vdout0_29ck11 = 0 time = 120
* CHECK dout0_30 vdout0_30ck11 = 0 time = 120
* CHECK dout0_31 vdout0_31ck11 = 3.3 time = 120
* CHECK dout0_0 vdout0_0ck12 = 3.3 time = 130
* CHECK dout0_1 vdout0_1ck12 = 3.3 time = 130
* CHECK dout0_2 vdout0_2ck12 = 3.3 time = 130
* CHECK dout0_3 vdout0_3ck12 = 0 time = 130
* CHECK dout0_4 vdout0_4ck12 = 0 time = 130
* CHECK dout0_5 vdout0_5ck12 = 3.3 time = 130
* CHECK dout0_6 vdout0_6ck12 = 3.3 time = 130
* CHECK dout0_7 vdout0_7ck12 = 3.3 time = 130
* CHECK dout0_8 vdout0_8ck12 = 0 time = 130
* CHECK dout0_9 vdout0_9ck12 = 3.3 time = 130
* CHECK dout0_10 vdout0_10ck12 = 0 time = 130
* CHECK dout0_11 vdout0_11ck12 = 3.3 time = 130
* CHECK dout0_12 vdout0_12ck12 = 3.3 time = 130
* CHECK dout0_13 vdout0_13ck12 = 0 time = 130
* CHECK dout0_14 vdout0_14ck12 = 0 time = 130
* CHECK dout0_15 vdout0_15ck12 = 0 time = 130
* CHECK dout0_16 vdout0_16ck12 = 0 time = 130
* CHECK dout0_17 vdout0_17ck12 = 3.3 time = 130
* CHECK dout0_18 vdout0_18ck12 = 0 time = 130
* CHECK dout0_19 vdout0_19ck12 = 0 time = 130
* CHECK dout0_20 vdout0_20ck12 = 3.3 time = 130
* CHECK dout0_21 vdout0_21ck12 = 0 time = 130
* CHECK dout0_22 vdout0_22ck12 = 0 time = 130
* CHECK dout0_23 vdout0_23ck12 = 0 time = 130
* CHECK dout0_24 vdout0_24ck12 = 0 time = 130
* CHECK dout0_25 vdout0_25ck12 = 0 time = 130
* CHECK dout0_26 vdout0_26ck12 = 3.3 time = 130
* CHECK dout0_27 vdout0_27ck12 = 0 time = 130
* CHECK dout0_28 vdout0_28ck12 = 0 time = 130
* CHECK dout0_29 vdout0_29ck12 = 0 time = 130
* CHECK dout0_30 vdout0_30ck12 = 0 time = 130
* CHECK dout0_31 vdout0_31ck12 = 3.3 time = 130
* CHECK dout1_0 vdout1_0ck13 = 3.3 time = 140
* CHECK dout1_1 vdout1_1ck13 = 3.3 time = 140
* CHECK dout1_2 vdout1_2ck13 = 3.3 time = 140
* CHECK dout1_3 vdout1_3ck13 = 0 time = 140
* CHECK dout1_4 vdout1_4ck13 = 0 time = 140
* CHECK dout1_5 vdout1_5ck13 = 3.3 time = 140
* CHECK dout1_6 vdout1_6ck13 = 3.3 time = 140
* CHECK dout1_7 vdout1_7ck13 = 3.3 time = 140
* CHECK dout1_8 vdout1_8ck13 = 0 time = 140
* CHECK dout1_9 vdout1_9ck13 = 3.3 time = 140
* CHECK dout1_10 vdout1_10ck13 = 0 time = 140
* CHECK dout1_11 vdout1_11ck13 = 3.3 time = 140
* CHECK dout1_12 vdout1_12ck13 = 3.3 time = 140
* CHECK dout1_13 vdout1_13ck13 = 0 time = 140
* CHECK dout1_14 vdout1_14ck13 = 0 time = 140
* CHECK dout1_15 vdout1_15ck13 = 0 time = 140
* CHECK dout1_16 vdout1_16ck13 = 0 time = 140
* CHECK dout1_17 vdout1_17ck13 = 3.3 time = 140
* CHECK dout1_18 vdout1_18ck13 = 0 time = 140
* CHECK dout1_19 vdout1_19ck13 = 0 time = 140
* CHECK dout1_20 vdout1_20ck13 = 3.3 time = 140
* CHECK dout1_21 vdout1_21ck13 = 0 time = 140
* CHECK dout1_22 vdout1_22ck13 = 0 time = 140
* CHECK dout1_23 vdout1_23ck13 = 0 time = 140
* CHECK dout1_24 vdout1_24ck13 = 0 time = 140
* CHECK dout1_25 vdout1_25ck13 = 0 time = 140
* CHECK dout1_26 vdout1_26ck13 = 3.3 time = 140
* CHECK dout1_27 vdout1_27ck13 = 0 time = 140
* CHECK dout1_28 vdout1_28ck13 = 0 time = 140
* CHECK dout1_29 vdout1_29ck13 = 0 time = 140
* CHECK dout1_30 vdout1_30ck13 = 0 time = 140
* CHECK dout1_31 vdout1_31ck13 = 3.3 time = 140
* CHECK dout0_0 vdout0_0ck15 = 0 time = 160
* CHECK dout0_1 vdout0_1ck15 = 0 time = 160
* CHECK dout0_2 vdout0_2ck15 = 0 time = 160
* CHECK dout0_3 vdout0_3ck15 = 3.3 time = 160
* CHECK dout0_4 vdout0_4ck15 = 3.3 time = 160
* CHECK dout0_5 vdout0_5ck15 = 0 time = 160
* CHECK dout0_6 vdout0_6ck15 = 0 time = 160
* CHECK dout0_7 vdout0_7ck15 = 3.3 time = 160
* CHECK dout0_8 vdout0_8ck15 = 3.3 time = 160
* CHECK dout0_9 vdout0_9ck15 = 3.3 time = 160
* CHECK dout0_10 vdout0_10ck15 = 0 time = 160
* CHECK dout0_11 vdout0_11ck15 = 3.3 time = 160
* CHECK dout0_12 vdout0_12ck15 = 3.3 time = 160
* CHECK dout0_13 vdout0_13ck15 = 3.3 time = 160
* CHECK dout0_14 vdout0_14ck15 = 0 time = 160
* CHECK dout0_15 vdout0_15ck15 = 3.3 time = 160
* CHECK dout0_16 vdout0_16ck15 = 3.3 time = 160
* CHECK dout0_17 vdout0_17ck15 = 3.3 time = 160
* CHECK dout0_18 vdout0_18ck15 = 0 time = 160
* CHECK dout0_19 vdout0_19ck15 = 0 time = 160
* CHECK dout0_20 vdout0_20ck15 = 0 time = 160
* CHECK dout0_21 vdout0_21ck15 = 0 time = 160
* CHECK dout0_22 vdout0_22ck15 = 0 time = 160
* CHECK dout0_23 vdout0_23ck15 = 3.3 time = 160
* CHECK dout0_24 vdout0_24ck15 = 3.3 time = 160
* CHECK dout0_25 vdout0_25ck15 = 3.3 time = 160
* CHECK dout0_26 vdout0_26ck15 = 0 time = 160
* CHECK dout0_27 vdout0_27ck15 = 3.3 time = 160
* CHECK dout0_28 vdout0_28ck15 = 0 time = 160
* CHECK dout0_29 vdout0_29ck15 = 0 time = 160
* CHECK dout0_30 vdout0_30ck15 = 3.3 time = 160
* CHECK dout0_31 vdout0_31ck15 = 0 time = 160
* CHECK dout0_0 vdout0_0ck17 = 3.3 time = 180
* CHECK dout0_1 vdout0_1ck17 = 3.3 time = 180
* CHECK dout0_2 vdout0_2ck17 = 0 time = 180
* CHECK dout0_3 vdout0_3ck17 = 0 time = 180
* CHECK dout0_4 vdout0_4ck17 = 0 time = 180
* CHECK dout0_5 vdout0_5ck17 = 3.3 time = 180
* CHECK dout0_6 vdout0_6ck17 = 0 time = 180
* CHECK dout0_7 vdout0_7ck17 = 0 time = 180
* CHECK dout0_8 vdout0_8ck17 = 0 time = 180
* CHECK dout0_9 vdout0_9ck17 = 3.3 time = 180
* CHECK dout0_10 vdout0_10ck17 = 0 time = 180
* CHECK dout0_11 vdout0_11ck17 = 3.3 time = 180
* CHECK dout0_12 vdout0_12ck17 = 3.3 time = 180
* CHECK dout0_13 vdout0_13ck17 = 0 time = 180
* CHECK dout0_14 vdout0_14ck17 = 0 time = 180
* CHECK dout0_15 vdout0_15ck17 = 3.3 time = 180
* CHECK dout0_16 vdout0_16ck17 = 0 time = 180
* CHECK dout0_17 vdout0_17ck17 = 3.3 time = 180
* CHECK dout0_18 vdout0_18ck17 = 3.3 time = 180
* CHECK dout0_19 vdout0_19ck17 = 0 time = 180
* CHECK dout0_20 vdout0_20ck17 = 0 time = 180
* CHECK dout0_21 vdout0_21ck17 = 0 time = 180
* CHECK dout0_22 vdout0_22ck17 = 0 time = 180
* CHECK dout0_23 vdout0_23ck17 = 0 time = 180
* CHECK dout0_24 vdout0_24ck17 = 3.3 time = 180
* CHECK dout0_25 vdout0_25ck17 = 3.3 time = 180
* CHECK dout0_26 vdout0_26ck17 = 3.3 time = 180
* CHECK dout0_27 vdout0_27ck17 = 0 time = 180
* CHECK dout0_28 vdout0_28ck17 = 3.3 time = 180
* CHECK dout0_29 vdout0_29ck17 = 0 time = 180
* CHECK dout0_30 vdout0_30ck17 = 3.3 time = 180
* CHECK dout0_31 vdout0_31ck17 = 0 time = 180
* CHECK dout0_0 vdout0_0ck18 = 0 time = 190
* CHECK dout0_1 vdout0_1ck18 = 0 time = 190
* CHECK dout0_2 vdout0_2ck18 = 0 time = 190
* CHECK dout0_3 vdout0_3ck18 = 3.3 time = 190
* CHECK dout0_4 vdout0_4ck18 = 3.3 time = 190
* CHECK dout0_5 vdout0_5ck18 = 0 time = 190
* CHECK dout0_6 vdout0_6ck18 = 0 time = 190
* CHECK dout0_7 vdout0_7ck18 = 3.3 time = 190
* CHECK dout0_8 vdout0_8ck18 = 3.3 time = 190
* CHECK dout0_9 vdout0_9ck18 = 3.3 time = 190
* CHECK dout0_10 vdout0_10ck18 = 0 time = 190
* CHECK dout0_11 vdout0_11ck18 = 3.3 time = 190
* CHECK dout0_12 vdout0_12ck18 = 3.3 time = 190
* CHECK dout0_13 vdout0_13ck18 = 3.3 time = 190
* CHECK dout0_14 vdout0_14ck18 = 0 time = 190
* CHECK dout0_15 vdout0_15ck18 = 3.3 time = 190
* CHECK dout0_16 vdout0_16ck18 = 3.3 time = 190
* CHECK dout0_17 vdout0_17ck18 = 3.3 time = 190
* CHECK dout0_18 vdout0_18ck18 = 0 time = 190
* CHECK dout0_19 vdout0_19ck18 = 0 time = 190
* CHECK dout0_20 vdout0_20ck18 = 0 time = 190
* CHECK dout0_21 vdout0_21ck18 = 0 time = 190
* CHECK dout0_22 vdout0_22ck18 = 0 time = 190
* CHECK dout0_23 vdout0_23ck18 = 3.3 time = 190
* CHECK dout0_24 vdout0_24ck18 = 3.3 time = 190
* CHECK dout0_25 vdout0_25ck18 = 3.3 time = 190
* CHECK dout0_26 vdout0_26ck18 = 0 time = 190
* CHECK dout0_27 vdout0_27ck18 = 3.3 time = 190
* CHECK dout0_28 vdout0_28ck18 = 0 time = 190
* CHECK dout0_29 vdout0_29ck18 = 0 time = 190
* CHECK dout0_30 vdout0_30ck18 = 3.3 time = 190
* CHECK dout0_31 vdout0_31ck18 = 0 time = 190
* CHECK dout1_0 vdout1_0ck18 = 0 time = 190
* CHECK dout1_1 vdout1_1ck18 = 0 time = 190
* CHECK dout1_2 vdout1_2ck18 = 0 time = 190
* CHECK dout1_3 vdout1_3ck18 = 3.3 time = 190
* CHECK dout1_4 vdout1_4ck18 = 0 time = 190
* CHECK dout1_5 vdout1_5ck18 = 3.3 time = 190
* CHECK dout1_6 vdout1_6ck18 = 3.3 time = 190
* CHECK dout1_7 vdout1_7ck18 = 0 time = 190
* CHECK dout1_8 vdout1_8ck18 = 3.3 time = 190
* CHECK dout1_9 vdout1_9ck18 = 0 time = 190
* CHECK dout1_10 vdout1_10ck18 = 0 time = 190
* CHECK dout1_11 vdout1_11ck18 = 3.3 time = 190
* CHECK dout1_12 vdout1_12ck18 = 3.3 time = 190
* CHECK dout1_13 vdout1_13ck18 = 0 time = 190
* CHECK dout1_14 vdout1_14ck18 = 3.3 time = 190
* CHECK dout1_15 vdout1_15ck18 = 3.3 time = 190
* CHECK dout1_16 vdout1_16ck18 = 0 time = 190
* CHECK dout1_17 vdout1_17ck18 = 0 time = 190
* CHECK dout1_18 vdout1_18ck18 = 3.3 time = 190
* CHECK dout1_19 vdout1_19ck18 = 3.3 time = 190
* CHECK dout1_20 vdout1_20ck18 = 3.3 time = 190
* CHECK dout1_21 vdout1_21ck18 = 0 time = 190
* CHECK dout1_22 vdout1_22ck18 = 0 time = 190
* CHECK dout1_23 vdout1_23ck18 = 3.3 time = 190
* CHECK dout1_24 vdout1_24ck18 = 0 time = 190
* CHECK dout1_25 vdout1_25ck18 = 3.3 time = 190
* CHECK dout1_26 vdout1_26ck18 = 3.3 time = 190
* CHECK dout1_27 vdout1_27ck18 = 3.3 time = 190
* CHECK dout1_28 vdout1_28ck18 = 3.3 time = 190
* CHECK dout1_29 vdout1_29ck18 = 0 time = 190
* CHECK dout1_30 vdout1_30ck18 = 3.3 time = 190
* CHECK dout1_31 vdout1_31ck18 = 0 time = 190
* CHECK dout0_0 vdout0_0ck19 = 0 time = 200
* CHECK dout0_1 vdout0_1ck19 = 0 time = 200
* CHECK dout0_2 vdout0_2ck19 = 0 time = 200
* CHECK dout0_3 vdout0_3ck19 = 3.3 time = 200
* CHECK dout0_4 vdout0_4ck19 = 0 time = 200
* CHECK dout0_5 vdout0_5ck19 = 3.3 time = 200
* CHECK dout0_6 vdout0_6ck19 = 3.3 time = 200
* CHECK dout0_7 vdout0_7ck19 = 0 time = 200
* CHECK dout0_8 vdout0_8ck19 = 3.3 time = 200
* CHECK dout0_9 vdout0_9ck19 = 0 time = 200
* CHECK dout0_10 vdout0_10ck19 = 0 time = 200
* CHECK dout0_11 vdout0_11ck19 = 3.3 time = 200
* CHECK dout0_12 vdout0_12ck19 = 3.3 time = 200
* CHECK dout0_13 vdout0_13ck19 = 0 time = 200
* CHECK dout0_14 vdout0_14ck19 = 3.3 time = 200
* CHECK dout0_15 vdout0_15ck19 = 3.3 time = 200
* CHECK dout0_16 vdout0_16ck19 = 0 time = 200
* CHECK dout0_17 vdout0_17ck19 = 0 time = 200
* CHECK dout0_18 vdout0_18ck19 = 3.3 time = 200
* CHECK dout0_19 vdout0_19ck19 = 3.3 time = 200
* CHECK dout0_20 vdout0_20ck19 = 3.3 time = 200
* CHECK dout0_21 vdout0_21ck19 = 0 time = 200
* CHECK dout0_22 vdout0_22ck19 = 0 time = 200
* CHECK dout0_23 vdout0_23ck19 = 3.3 time = 200
* CHECK dout0_24 vdout0_24ck19 = 0 time = 200
* CHECK dout0_25 vdout0_25ck19 = 3.3 time = 200
* CHECK dout0_26 vdout0_26ck19 = 3.3 time = 200
* CHECK dout0_27 vdout0_27ck19 = 3.3 time = 200
* CHECK dout0_28 vdout0_28ck19 = 3.3 time = 200
* CHECK dout0_29 vdout0_29ck19 = 0 time = 200
* CHECK dout0_30 vdout0_30ck19 = 3.3 time = 200
* CHECK dout0_31 vdout0_31ck19 = 0 time = 200
* CHECK dout1_0 vdout1_0ck19 = 0 time = 200
* CHECK dout1_1 vdout1_1ck19 = 0 time = 200
* CHECK dout1_2 vdout1_2ck19 = 0 time = 200
* CHECK dout1_3 vdout1_3ck19 = 3.3 time = 200
* CHECK dout1_4 vdout1_4ck19 = 0 time = 200
* CHECK dout1_5 vdout1_5ck19 = 3.3 time = 200
* CHECK dout1_6 vdout1_6ck19 = 3.3 time = 200
* CHECK dout1_7 vdout1_7ck19 = 0 time = 200
* CHECK dout1_8 vdout1_8ck19 = 3.3 time = 200
* CHECK dout1_9 vdout1_9ck19 = 0 time = 200
* CHECK dout1_10 vdout1_10ck19 = 0 time = 200
* CHECK dout1_11 vdout1_11ck19 = 3.3 time = 200
* CHECK dout1_12 vdout1_12ck19 = 3.3 time = 200
* CHECK dout1_13 vdout1_13ck19 = 0 time = 200
* CHECK dout1_14 vdout1_14ck19 = 3.3 time = 200
* CHECK dout1_15 vdout1_15ck19 = 3.3 time = 200
* CHECK dout1_16 vdout1_16ck19 = 0 time = 200
* CHECK dout1_17 vdout1_17ck19 = 0 time = 200
* CHECK dout1_18 vdout1_18ck19 = 3.3 time = 200
* CHECK dout1_19 vdout1_19ck19 = 3.3 time = 200
* CHECK dout1_20 vdout1_20ck19 = 3.3 time = 200
* CHECK dout1_21 vdout1_21ck19 = 0 time = 200
* CHECK dout1_22 vdout1_22ck19 = 0 time = 200
* CHECK dout1_23 vdout1_23ck19 = 3.3 time = 200
* CHECK dout1_24 vdout1_24ck19 = 0 time = 200
* CHECK dout1_25 vdout1_25ck19 = 3.3 time = 200
* CHECK dout1_26 vdout1_26ck19 = 3.3 time = 200
* CHECK dout1_27 vdout1_27ck19 = 3.3 time = 200
* CHECK dout1_28 vdout1_28ck19 = 3.3 time = 200
* CHECK dout1_29 vdout1_29ck19 = 0 time = 200
* CHECK dout1_30 vdout1_30ck19 = 3.3 time = 200
* CHECK dout1_31 vdout1_31ck19 = 0 time = 200
* CHECK dout0_0 vdout0_0ck20 = 0 time = 210
* CHECK dout0_1 vdout0_1ck20 = 0 time = 210
* CHECK dout0_2 vdout0_2ck20 = 0 time = 210
* CHECK dout0_3 vdout0_3ck20 = 3.3 time = 210
* CHECK dout0_4 vdout0_4ck20 = 3.3 time = 210
* CHECK dout0_5 vdout0_5ck20 = 0 time = 210
* CHECK dout0_6 vdout0_6ck20 = 0 time = 210
* CHECK dout0_7 vdout0_7ck20 = 3.3 time = 210
* CHECK dout0_8 vdout0_8ck20 = 3.3 time = 210
* CHECK dout0_9 vdout0_9ck20 = 3.3 time = 210
* CHECK dout0_10 vdout0_10ck20 = 0 time = 210
* CHECK dout0_11 vdout0_11ck20 = 3.3 time = 210
* CHECK dout0_12 vdout0_12ck20 = 3.3 time = 210
* CHECK dout0_13 vdout0_13ck20 = 3.3 time = 210
* CHECK dout0_14 vdout0_14ck20 = 0 time = 210
* CHECK dout0_15 vdout0_15ck20 = 3.3 time = 210
* CHECK dout0_16 vdout0_16ck20 = 3.3 time = 210
* CHECK dout0_17 vdout0_17ck20 = 3.3 time = 210
* CHECK dout0_18 vdout0_18ck20 = 0 time = 210
* CHECK dout0_19 vdout0_19ck20 = 0 time = 210
* CHECK dout0_20 vdout0_20ck20 = 0 time = 210
* CHECK dout0_21 vdout0_21ck20 = 0 time = 210
* CHECK dout0_22 vdout0_22ck20 = 0 time = 210
* CHECK dout0_23 vdout0_23ck20 = 3.3 time = 210
* CHECK dout0_24 vdout0_24ck20 = 3.3 time = 210
* CHECK dout0_25 vdout0_25ck20 = 3.3 time = 210
* CHECK dout0_26 vdout0_26ck20 = 0 time = 210
* CHECK dout0_27 vdout0_27ck20 = 3.3 time = 210
* CHECK dout0_28 vdout0_28ck20 = 0 time = 210
* CHECK dout0_29 vdout0_29ck20 = 0 time = 210
* CHECK dout0_30 vdout0_30ck20 = 3.3 time = 210
* CHECK dout0_31 vdout0_31ck20 = 0 time = 210
* CHECK dout0_0 vdout0_0ck21 = 0 time = 220
* CHECK dout0_1 vdout0_1ck21 = 0 time = 220
* CHECK dout0_2 vdout0_2ck21 = 0 time = 220
* CHECK dout0_3 vdout0_3ck21 = 3.3 time = 220
* CHECK dout0_4 vdout0_4ck21 = 3.3 time = 220
* CHECK dout0_5 vdout0_5ck21 = 0 time = 220
* CHECK dout0_6 vdout0_6ck21 = 0 time = 220
* CHECK dout0_7 vdout0_7ck21 = 3.3 time = 220
* CHECK dout0_8 vdout0_8ck21 = 3.3 time = 220
* CHECK dout0_9 vdout0_9ck21 = 3.3 time = 220
* CHECK dout0_10 vdout0_10ck21 = 0 time = 220
* CHECK dout0_11 vdout0_11ck21 = 3.3 time = 220
* CHECK dout0_12 vdout0_12ck21 = 3.3 time = 220
* CHECK dout0_13 vdout0_13ck21 = 3.3 time = 220
* CHECK dout0_14 vdout0_14ck21 = 0 time = 220
* CHECK dout0_15 vdout0_15ck21 = 3.3 time = 220
* CHECK dout0_16 vdout0_16ck21 = 3.3 time = 220
* CHECK dout0_17 vdout0_17ck21 = 3.3 time = 220
* CHECK dout0_18 vdout0_18ck21 = 0 time = 220
* CHECK dout0_19 vdout0_19ck21 = 0 time = 220
* CHECK dout0_20 vdout0_20ck21 = 0 time = 220
* CHECK dout0_21 vdout0_21ck21 = 0 time = 220
* CHECK dout0_22 vdout0_22ck21 = 0 time = 220
* CHECK dout0_23 vdout0_23ck21 = 3.3 time = 220
* CHECK dout0_24 vdout0_24ck21 = 3.3 time = 220
* CHECK dout0_25 vdout0_25ck21 = 3.3 time = 220
* CHECK dout0_26 vdout0_26ck21 = 0 time = 220
* CHECK dout0_27 vdout0_27ck21 = 3.3 time = 220
* CHECK dout0_28 vdout0_28ck21 = 0 time = 220
* CHECK dout0_29 vdout0_29ck21 = 0 time = 220
* CHECK dout0_30 vdout0_30ck21 = 3.3 time = 220
* CHECK dout0_31 vdout0_31ck21 = 0 time = 220
* CHECK dout0_0 vdout0_0ck23 = 3.3 time = 240
* CHECK dout0_1 vdout0_1ck23 = 0 time = 240
* CHECK dout0_2 vdout0_2ck23 = 0 time = 240
* CHECK dout0_3 vdout0_3ck23 = 0 time = 240
* CHECK dout0_4 vdout0_4ck23 = 3.3 time = 240
* CHECK dout0_5 vdout0_5ck23 = 3.3 time = 240
* CHECK dout0_6 vdout0_6ck23 = 3.3 time = 240
* CHECK dout0_7 vdout0_7ck23 = 0 time = 240
* CHECK dout0_8 vdout0_8ck23 = 3.3 time = 240
* CHECK dout0_9 vdout0_9ck23 = 0 time = 240
* CHECK dout0_10 vdout0_10ck23 = 3.3 time = 240
* CHECK dout0_11 vdout0_11ck23 = 3.3 time = 240
* CHECK dout0_12 vdout0_12ck23 = 3.3 time = 240
* CHECK dout0_13 vdout0_13ck23 = 3.3 time = 240
* CHECK dout0_14 vdout0_14ck23 = 0 time = 240
* CHECK dout0_15 vdout0_15ck23 = 0 time = 240
* CHECK dout0_16 vdout0_16ck23 = 3.3 time = 240
* CHECK dout0_17 vdout0_17ck23 = 0 time = 240
* CHECK dout0_18 vdout0_18ck23 = 0 time = 240
* CHECK dout0_19 vdout0_19ck23 = 3.3 time = 240
* CHECK dout0_20 vdout0_20ck23 = 3.3 time = 240
* CHECK dout0_21 vdout0_21ck23 = 3.3 time = 240
* CHECK dout0_22 vdout0_22ck23 = 0 time = 240
* CHECK dout0_23 vdout0_23ck23 = 0 time = 240
* CHECK dout0_24 vdout0_24ck23 = 0 time = 240
* CHECK dout0_25 vdout0_25ck23 = 0 time = 240
* CHECK dout0_26 vdout0_26ck23 = 0 time = 240
* CHECK dout0_27 vdout0_27ck23 = 3.3 time = 240
* CHECK dout0_28 vdout0_28ck23 = 0 time = 240
* CHECK dout0_29 vdout0_29ck23 = 0 time = 240
* CHECK dout0_30 vdout0_30ck23 = 0 time = 240
* CHECK dout0_31 vdout0_31ck23 = 3.3 time = 240
* CHECK dout1_0 vdout1_0ck23 = 0 time = 240
* CHECK dout1_1 vdout1_1ck23 = 0 time = 240
* CHECK dout1_2 vdout1_2ck23 = 0 time = 240
* CHECK dout1_3 vdout1_3ck23 = 3.3 time = 240
* CHECK dout1_4 vdout1_4ck23 = 3.3 time = 240
* CHECK dout1_5 vdout1_5ck23 = 0 time = 240
* CHECK dout1_6 vdout1_6ck23 = 0 time = 240
* CHECK dout1_7 vdout1_7ck23 = 3.3 time = 240
* CHECK dout1_8 vdout1_8ck23 = 3.3 time = 240
* CHECK dout1_9 vdout1_9ck23 = 3.3 time = 240
* CHECK dout1_10 vdout1_10ck23 = 0 time = 240
* CHECK dout1_11 vdout1_11ck23 = 3.3 time = 240
* CHECK dout1_12 vdout1_12ck23 = 3.3 time = 240
* CHECK dout1_13 vdout1_13ck23 = 3.3 time = 240
* CHECK dout1_14 vdout1_14ck23 = 0 time = 240
* CHECK dout1_15 vdout1_15ck23 = 3.3 time = 240
* CHECK dout1_16 vdout1_16ck23 = 3.3 time = 240
* CHECK dout1_17 vdout1_17ck23 = 3.3 time = 240
* CHECK dout1_18 vdout1_18ck23 = 0 time = 240
* CHECK dout1_19 vdout1_19ck23 = 0 time = 240
* CHECK dout1_20 vdout1_20ck23 = 0 time = 240
* CHECK dout1_21 vdout1_21ck23 = 0 time = 240
* CHECK dout1_22 vdout1_22ck23 = 0 time = 240
* CHECK dout1_23 vdout1_23ck23 = 3.3 time = 240
* CHECK dout1_24 vdout1_24ck23 = 3.3 time = 240
* CHECK dout1_25 vdout1_25ck23 = 3.3 time = 240
* CHECK dout1_26 vdout1_26ck23 = 0 time = 240
* CHECK dout1_27 vdout1_27ck23 = 3.3 time = 240
* CHECK dout1_28 vdout1_28ck23 = 0 time = 240
* CHECK dout1_29 vdout1_29ck23 = 0 time = 240
* CHECK dout1_30 vdout1_30ck23 = 3.3 time = 240
* CHECK dout1_31 vdout1_31ck23 = 0 time = 240
* CHECK dout0_0 vdout0_0ck24 = 3.3 time = 250
* CHECK dout0_1 vdout0_1ck24 = 0 time = 250
* CHECK dout0_2 vdout0_2ck24 = 0 time = 250
* CHECK dout0_3 vdout0_3ck24 = 0 time = 250
* CHECK dout0_4 vdout0_4ck24 = 3.3 time = 250
* CHECK dout0_5 vdout0_5ck24 = 3.3 time = 250
* CHECK dout0_6 vdout0_6ck24 = 3.3 time = 250
* CHECK dout0_7 vdout0_7ck24 = 0 time = 250
* CHECK dout0_8 vdout0_8ck24 = 3.3 time = 250
* CHECK dout0_9 vdout0_9ck24 = 0 time = 250
* CHECK dout0_10 vdout0_10ck24 = 3.3 time = 250
* CHECK dout0_11 vdout0_11ck24 = 3.3 time = 250
* CHECK dout0_12 vdout0_12ck24 = 3.3 time = 250
* CHECK dout0_13 vdout0_13ck24 = 3.3 time = 250
* CHECK dout0_14 vdout0_14ck24 = 0 time = 250
* CHECK dout0_15 vdout0_15ck24 = 0 time = 250
* CHECK dout0_16 vdout0_16ck24 = 3.3 time = 250
* CHECK dout0_17 vdout0_17ck24 = 0 time = 250
* CHECK dout0_18 vdout0_18ck24 = 0 time = 250
* CHECK dout0_19 vdout0_19ck24 = 3.3 time = 250
* CHECK dout0_20 vdout0_20ck24 = 3.3 time = 250
* CHECK dout0_21 vdout0_21ck24 = 3.3 time = 250
* CHECK dout0_22 vdout0_22ck24 = 0 time = 250
* CHECK dout0_23 vdout0_23ck24 = 0 time = 250
* CHECK dout0_24 vdout0_24ck24 = 0 time = 250
* CHECK dout0_25 vdout0_25ck24 = 0 time = 250
* CHECK dout0_26 vdout0_26ck24 = 0 time = 250
* CHECK dout0_27 vdout0_27ck24 = 3.3 time = 250
* CHECK dout0_28 vdout0_28ck24 = 0 time = 250
* CHECK dout0_29 vdout0_29ck24 = 0 time = 250
* CHECK dout0_30 vdout0_30ck24 = 0 time = 250
* CHECK dout0_31 vdout0_31ck24 = 3.3 time = 250
* CHECK dout0_0 vdout0_0ck25 = 3.3 time = 260
* CHECK dout0_1 vdout0_1ck25 = 0 time = 260
* CHECK dout0_2 vdout0_2ck25 = 0 time = 260
* CHECK dout0_3 vdout0_3ck25 = 0 time = 260
* CHECK dout0_4 vdout0_4ck25 = 3.3 time = 260
* CHECK dout0_5 vdout0_5ck25 = 0 time = 260
* CHECK dout0_6 vdout0_6ck25 = 0 time = 260
* CHECK dout0_7 vdout0_7ck25 = 0 time = 260
* CHECK dout0_8 vdout0_8ck25 = 3.3 time = 260
* CHECK dout0_9 vdout0_9ck25 = 3.3 time = 260
* CHECK dout0_10 vdout0_10ck25 = 3.3 time = 260
* CHECK dout0_11 vdout0_11ck25 = 0 time = 260
* CHECK dout0_12 vdout0_12ck25 = 3.3 time = 260
* CHECK dout0_13 vdout0_13ck25 = 3.3 time = 260
* CHECK dout0_14 vdout0_14ck25 = 3.3 time = 260
* CHECK dout0_15 vdout0_15ck25 = 3.3 time = 260
* CHECK dout0_16 vdout0_16ck25 = 0 time = 260
* CHECK dout0_17 vdout0_17ck25 = 0 time = 260
* CHECK dout0_18 vdout0_18ck25 = 0 time = 260
* CHECK dout0_19 vdout0_19ck25 = 0 time = 260
* CHECK dout0_20 vdout0_20ck25 = 3.3 time = 260
* CHECK dout0_21 vdout0_21ck25 = 0 time = 260
* CHECK dout0_22 vdout0_22ck25 = 0 time = 260
* CHECK dout0_23 vdout0_23ck25 = 3.3 time = 260
* CHECK dout0_24 vdout0_24ck25 = 3.3 time = 260
* CHECK dout0_25 vdout0_25ck25 = 3.3 time = 260
* CHECK dout0_26 vdout0_26ck25 = 0 time = 260
* CHECK dout0_27 vdout0_27ck25 = 3.3 time = 260
* CHECK dout0_28 vdout0_28ck25 = 3.3 time = 260
* CHECK dout0_29 vdout0_29ck25 = 0 time = 260
* CHECK dout0_30 vdout0_30ck25 = 0 time = 260
* CHECK dout0_31 vdout0_31ck25 = 0 time = 260
* CHECK dout1_0 vdout1_0ck25 = 3.3 time = 260
* CHECK dout1_1 vdout1_1ck25 = 0 time = 260
* CHECK dout1_2 vdout1_2ck25 = 0 time = 260
* CHECK dout1_3 vdout1_3ck25 = 0 time = 260
* CHECK dout1_4 vdout1_4ck25 = 3.3 time = 260
* CHECK dout1_5 vdout1_5ck25 = 0 time = 260
* CHECK dout1_6 vdout1_6ck25 = 0 time = 260
* CHECK dout1_7 vdout1_7ck25 = 0 time = 260
* CHECK dout1_8 vdout1_8ck25 = 3.3 time = 260
* CHECK dout1_9 vdout1_9ck25 = 3.3 time = 260
* CHECK dout1_10 vdout1_10ck25 = 3.3 time = 260
* CHECK dout1_11 vdout1_11ck25 = 0 time = 260
* CHECK dout1_12 vdout1_12ck25 = 3.3 time = 260
* CHECK dout1_13 vdout1_13ck25 = 3.3 time = 260
* CHECK dout1_14 vdout1_14ck25 = 3.3 time = 260
* CHECK dout1_15 vdout1_15ck25 = 3.3 time = 260
* CHECK dout1_16 vdout1_16ck25 = 0 time = 260
* CHECK dout1_17 vdout1_17ck25 = 0 time = 260
* CHECK dout1_18 vdout1_18ck25 = 0 time = 260
* CHECK dout1_19 vdout1_19ck25 = 0 time = 260
* CHECK dout1_20 vdout1_20ck25 = 3.3 time = 260
* CHECK dout1_21 vdout1_21ck25 = 0 time = 260
* CHECK dout1_22 vdout1_22ck25 = 0 time = 260
* CHECK dout1_23 vdout1_23ck25 = 3.3 time = 260
* CHECK dout1_24 vdout1_24ck25 = 3.3 time = 260
* CHECK dout1_25 vdout1_25ck25 = 3.3 time = 260
* CHECK dout1_26 vdout1_26ck25 = 0 time = 260
* CHECK dout1_27 vdout1_27ck25 = 3.3 time = 260
* CHECK dout1_28 vdout1_28ck25 = 3.3 time = 260
* CHECK dout1_29 vdout1_29ck25 = 0 time = 260
* CHECK dout1_30 vdout1_30ck25 = 0 time = 260
* CHECK dout1_31 vdout1_31ck25 = 0 time = 260
* CHECK dout1_0 vdout1_0ck28 = 0 time = 290
* CHECK dout1_1 vdout1_1ck28 = 0 time = 290
* CHECK dout1_2 vdout1_2ck28 = 0 time = 290
* CHECK dout1_3 vdout1_3ck28 = 0 time = 290
* CHECK dout1_4 vdout1_4ck28 = 3.3 time = 290
* CHECK dout1_5 vdout1_5ck28 = 3.3 time = 290
* CHECK dout1_6 vdout1_6ck28 = 0 time = 290
* CHECK dout1_7 vdout1_7ck28 = 0 time = 290
* CHECK dout1_8 vdout1_8ck28 = 0 time = 290
* CHECK dout1_9 vdout1_9ck28 = 3.3 time = 290
* CHECK dout1_10 vdout1_10ck28 = 0 time = 290
* CHECK dout1_11 vdout1_11ck28 = 0 time = 290
* CHECK dout1_12 vdout1_12ck28 = 0 time = 290
* CHECK dout1_13 vdout1_13ck28 = 0 time = 290
* CHECK dout1_14 vdout1_14ck28 = 3.3 time = 290
* CHECK dout1_15 vdout1_15ck28 = 3.3 time = 290
* CHECK dout1_16 vdout1_16ck28 = 3.3 time = 290
* CHECK dout1_17 vdout1_17ck28 = 0 time = 290
* CHECK dout1_18 vdout1_18ck28 = 3.3 time = 290
* CHECK dout1_19 vdout1_19ck28 = 3.3 time = 290
* CHECK dout1_20 vdout1_20ck28 = 3.3 time = 290
* CHECK dout1_21 vdout1_21ck28 = 3.3 time = 290
* CHECK dout1_22 vdout1_22ck28 = 0 time = 290
* CHECK dout1_23 vdout1_23ck28 = 3.3 time = 290
* CHECK dout1_24 vdout1_24ck28 = 3.3 time = 290
* CHECK dout1_25 vdout1_25ck28 = 0 time = 290
* CHECK dout1_26 vdout1_26ck28 = 0 time = 290
* CHECK dout1_27 vdout1_27ck28 = 0 time = 290
* CHECK dout1_28 vdout1_28ck28 = 3.3 time = 290
* CHECK dout1_29 vdout1_29ck28 = 3.3 time = 290
* CHECK dout1_30 vdout1_30ck28 = 3.3 time = 290
* CHECK dout1_31 vdout1_31ck28 = 3.3 time = 290
* CHECK dout0_0 vdout0_0ck32 = 3.3 time = 330
* CHECK dout0_1 vdout0_1ck32 = 3.3 time = 330
* CHECK dout0_2 vdout0_2ck32 = 3.3 time = 330
* CHECK dout0_3 vdout0_3ck32 = 0 time = 330
* CHECK dout0_4 vdout0_4ck32 = 0 time = 330
* CHECK dout0_5 vdout0_5ck32 = 3.3 time = 330
* CHECK dout0_6 vdout0_6ck32 = 3.3 time = 330
* CHECK dout0_7 vdout0_7ck32 = 3.3 time = 330
* CHECK dout0_8 vdout0_8ck32 = 3.3 time = 330
* CHECK dout0_9 vdout0_9ck32 = 3.3 time = 330
* CHECK dout0_10 vdout0_10ck32 = 0 time = 330
* CHECK dout0_11 vdout0_11ck32 = 3.3 time = 330
* CHECK dout0_12 vdout0_12ck32 = 0 time = 330
* CHECK dout0_13 vdout0_13ck32 = 3.3 time = 330
* CHECK dout0_14 vdout0_14ck32 = 3.3 time = 330
* CHECK dout0_15 vdout0_15ck32 = 0 time = 330
* CHECK dout0_16 vdout0_16ck32 = 3.3 time = 330
* CHECK dout0_17 vdout0_17ck32 = 0 time = 330
* CHECK dout0_18 vdout0_18ck32 = 3.3 time = 330
* CHECK dout0_19 vdout0_19ck32 = 0 time = 330
* CHECK dout0_20 vdout0_20ck32 = 0 time = 330
* CHECK dout0_21 vdout0_21ck32 = 3.3 time = 330
* CHECK dout0_22 vdout0_22ck32 = 3.3 time = 330
* CHECK dout0_23 vdout0_23ck32 = 0 time = 330
* CHECK dout0_24 vdout0_24ck32 = 3.3 time = 330
* CHECK dout0_25 vdout0_25ck32 = 3.3 time = 330
* CHECK dout0_26 vdout0_26ck32 = 3.3 time = 330
* CHECK dout0_27 vdout0_27ck32 = 0 time = 330
* CHECK dout0_28 vdout0_28ck32 = 0 time = 330
* CHECK dout0_29 vdout0_29ck32 = 3.3 time = 330
* CHECK dout0_30 vdout0_30ck32 = 3.3 time = 330
* CHECK dout0_31 vdout0_31ck32 = 3.3 time = 330
* CHECK dout0_0 vdout0_0ck35 = 3.3 time = 360
* CHECK dout0_1 vdout0_1ck35 = 3.3 time = 360
* CHECK dout0_2 vdout0_2ck35 = 3.3 time = 360
* CHECK dout0_3 vdout0_3ck35 = 0 time = 360
* CHECK dout0_4 vdout0_4ck35 = 0 time = 360
* CHECK dout0_5 vdout0_5ck35 = 3.3 time = 360
* CHECK dout0_6 vdout0_6ck35 = 3.3 time = 360
* CHECK dout0_7 vdout0_7ck35 = 3.3 time = 360
* CHECK dout0_8 vdout0_8ck35 = 3.3 time = 360
* CHECK dout0_9 vdout0_9ck35 = 3.3 time = 360
* CHECK dout0_10 vdout0_10ck35 = 0 time = 360
* CHECK dout0_11 vdout0_11ck35 = 3.3 time = 360
* CHECK dout0_12 vdout0_12ck35 = 0 time = 360
* CHECK dout0_13 vdout0_13ck35 = 3.3 time = 360
* CHECK dout0_14 vdout0_14ck35 = 3.3 time = 360
* CHECK dout0_15 vdout0_15ck35 = 0 time = 360
* CHECK dout0_16 vdout0_16ck35 = 3.3 time = 360
* CHECK dout0_17 vdout0_17ck35 = 0 time = 360
* CHECK dout0_18 vdout0_18ck35 = 3.3 time = 360
* CHECK dout0_19 vdout0_19ck35 = 0 time = 360
* CHECK dout0_20 vdout0_20ck35 = 0 time = 360
* CHECK dout0_21 vdout0_21ck35 = 3.3 time = 360
* CHECK dout0_22 vdout0_22ck35 = 3.3 time = 360
* CHECK dout0_23 vdout0_23ck35 = 0 time = 360
* CHECK dout0_24 vdout0_24ck35 = 3.3 time = 360
* CHECK dout0_25 vdout0_25ck35 = 3.3 time = 360
* CHECK dout0_26 vdout0_26ck35 = 3.3 time = 360
* CHECK dout0_27 vdout0_27ck35 = 0 time = 360
* CHECK dout0_28 vdout0_28ck35 = 0 time = 360
* CHECK dout0_29 vdout0_29ck35 = 3.3 time = 360
* CHECK dout0_30 vdout0_30ck35 = 3.3 time = 360
* CHECK dout0_31 vdout0_31ck35 = 3.3 time = 360
* CHECK dout1_0 vdout1_0ck35 = 3.3 time = 360
* CHECK dout1_1 vdout1_1ck35 = 3.3 time = 360
* CHECK dout1_2 vdout1_2ck35 = 3.3 time = 360
* CHECK dout1_3 vdout1_3ck35 = 0 time = 360
* CHECK dout1_4 vdout1_4ck35 = 0 time = 360
* CHECK dout1_5 vdout1_5ck35 = 3.3 time = 360
* CHECK dout1_6 vdout1_6ck35 = 3.3 time = 360
* CHECK dout1_7 vdout1_7ck35 = 3.3 time = 360
* CHECK dout1_8 vdout1_8ck35 = 3.3 time = 360
* CHECK dout1_9 vdout1_9ck35 = 3.3 time = 360
* CHECK dout1_10 vdout1_10ck35 = 0 time = 360
* CHECK dout1_11 vdout1_11ck35 = 3.3 time = 360
* CHECK dout1_12 vdout1_12ck35 = 0 time = 360
* CHECK dout1_13 vdout1_13ck35 = 3.3 time = 360
* CHECK dout1_14 vdout1_14ck35 = 3.3 time = 360
* CHECK dout1_15 vdout1_15ck35 = 0 time = 360
* CHECK dout1_16 vdout1_16ck35 = 3.3 time = 360
* CHECK dout1_17 vdout1_17ck35 = 0 time = 360
* CHECK dout1_18 vdout1_18ck35 = 3.3 time = 360
* CHECK dout1_19 vdout1_19ck35 = 0 time = 360
* CHECK dout1_20 vdout1_20ck35 = 0 time = 360
* CHECK dout1_21 vdout1_21ck35 = 3.3 time = 360
* CHECK dout1_22 vdout1_22ck35 = 3.3 time = 360
* CHECK dout1_23 vdout1_23ck35 = 0 time = 360
* CHECK dout1_24 vdout1_24ck35 = 3.3 time = 360
* CHECK dout1_25 vdout1_25ck35 = 3.3 time = 360
* CHECK dout1_26 vdout1_26ck35 = 3.3 time = 360
* CHECK dout1_27 vdout1_27ck35 = 0 time = 360
* CHECK dout1_28 vdout1_28ck35 = 0 time = 360
* CHECK dout1_29 vdout1_29ck35 = 3.3 time = 360
* CHECK dout1_30 vdout1_30ck35 = 3.3 time = 360
* CHECK dout1_31 vdout1_31ck35 = 3.3 time = 360
* CHECK dout0_0 vdout0_0ck36 = 3.3 time = 370
* CHECK dout0_1 vdout0_1ck36 = 3.3 time = 370
* CHECK dout0_2 vdout0_2ck36 = 3.3 time = 370
* CHECK dout0_3 vdout0_3ck36 = 0 time = 370
* CHECK dout0_4 vdout0_4ck36 = 0 time = 370
* CHECK dout0_5 vdout0_5ck36 = 3.3 time = 370
* CHECK dout0_6 vdout0_6ck36 = 3.3 time = 370
* CHECK dout0_7 vdout0_7ck36 = 3.3 time = 370
* CHECK dout0_8 vdout0_8ck36 = 3.3 time = 370
* CHECK dout0_9 vdout0_9ck36 = 3.3 time = 370
* CHECK dout0_10 vdout0_10ck36 = 0 time = 370
* CHECK dout0_11 vdout0_11ck36 = 3.3 time = 370
* CHECK dout0_12 vdout0_12ck36 = 0 time = 370
* CHECK dout0_13 vdout0_13ck36 = 3.3 time = 370
* CHECK dout0_14 vdout0_14ck36 = 3.3 time = 370
* CHECK dout0_15 vdout0_15ck36 = 0 time = 370
* CHECK dout0_16 vdout0_16ck36 = 3.3 time = 370
* CHECK dout0_17 vdout0_17ck36 = 0 time = 370
* CHECK dout0_18 vdout0_18ck36 = 3.3 time = 370
* CHECK dout0_19 vdout0_19ck36 = 0 time = 370
* CHECK dout0_20 vdout0_20ck36 = 0 time = 370
* CHECK dout0_21 vdout0_21ck36 = 3.3 time = 370
* CHECK dout0_22 vdout0_22ck36 = 3.3 time = 370
* CHECK dout0_23 vdout0_23ck36 = 0 time = 370
* CHECK dout0_24 vdout0_24ck36 = 3.3 time = 370
* CHECK dout0_25 vdout0_25ck36 = 3.3 time = 370
* CHECK dout0_26 vdout0_26ck36 = 3.3 time = 370
* CHECK dout0_27 vdout0_27ck36 = 0 time = 370
* CHECK dout0_28 vdout0_28ck36 = 0 time = 370
* CHECK dout0_29 vdout0_29ck36 = 3.3 time = 370
* CHECK dout0_30 vdout0_30ck36 = 3.3 time = 370
* CHECK dout0_31 vdout0_31ck36 = 3.3 time = 370
* CHECK dout0_0 vdout0_0ck37 = 3.3 time = 380
* CHECK dout0_1 vdout0_1ck37 = 3.3 time = 380
* CHECK dout0_2 vdout0_2ck37 = 3.3 time = 380
* CHECK dout0_3 vdout0_3ck37 = 0 time = 380
* CHECK dout0_4 vdout0_4ck37 = 0 time = 380
* CHECK dout0_5 vdout0_5ck37 = 3.3 time = 380
* CHECK dout0_6 vdout0_6ck37 = 3.3 time = 380
* CHECK dout0_7 vdout0_7ck37 = 3.3 time = 380
* CHECK dout0_8 vdout0_8ck37 = 3.3 time = 380
* CHECK dout0_9 vdout0_9ck37 = 3.3 time = 380
* CHECK dout0_10 vdout0_10ck37 = 0 time = 380
* CHECK dout0_11 vdout0_11ck37 = 3.3 time = 380
* CHECK dout0_12 vdout0_12ck37 = 0 time = 380
* CHECK dout0_13 vdout0_13ck37 = 3.3 time = 380
* CHECK dout0_14 vdout0_14ck37 = 3.3 time = 380
* CHECK dout0_15 vdout0_15ck37 = 0 time = 380
* CHECK dout0_16 vdout0_16ck37 = 3.3 time = 380
* CHECK dout0_17 vdout0_17ck37 = 0 time = 380
* CHECK dout0_18 vdout0_18ck37 = 3.3 time = 380
* CHECK dout0_19 vdout0_19ck37 = 0 time = 380
* CHECK dout0_20 vdout0_20ck37 = 0 time = 380
* CHECK dout0_21 vdout0_21ck37 = 3.3 time = 380
* CHECK dout0_22 vdout0_22ck37 = 3.3 time = 380
* CHECK dout0_23 vdout0_23ck37 = 0 time = 380
* CHECK dout0_24 vdout0_24ck37 = 3.3 time = 380
* CHECK dout0_25 vdout0_25ck37 = 3.3 time = 380
* CHECK dout0_26 vdout0_26ck37 = 3.3 time = 380
* CHECK dout0_27 vdout0_27ck37 = 0 time = 380
* CHECK dout0_28 vdout0_28ck37 = 0 time = 380
* CHECK dout0_29 vdout0_29ck37 = 3.3 time = 380
* CHECK dout0_30 vdout0_30ck37 = 3.3 time = 380
* CHECK dout0_31 vdout0_31ck37 = 3.3 time = 380
* CHECK dout0_0 vdout0_0ck38 = 0 time = 390
* CHECK dout0_1 vdout0_1ck38 = 0 time = 390
* CHECK dout0_2 vdout0_2ck38 = 3.3 time = 390
* CHECK dout0_3 vdout0_3ck38 = 3.3 time = 390
* CHECK dout0_4 vdout0_4ck38 = 0 time = 390
* CHECK dout0_5 vdout0_5ck38 = 0 time = 390
* CHECK dout0_6 vdout0_6ck38 = 0 time = 390
* CHECK dout0_7 vdout0_7ck38 = 0 time = 390
* CHECK dout0_8 vdout0_8ck38 = 0 time = 390
* CHECK dout0_9 vdout0_9ck38 = 0 time = 390
* CHECK dout0_10 vdout0_10ck38 = 0 time = 390
* CHECK dout0_11 vdout0_11ck38 = 0 time = 390
* CHECK dout0_12 vdout0_12ck38 = 3.3 time = 390
* CHECK dout0_13 vdout0_13ck38 = 3.3 time = 390
* CHECK dout0_14 vdout0_14ck38 = 0 time = 390
* CHECK dout0_15 vdout0_15ck38 = 3.3 time = 390
* CHECK dout0_16 vdout0_16ck38 = 3.3 time = 390
* CHECK dout0_17 vdout0_17ck38 = 0 time = 390
* CHECK dout0_18 vdout0_18ck38 = 3.3 time = 390
* CHECK dout0_19 vdout0_19ck38 = 0 time = 390
* CHECK dout0_20 vdout0_20ck38 = 3.3 time = 390
* CHECK dout0_21 vdout0_21ck38 = 0 time = 390
* CHECK dout0_22 vdout0_22ck38 = 3.3 time = 390
* CHECK dout0_23 vdout0_23ck38 = 3.3 time = 390
* CHECK dout0_24 vdout0_24ck38 = 0 time = 390
* CHECK dout0_25 vdout0_25ck38 = 3.3 time = 390
* CHECK dout0_26 vdout0_26ck38 = 3.3 time = 390
* CHECK dout0_27 vdout0_27ck38 = 3.3 time = 390
* CHECK dout0_28 vdout0_28ck38 = 0 time = 390
* CHECK dout0_29 vdout0_29ck38 = 0 time = 390
* CHECK dout0_30 vdout0_30ck38 = 0 time = 390
* CHECK dout0_31 vdout0_31ck38 = 0 time = 390
* CHECK dout0_0 vdout0_0ck40 = 0 time = 410
* CHECK dout0_1 vdout0_1ck40 = 0 time = 410
* CHECK dout0_2 vdout0_2ck40 = 3.3 time = 410
* CHECK dout0_3 vdout0_3ck40 = 3.3 time = 410
* CHECK dout0_4 vdout0_4ck40 = 0 time = 410
* CHECK dout0_5 vdout0_5ck40 = 0 time = 410
* CHECK dout0_6 vdout0_6ck40 = 0 time = 410
* CHECK dout0_7 vdout0_7ck40 = 0 time = 410
* CHECK dout0_8 vdout0_8ck40 = 0 time = 410
* CHECK dout0_9 vdout0_9ck40 = 0 time = 410
* CHECK dout0_10 vdout0_10ck40 = 0 time = 410
* CHECK dout0_11 vdout0_11ck40 = 0 time = 410
* CHECK dout0_12 vdout0_12ck40 = 3.3 time = 410
* CHECK dout0_13 vdout0_13ck40 = 3.3 time = 410
* CHECK dout0_14 vdout0_14ck40 = 0 time = 410
* CHECK dout0_15 vdout0_15ck40 = 3.3 time = 410
* CHECK dout0_16 vdout0_16ck40 = 3.3 time = 410
* CHECK dout0_17 vdout0_17ck40 = 0 time = 410
* CHECK dout0_18 vdout0_18ck40 = 3.3 time = 410
* CHECK dout0_19 vdout0_19ck40 = 0 time = 410
* CHECK dout0_20 vdout0_20ck40 = 3.3 time = 410
* CHECK dout0_21 vdout0_21ck40 = 0 time = 410
* CHECK dout0_22 vdout0_22ck40 = 3.3 time = 410
* CHECK dout0_23 vdout0_23ck40 = 3.3 time = 410
* CHECK dout0_24 vdout0_24ck40 = 0 time = 410
* CHECK dout0_25 vdout0_25ck40 = 3.3 time = 410
* CHECK dout0_26 vdout0_26ck40 = 3.3 time = 410
* CHECK dout0_27 vdout0_27ck40 = 3.3 time = 410
* CHECK dout0_28 vdout0_28ck40 = 0 time = 410
* CHECK dout0_29 vdout0_29ck40 = 0 time = 410
* CHECK dout0_30 vdout0_30ck40 = 0 time = 410
* CHECK dout0_31 vdout0_31ck40 = 0 time = 410
* CHECK dout1_0 vdout1_0ck41 = 0 time = 420
* CHECK dout1_1 vdout1_1ck41 = 0 time = 420
* CHECK dout1_2 vdout1_2ck41 = 3.3 time = 420
* CHECK dout1_3 vdout1_3ck41 = 3.3 time = 420
* CHECK dout1_4 vdout1_4ck41 = 0 time = 420
* CHECK dout1_5 vdout1_5ck41 = 0 time = 420
* CHECK dout1_6 vdout1_6ck41 = 0 time = 420
* CHECK dout1_7 vdout1_7ck41 = 0 time = 420
* CHECK dout1_8 vdout1_8ck41 = 0 time = 420
* CHECK dout1_9 vdout1_9ck41 = 0 time = 420
* CHECK dout1_10 vdout1_10ck41 = 0 time = 420
* CHECK dout1_11 vdout1_11ck41 = 0 time = 420
* CHECK dout1_12 vdout1_12ck41 = 3.3 time = 420
* CHECK dout1_13 vdout1_13ck41 = 3.3 time = 420
* CHECK dout1_14 vdout1_14ck41 = 0 time = 420
* CHECK dout1_15 vdout1_15ck41 = 3.3 time = 420
* CHECK dout1_16 vdout1_16ck41 = 3.3 time = 420
* CHECK dout1_17 vdout1_17ck41 = 0 time = 420
* CHECK dout1_18 vdout1_18ck41 = 3.3 time = 420
* CHECK dout1_19 vdout1_19ck41 = 0 time = 420
* CHECK dout1_20 vdout1_20ck41 = 3.3 time = 420
* CHECK dout1_21 vdout1_21ck41 = 0 time = 420
* CHECK dout1_22 vdout1_22ck41 = 3.3 time = 420
* CHECK dout1_23 vdout1_23ck41 = 3.3 time = 420
* CHECK dout1_24 vdout1_24ck41 = 0 time = 420
* CHECK dout1_25 vdout1_25ck41 = 3.3 time = 420
* CHECK dout1_26 vdout1_26ck41 = 3.3 time = 420
* CHECK dout1_27 vdout1_27ck41 = 3.3 time = 420
* CHECK dout1_28 vdout1_28ck41 = 0 time = 420
* CHECK dout1_29 vdout1_29ck41 = 0 time = 420
* CHECK dout1_30 vdout1_30ck41 = 0 time = 420
* CHECK dout1_31 vdout1_31ck41 = 0 time = 420
* CHECK dout0_0 vdout0_0ck44 = 0 time = 450
* CHECK dout0_1 vdout0_1ck44 = 0 time = 450
* CHECK dout0_2 vdout0_2ck44 = 0 time = 450
* CHECK dout0_3 vdout0_3ck44 = 3.3 time = 450
* CHECK dout0_4 vdout0_4ck44 = 3.3 time = 450
* CHECK dout0_5 vdout0_5ck44 = 0 time = 450
* CHECK dout0_6 vdout0_6ck44 = 0 time = 450
* CHECK dout0_7 vdout0_7ck44 = 0 time = 450
* CHECK dout0_8 vdout0_8ck44 = 0 time = 450
* CHECK dout0_9 vdout0_9ck44 = 3.3 time = 450
* CHECK dout0_10 vdout0_10ck44 = 3.3 time = 450
* CHECK dout0_11 vdout0_11ck44 = 0 time = 450
* CHECK dout0_12 vdout0_12ck44 = 3.3 time = 450
* CHECK dout0_13 vdout0_13ck44 = 3.3 time = 450
* CHECK dout0_14 vdout0_14ck44 = 0 time = 450
* CHECK dout0_15 vdout0_15ck44 = 3.3 time = 450
* CHECK dout0_16 vdout0_16ck44 = 0 time = 450
* CHECK dout0_17 vdout0_17ck44 = 3.3 time = 450
* CHECK dout0_18 vdout0_18ck44 = 0 time = 450
* CHECK dout0_19 vdout0_19ck44 = 3.3 time = 450
* CHECK dout0_20 vdout0_20ck44 = 0 time = 450
* CHECK dout0_21 vdout0_21ck44 = 0 time = 450
* CHECK dout0_22 vdout0_22ck44 = 3.3 time = 450
* CHECK dout0_23 vdout0_23ck44 = 0 time = 450
* CHECK dout0_24 vdout0_24ck44 = 3.3 time = 450
* CHECK dout0_25 vdout0_25ck44 = 0 time = 450
* CHECK dout0_26 vdout0_26ck44 = 0 time = 450
* CHECK dout0_27 vdout0_27ck44 = 0 time = 450
* CHECK dout0_28 vdout0_28ck44 = 0 time = 450
* CHECK dout0_29 vdout0_29ck44 = 3.3 time = 450
* CHECK dout0_30 vdout0_30ck44 = 3.3 time = 450
* CHECK dout0_31 vdout0_31ck44 = 3.3 time = 450
* CHECK dout1_0 vdout1_0ck44 = 0 time = 450
* CHECK dout1_1 vdout1_1ck44 = 0 time = 450
* CHECK dout1_2 vdout1_2ck44 = 0 time = 450
* CHECK dout1_3 vdout1_3ck44 = 3.3 time = 450
* CHECK dout1_4 vdout1_4ck44 = 3.3 time = 450
* CHECK dout1_5 vdout1_5ck44 = 0 time = 450
* CHECK dout1_6 vdout1_6ck44 = 0 time = 450
* CHECK dout1_7 vdout1_7ck44 = 0 time = 450
* CHECK dout1_8 vdout1_8ck44 = 0 time = 450
* CHECK dout1_9 vdout1_9ck44 = 3.3 time = 450
* CHECK dout1_10 vdout1_10ck44 = 3.3 time = 450
* CHECK dout1_11 vdout1_11ck44 = 0 time = 450
* CHECK dout1_12 vdout1_12ck44 = 3.3 time = 450
* CHECK dout1_13 vdout1_13ck44 = 3.3 time = 450
* CHECK dout1_14 vdout1_14ck44 = 0 time = 450
* CHECK dout1_15 vdout1_15ck44 = 3.3 time = 450
* CHECK dout1_16 vdout1_16ck44 = 0 time = 450
* CHECK dout1_17 vdout1_17ck44 = 3.3 time = 450
* CHECK dout1_18 vdout1_18ck44 = 0 time = 450
* CHECK dout1_19 vdout1_19ck44 = 3.3 time = 450
* CHECK dout1_20 vdout1_20ck44 = 0 time = 450
* CHECK dout1_21 vdout1_21ck44 = 0 time = 450
* CHECK dout1_22 vdout1_22ck44 = 3.3 time = 450
* CHECK dout1_23 vdout1_23ck44 = 0 time = 450
* CHECK dout1_24 vdout1_24ck44 = 3.3 time = 450
* CHECK dout1_25 vdout1_25ck44 = 0 time = 450
* CHECK dout1_26 vdout1_26ck44 = 0 time = 450
* CHECK dout1_27 vdout1_27ck44 = 0 time = 450
* CHECK dout1_28 vdout1_28ck44 = 0 time = 450
* CHECK dout1_29 vdout1_29ck44 = 3.3 time = 450
* CHECK dout1_30 vdout1_30ck44 = 3.3 time = 450
* CHECK dout1_31 vdout1_31ck44 = 3.3 time = 450
* CHECK dout1_0 vdout1_0ck45 = 0 time = 460
* CHECK dout1_1 vdout1_1ck45 = 0 time = 460
* CHECK dout1_2 vdout1_2ck45 = 0 time = 460
* CHECK dout1_3 vdout1_3ck45 = 3.3 time = 460
* CHECK dout1_4 vdout1_4ck45 = 3.3 time = 460
* CHECK dout1_5 vdout1_5ck45 = 0 time = 460
* CHECK dout1_6 vdout1_6ck45 = 0 time = 460
* CHECK dout1_7 vdout1_7ck45 = 0 time = 460
* CHECK dout1_8 vdout1_8ck45 = 0 time = 460
* CHECK dout1_9 vdout1_9ck45 = 3.3 time = 460
* CHECK dout1_10 vdout1_10ck45 = 3.3 time = 460
* CHECK dout1_11 vdout1_11ck45 = 0 time = 460
* CHECK dout1_12 vdout1_12ck45 = 3.3 time = 460
* CHECK dout1_13 vdout1_13ck45 = 3.3 time = 460
* CHECK dout1_14 vdout1_14ck45 = 0 time = 460
* CHECK dout1_15 vdout1_15ck45 = 3.3 time = 460
* CHECK dout1_16 vdout1_16ck45 = 0 time = 460
* CHECK dout1_17 vdout1_17ck45 = 3.3 time = 460
* CHECK dout1_18 vdout1_18ck45 = 0 time = 460
* CHECK dout1_19 vdout1_19ck45 = 3.3 time = 460
* CHECK dout1_20 vdout1_20ck45 = 0 time = 460
* CHECK dout1_21 vdout1_21ck45 = 0 time = 460
* CHECK dout1_22 vdout1_22ck45 = 3.3 time = 460
* CHECK dout1_23 vdout1_23ck45 = 0 time = 460
* CHECK dout1_24 vdout1_24ck45 = 3.3 time = 460
* CHECK dout1_25 vdout1_25ck45 = 0 time = 460
* CHECK dout1_26 vdout1_26ck45 = 0 time = 460
* CHECK dout1_27 vdout1_27ck45 = 0 time = 460
* CHECK dout1_28 vdout1_28ck45 = 0 time = 460
* CHECK dout1_29 vdout1_29ck45 = 3.3 time = 460
* CHECK dout1_30 vdout1_30ck45 = 3.3 time = 460
* CHECK dout1_31 vdout1_31ck45 = 3.3 time = 460
* CHECK dout1_0 vdout1_0ck46 = 3.3 time = 470
* CHECK dout1_1 vdout1_1ck46 = 0 time = 470
* CHECK dout1_2 vdout1_2ck46 = 3.3 time = 470
* CHECK dout1_3 vdout1_3ck46 = 0 time = 470
* CHECK dout1_4 vdout1_4ck46 = 3.3 time = 470
* CHECK dout1_5 vdout1_5ck46 = 0 time = 470
* CHECK dout1_6 vdout1_6ck46 = 3.3 time = 470
* CHECK dout1_7 vdout1_7ck46 = 3.3 time = 470
* CHECK dout1_8 vdout1_8ck46 = 0 time = 470
* CHECK dout1_9 vdout1_9ck46 = 0 time = 470
* CHECK dout1_10 vdout1_10ck46 = 3.3 time = 470
* CHECK dout1_11 vdout1_11ck46 = 3.3 time = 470
* CHECK dout1_12 vdout1_12ck46 = 0 time = 470
* CHECK dout1_13 vdout1_13ck46 = 3.3 time = 470
* CHECK dout1_14 vdout1_14ck46 = 0 time = 470
* CHECK dout1_15 vdout1_15ck46 = 3.3 time = 470
* CHECK dout1_16 vdout1_16ck46 = 3.3 time = 470
* CHECK dout1_17 vdout1_17ck46 = 3.3 time = 470
* CHECK dout1_18 vdout1_18ck46 = 3.3 time = 470
* CHECK dout1_19 vdout1_19ck46 = 0 time = 470
* CHECK dout1_20 vdout1_20ck46 = 0 time = 470
* CHECK dout1_21 vdout1_21ck46 = 0 time = 470
* CHECK dout1_22 vdout1_22ck46 = 3.3 time = 470
* CHECK dout1_23 vdout1_23ck46 = 0 time = 470
* CHECK dout1_24 vdout1_24ck46 = 3.3 time = 470
* CHECK dout1_25 vdout1_25ck46 = 3.3 time = 470
* CHECK dout1_26 vdout1_26ck46 = 0 time = 470
* CHECK dout1_27 vdout1_27ck46 = 3.3 time = 470
* CHECK dout1_28 vdout1_28ck46 = 0 time = 470
* CHECK dout1_29 vdout1_29ck46 = 3.3 time = 470
* CHECK dout1_30 vdout1_30ck46 = 3.3 time = 470
* CHECK dout1_31 vdout1_31ck46 = 0 time = 470
* CHECK dout1_0 vdout1_0ck48 = 0 time = 490
* CHECK dout1_1 vdout1_1ck48 = 3.3 time = 490
* CHECK dout1_2 vdout1_2ck48 = 0 time = 490
* CHECK dout1_3 vdout1_3ck48 = 3.3 time = 490
* CHECK dout1_4 vdout1_4ck48 = 3.3 time = 490
* CHECK dout1_5 vdout1_5ck48 = 3.3 time = 490
* CHECK dout1_6 vdout1_6ck48 = 3.3 time = 490
* CHECK dout1_7 vdout1_7ck48 = 3.3 time = 490
* CHECK dout1_8 vdout1_8ck48 = 0 time = 490
* CHECK dout1_9 vdout1_9ck48 = 3.3 time = 490
* CHECK dout1_10 vdout1_10ck48 = 0 time = 490
* CHECK dout1_11 vdout1_11ck48 = 0 time = 490
* CHECK dout1_12 vdout1_12ck48 = 3.3 time = 490
* CHECK dout1_13 vdout1_13ck48 = 3.3 time = 490
* CHECK dout1_14 vdout1_14ck48 = 0 time = 490
* CHECK dout1_15 vdout1_15ck48 = 3.3 time = 490
* CHECK dout1_16 vdout1_16ck48 = 0 time = 490
* CHECK dout1_17 vdout1_17ck48 = 3.3 time = 490
* CHECK dout1_18 vdout1_18ck48 = 3.3 time = 490
* CHECK dout1_19 vdout1_19ck48 = 3.3 time = 490
* CHECK dout1_20 vdout1_20ck48 = 0 time = 490
* CHECK dout1_21 vdout1_21ck48 = 0 time = 490
* CHECK dout1_22 vdout1_22ck48 = 3.3 time = 490
* CHECK dout1_23 vdout1_23ck48 = 0 time = 490
* CHECK dout1_24 vdout1_24ck48 = 0 time = 490
* CHECK dout1_25 vdout1_25ck48 = 3.3 time = 490
* CHECK dout1_26 vdout1_26ck48 = 3.3 time = 490
* CHECK dout1_27 vdout1_27ck48 = 3.3 time = 490
* CHECK dout1_28 vdout1_28ck48 = 0 time = 490
* CHECK dout1_29 vdout1_29ck48 = 3.3 time = 490
* CHECK dout1_30 vdout1_30ck48 = 0 time = 490
* CHECK dout1_31 vdout1_31ck48 = 0 time = 490
* CHECK dout1_0 vdout1_0ck49 = 3.3 time = 500
* CHECK dout1_1 vdout1_1ck49 = 0 time = 500
* CHECK dout1_2 vdout1_2ck49 = 3.3 time = 500
* CHECK dout1_3 vdout1_3ck49 = 0 time = 500
* CHECK dout1_4 vdout1_4ck49 = 3.3 time = 500
* CHECK dout1_5 vdout1_5ck49 = 0 time = 500
* CHECK dout1_6 vdout1_6ck49 = 3.3 time = 500
* CHECK dout1_7 vdout1_7ck49 = 3.3 time = 500
* CHECK dout1_8 vdout1_8ck49 = 0 time = 500
* CHECK dout1_9 vdout1_9ck49 = 0 time = 500
* CHECK dout1_10 vdout1_10ck49 = 3.3 time = 500
* CHECK dout1_11 vdout1_11ck49 = 3.3 time = 500
* CHECK dout1_12 vdout1_12ck49 = 0 time = 500
* CHECK dout1_13 vdout1_13ck49 = 3.3 time = 500
* CHECK dout1_14 vdout1_14ck49 = 0 time = 500
* CHECK dout1_15 vdout1_15ck49 = 3.3 time = 500
* CHECK dout1_16 vdout1_16ck49 = 3.3 time = 500
* CHECK dout1_17 vdout1_17ck49 = 3.3 time = 500
* CHECK dout1_18 vdout1_18ck49 = 3.3 time = 500
* CHECK dout1_19 vdout1_19ck49 = 0 time = 500
* CHECK dout1_20 vdout1_20ck49 = 0 time = 500
* CHECK dout1_21 vdout1_21ck49 = 0 time = 500
* CHECK dout1_22 vdout1_22ck49 = 3.3 time = 500
* CHECK dout1_23 vdout1_23ck49 = 0 time = 500
* CHECK dout1_24 vdout1_24ck49 = 3.3 time = 500
* CHECK dout1_25 vdout1_25ck49 = 3.3 time = 500
* CHECK dout1_26 vdout1_26ck49 = 0 time = 500
* CHECK dout1_27 vdout1_27ck49 = 3.3 time = 500
* CHECK dout1_28 vdout1_28ck49 = 0 time = 500
* CHECK dout1_29 vdout1_29ck49 = 3.3 time = 500
* CHECK dout1_30 vdout1_30ck49 = 3.3 time = 500
* CHECK dout1_31 vdout1_31ck49 = 0 time = 500
* CHECK dout0_0 vdout0_0ck50 = 3.3 time = 510
* CHECK dout0_1 vdout0_1ck50 = 0 time = 510
* CHECK dout0_2 vdout0_2ck50 = 3.3 time = 510
* CHECK dout0_3 vdout0_3ck50 = 0 time = 510
* CHECK dout0_4 vdout0_4ck50 = 3.3 time = 510
* CHECK dout0_5 vdout0_5ck50 = 0 time = 510
* CHECK dout0_6 vdout0_6ck50 = 3.3 time = 510
* CHECK dout0_7 vdout0_7ck50 = 3.3 time = 510
* CHECK dout0_8 vdout0_8ck50 = 0 time = 510
* CHECK dout0_9 vdout0_9ck50 = 0 time = 510
* CHECK dout0_10 vdout0_10ck50 = 3.3 time = 510
* CHECK dout0_11 vdout0_11ck50 = 3.3 time = 510
* CHECK dout0_12 vdout0_12ck50 = 0 time = 510
* CHECK dout0_13 vdout0_13ck50 = 3.3 time = 510
* CHECK dout0_14 vdout0_14ck50 = 0 time = 510
* CHECK dout0_15 vdout0_15ck50 = 3.3 time = 510
* CHECK dout0_16 vdout0_16ck50 = 3.3 time = 510
* CHECK dout0_17 vdout0_17ck50 = 3.3 time = 510
* CHECK dout0_18 vdout0_18ck50 = 3.3 time = 510
* CHECK dout0_19 vdout0_19ck50 = 0 time = 510
* CHECK dout0_20 vdout0_20ck50 = 0 time = 510
* CHECK dout0_21 vdout0_21ck50 = 0 time = 510
* CHECK dout0_22 vdout0_22ck50 = 3.3 time = 510
* CHECK dout0_23 vdout0_23ck50 = 0 time = 510
* CHECK dout0_24 vdout0_24ck50 = 3.3 time = 510
* CHECK dout0_25 vdout0_25ck50 = 3.3 time = 510
* CHECK dout0_26 vdout0_26ck50 = 0 time = 510
* CHECK dout0_27 vdout0_27ck50 = 3.3 time = 510
* CHECK dout0_28 vdout0_28ck50 = 0 time = 510
* CHECK dout0_29 vdout0_29ck50 = 3.3 time = 510
* CHECK dout0_30 vdout0_30ck50 = 3.3 time = 510
* CHECK dout0_31 vdout0_31ck50 = 0 time = 510
* CHECK dout0_0 vdout0_0ck51 = 3.3 time = 520
* CHECK dout0_1 vdout0_1ck51 = 0 time = 520
* CHECK dout0_2 vdout0_2ck51 = 3.3 time = 520
* CHECK dout0_3 vdout0_3ck51 = 0 time = 520
* CHECK dout0_4 vdout0_4ck51 = 3.3 time = 520
* CHECK dout0_5 vdout0_5ck51 = 0 time = 520
* CHECK dout0_6 vdout0_6ck51 = 3.3 time = 520
* CHECK dout0_7 vdout0_7ck51 = 3.3 time = 520
* CHECK dout0_8 vdout0_8ck51 = 0 time = 520
* CHECK dout0_9 vdout0_9ck51 = 0 time = 520
* CHECK dout0_10 vdout0_10ck51 = 3.3 time = 520
* CHECK dout0_11 vdout0_11ck51 = 3.3 time = 520
* CHECK dout0_12 vdout0_12ck51 = 0 time = 520
* CHECK dout0_13 vdout0_13ck51 = 3.3 time = 520
* CHECK dout0_14 vdout0_14ck51 = 0 time = 520
* CHECK dout0_15 vdout0_15ck51 = 3.3 time = 520
* CHECK dout0_16 vdout0_16ck51 = 3.3 time = 520
* CHECK dout0_17 vdout0_17ck51 = 3.3 time = 520
* CHECK dout0_18 vdout0_18ck51 = 3.3 time = 520
* CHECK dout0_19 vdout0_19ck51 = 0 time = 520
* CHECK dout0_20 vdout0_20ck51 = 0 time = 520
* CHECK dout0_21 vdout0_21ck51 = 0 time = 520
* CHECK dout0_22 vdout0_22ck51 = 3.3 time = 520
* CHECK dout0_23 vdout0_23ck51 = 0 time = 520
* CHECK dout0_24 vdout0_24ck51 = 3.3 time = 520
* CHECK dout0_25 vdout0_25ck51 = 3.3 time = 520
* CHECK dout0_26 vdout0_26ck51 = 0 time = 520
* CHECK dout0_27 vdout0_27ck51 = 3.3 time = 520
* CHECK dout0_28 vdout0_28ck51 = 0 time = 520
* CHECK dout0_29 vdout0_29ck51 = 3.3 time = 520
* CHECK dout0_30 vdout0_30ck51 = 3.3 time = 520
* CHECK dout0_31 vdout0_31ck51 = 0 time = 520
* CHECK dout1_0 vdout1_0ck51 = 3.3 time = 520
* CHECK dout1_1 vdout1_1ck51 = 0 time = 520
* CHECK dout1_2 vdout1_2ck51 = 0 time = 520
* CHECK dout1_3 vdout1_3ck51 = 0 time = 520
* CHECK dout1_4 vdout1_4ck51 = 0 time = 520
* CHECK dout1_5 vdout1_5ck51 = 3.3 time = 520
* CHECK dout1_6 vdout1_6ck51 = 0 time = 520
* CHECK dout1_7 vdout1_7ck51 = 0 time = 520
* CHECK dout1_8 vdout1_8ck51 = 3.3 time = 520
* CHECK dout1_9 vdout1_9ck51 = 0 time = 520
* CHECK dout1_10 vdout1_10ck51 = 0 time = 520
* CHECK dout1_11 vdout1_11ck51 = 0 time = 520
* CHECK dout1_12 vdout1_12ck51 = 0 time = 520
* CHECK dout1_13 vdout1_13ck51 = 3.3 time = 520
* CHECK dout1_14 vdout1_14ck51 = 3.3 time = 520
* CHECK dout1_15 vdout1_15ck51 = 3.3 time = 520
* CHECK dout1_16 vdout1_16ck51 = 0 time = 520
* CHECK dout1_17 vdout1_17ck51 = 0 time = 520
* CHECK dout1_18 vdout1_18ck51 = 0 time = 520
* CHECK dout1_19 vdout1_19ck51 = 3.3 time = 520
* CHECK dout1_20 vdout1_20ck51 = 0 time = 520
* CHECK dout1_21 vdout1_21ck51 = 0 time = 520
* CHECK dout1_22 vdout1_22ck51 = 0 time = 520
* CHECK dout1_23 vdout1_23ck51 = 0 time = 520
* CHECK dout1_24 vdout1_24ck51 = 3.3 time = 520
* CHECK dout1_25 vdout1_25ck51 = 0 time = 520
* CHECK dout1_26 vdout1_26ck51 = 0 time = 520
* CHECK dout1_27 vdout1_27ck51 = 3.3 time = 520
* CHECK dout1_28 vdout1_28ck51 = 0 time = 520
* CHECK dout1_29 vdout1_29ck51 = 3.3 time = 520
* CHECK dout1_30 vdout1_30ck51 = 0 time = 520
* CHECK dout1_31 vdout1_31ck51 = 3.3 time = 520
* CHECK dout0_0 vdout0_0ck52 = 3.3 time = 530
* CHECK dout0_1 vdout0_1ck52 = 0 time = 530
* CHECK dout0_2 vdout0_2ck52 = 3.3 time = 530
* CHECK dout0_3 vdout0_3ck52 = 0 time = 530
* CHECK dout0_4 vdout0_4ck52 = 3.3 time = 530
* CHECK dout0_5 vdout0_5ck52 = 0 time = 530
* CHECK dout0_6 vdout0_6ck52 = 3.3 time = 530
* CHECK dout0_7 vdout0_7ck52 = 3.3 time = 530
* CHECK dout0_8 vdout0_8ck52 = 0 time = 530
* CHECK dout0_9 vdout0_9ck52 = 0 time = 530
* CHECK dout0_10 vdout0_10ck52 = 3.3 time = 530
* CHECK dout0_11 vdout0_11ck52 = 3.3 time = 530
* CHECK dout0_12 vdout0_12ck52 = 0 time = 530
* CHECK dout0_13 vdout0_13ck52 = 3.3 time = 530
* CHECK dout0_14 vdout0_14ck52 = 0 time = 530
* CHECK dout0_15 vdout0_15ck52 = 3.3 time = 530
* CHECK dout0_16 vdout0_16ck52 = 3.3 time = 530
* CHECK dout0_17 vdout0_17ck52 = 3.3 time = 530
* CHECK dout0_18 vdout0_18ck52 = 3.3 time = 530
* CHECK dout0_19 vdout0_19ck52 = 0 time = 530
* CHECK dout0_20 vdout0_20ck52 = 0 time = 530
* CHECK dout0_21 vdout0_21ck52 = 0 time = 530
* CHECK dout0_22 vdout0_22ck52 = 3.3 time = 530
* CHECK dout0_23 vdout0_23ck52 = 0 time = 530
* CHECK dout0_24 vdout0_24ck52 = 3.3 time = 530
* CHECK dout0_25 vdout0_25ck52 = 3.3 time = 530
* CHECK dout0_26 vdout0_26ck52 = 0 time = 530
* CHECK dout0_27 vdout0_27ck52 = 3.3 time = 530
* CHECK dout0_28 vdout0_28ck52 = 0 time = 530
* CHECK dout0_29 vdout0_29ck52 = 3.3 time = 530
* CHECK dout0_30 vdout0_30ck52 = 3.3 time = 530
* CHECK dout0_31 vdout0_31ck52 = 0 time = 530
* CHECK dout1_0 vdout1_0ck52 = 3.3 time = 530
* CHECK dout1_1 vdout1_1ck52 = 0 time = 530
* CHECK dout1_2 vdout1_2ck52 = 0 time = 530
* CHECK dout1_3 vdout1_3ck52 = 0 time = 530
* CHECK dout1_4 vdout1_4ck52 = 0 time = 530
* CHECK dout1_5 vdout1_5ck52 = 3.3 time = 530
* CHECK dout1_6 vdout1_6ck52 = 0 time = 530
* CHECK dout1_7 vdout1_7ck52 = 0 time = 530
* CHECK dout1_8 vdout1_8ck52 = 3.3 time = 530
* CHECK dout1_9 vdout1_9ck52 = 0 time = 530
* CHECK dout1_10 vdout1_10ck52 = 0 time = 530
* CHECK dout1_11 vdout1_11ck52 = 0 time = 530
* CHECK dout1_12 vdout1_12ck52 = 0 time = 530
* CHECK dout1_13 vdout1_13ck52 = 3.3 time = 530
* CHECK dout1_14 vdout1_14ck52 = 3.3 time = 530
* CHECK dout1_15 vdout1_15ck52 = 3.3 time = 530
* CHECK dout1_16 vdout1_16ck52 = 0 time = 530
* CHECK dout1_17 vdout1_17ck52 = 0 time = 530
* CHECK dout1_18 vdout1_18ck52 = 0 time = 530
* CHECK dout1_19 vdout1_19ck52 = 3.3 time = 530
* CHECK dout1_20 vdout1_20ck52 = 0 time = 530
* CHECK dout1_21 vdout1_21ck52 = 0 time = 530
* CHECK dout1_22 vdout1_22ck52 = 0 time = 530
* CHECK dout1_23 vdout1_23ck52 = 0 time = 530
* CHECK dout1_24 vdout1_24ck52 = 3.3 time = 530
* CHECK dout1_25 vdout1_25ck52 = 0 time = 530
* CHECK dout1_26 vdout1_26ck52 = 0 time = 530
* CHECK dout1_27 vdout1_27ck52 = 3.3 time = 530
* CHECK dout1_28 vdout1_28ck52 = 0 time = 530
* CHECK dout1_29 vdout1_29ck52 = 3.3 time = 530
* CHECK dout1_30 vdout1_30ck52 = 0 time = 530
* CHECK dout1_31 vdout1_31ck52 = 3.3 time = 530
* CHECK dout1_0 vdout1_0ck55 = 3.3 time = 560
* CHECK dout1_1 vdout1_1ck55 = 0 time = 560
* CHECK dout1_2 vdout1_2ck55 = 3.3 time = 560
* CHECK dout1_3 vdout1_3ck55 = 0 time = 560
* CHECK dout1_4 vdout1_4ck55 = 3.3 time = 560
* CHECK dout1_5 vdout1_5ck55 = 0 time = 560
* CHECK dout1_6 vdout1_6ck55 = 3.3 time = 560
* CHECK dout1_7 vdout1_7ck55 = 3.3 time = 560
* CHECK dout1_8 vdout1_8ck55 = 0 time = 560
* CHECK dout1_9 vdout1_9ck55 = 0 time = 560
* CHECK dout1_10 vdout1_10ck55 = 3.3 time = 560
* CHECK dout1_11 vdout1_11ck55 = 3.3 time = 560
* CHECK dout1_12 vdout1_12ck55 = 0 time = 560
* CHECK dout1_13 vdout1_13ck55 = 3.3 time = 560
* CHECK dout1_14 vdout1_14ck55 = 0 time = 560
* CHECK dout1_15 vdout1_15ck55 = 3.3 time = 560
* CHECK dout1_16 vdout1_16ck55 = 3.3 time = 560
* CHECK dout1_17 vdout1_17ck55 = 3.3 time = 560
* CHECK dout1_18 vdout1_18ck55 = 3.3 time = 560
* CHECK dout1_19 vdout1_19ck55 = 0 time = 560
* CHECK dout1_20 vdout1_20ck55 = 0 time = 560
* CHECK dout1_21 vdout1_21ck55 = 0 time = 560
* CHECK dout1_22 vdout1_22ck55 = 3.3 time = 560
* CHECK dout1_23 vdout1_23ck55 = 0 time = 560
* CHECK dout1_24 vdout1_24ck55 = 3.3 time = 560
* CHECK dout1_25 vdout1_25ck55 = 3.3 time = 560
* CHECK dout1_26 vdout1_26ck55 = 0 time = 560
* CHECK dout1_27 vdout1_27ck55 = 3.3 time = 560
* CHECK dout1_28 vdout1_28ck55 = 0 time = 560
* CHECK dout1_29 vdout1_29ck55 = 3.3 time = 560
* CHECK dout1_30 vdout1_30ck55 = 3.3 time = 560
* CHECK dout1_31 vdout1_31ck55 = 0 time = 560
* CHECK dout0_0 vdout0_0ck57 = 0 time = 580
* CHECK dout0_1 vdout0_1ck57 = 3.3 time = 580
* CHECK dout0_2 vdout0_2ck57 = 0 time = 580
* CHECK dout0_3 vdout0_3ck57 = 0 time = 580
* CHECK dout0_4 vdout0_4ck57 = 0 time = 580
* CHECK dout0_5 vdout0_5ck57 = 3.3 time = 580
* CHECK dout0_6 vdout0_6ck57 = 0 time = 580
* CHECK dout0_7 vdout0_7ck57 = 0 time = 580
* CHECK dout0_8 vdout0_8ck57 = 0 time = 580
* CHECK dout0_9 vdout0_9ck57 = 0 time = 580
* CHECK dout0_10 vdout0_10ck57 = 0 time = 580
* CHECK dout0_11 vdout0_11ck57 = 3.3 time = 580
* CHECK dout0_12 vdout0_12ck57 = 3.3 time = 580
* CHECK dout0_13 vdout0_13ck57 = 0 time = 580
* CHECK dout0_14 vdout0_14ck57 = 3.3 time = 580
* CHECK dout0_15 vdout0_15ck57 = 0 time = 580
* CHECK dout0_16 vdout0_16ck57 = 0 time = 580
* CHECK dout0_17 vdout0_17ck57 = 3.3 time = 580
* CHECK dout0_18 vdout0_18ck57 = 0 time = 580
* CHECK dout0_19 vdout0_19ck57 = 0 time = 580
* CHECK dout0_20 vdout0_20ck57 = 3.3 time = 580
* CHECK dout0_21 vdout0_21ck57 = 0 time = 580
* CHECK dout0_22 vdout0_22ck57 = 0 time = 580
* CHECK dout0_23 vdout0_23ck57 = 0 time = 580
* CHECK dout0_24 vdout0_24ck57 = 3.3 time = 580
* CHECK dout0_25 vdout0_25ck57 = 3.3 time = 580
* CHECK dout0_26 vdout0_26ck57 = 0 time = 580
* CHECK dout0_27 vdout0_27ck57 = 3.3 time = 580
* CHECK dout0_28 vdout0_28ck57 = 0 time = 580
* CHECK dout0_29 vdout0_29ck57 = 3.3 time = 580
* CHECK dout0_30 vdout0_30ck57 = 0 time = 580
* CHECK dout0_31 vdout0_31ck57 = 3.3 time = 580
* CHECK dout1_0 vdout1_0ck57 = 0 time = 580
* CHECK dout1_1 vdout1_1ck57 = 3.3 time = 580
* CHECK dout1_2 vdout1_2ck57 = 0 time = 580
* CHECK dout1_3 vdout1_3ck57 = 0 time = 580
* CHECK dout1_4 vdout1_4ck57 = 3.3 time = 580
* CHECK dout1_5 vdout1_5ck57 = 0 time = 580
* CHECK dout1_6 vdout1_6ck57 = 3.3 time = 580
* CHECK dout1_7 vdout1_7ck57 = 3.3 time = 580
* CHECK dout1_8 vdout1_8ck57 = 3.3 time = 580
* CHECK dout1_9 vdout1_9ck57 = 3.3 time = 580
* CHECK dout1_10 vdout1_10ck57 = 3.3 time = 580
* CHECK dout1_11 vdout1_11ck57 = 0 time = 580
* CHECK dout1_12 vdout1_12ck57 = 3.3 time = 580
* CHECK dout1_13 vdout1_13ck57 = 0 time = 580
* CHECK dout1_14 vdout1_14ck57 = 3.3 time = 580
* CHECK dout1_15 vdout1_15ck57 = 0 time = 580
* CHECK dout1_16 vdout1_16ck57 = 0 time = 580
* CHECK dout1_17 vdout1_17ck57 = 3.3 time = 580
* CHECK dout1_18 vdout1_18ck57 = 3.3 time = 580
* CHECK dout1_19 vdout1_19ck57 = 3.3 time = 580
* CHECK dout1_20 vdout1_20ck57 = 3.3 time = 580
* CHECK dout1_21 vdout1_21ck57 = 0 time = 580
* CHECK dout1_22 vdout1_22ck57 = 3.3 time = 580
* CHECK dout1_23 vdout1_23ck57 = 0 time = 580
* CHECK dout1_24 vdout1_24ck57 = 3.3 time = 580
* CHECK dout1_25 vdout1_25ck57 = 3.3 time = 580
* CHECK dout1_26 vdout1_26ck57 = 0 time = 580
* CHECK dout1_27 vdout1_27ck57 = 0 time = 580
* CHECK dout1_28 vdout1_28ck57 = 3.3 time = 580
* CHECK dout1_29 vdout1_29ck57 = 0 time = 580
* CHECK dout1_30 vdout1_30ck57 = 0 time = 580
* CHECK dout1_31 vdout1_31ck57 = 3.3 time = 580
* CHECK dout0_0 vdout0_0ck59 = 3.3 time = 600
* CHECK dout0_1 vdout0_1ck59 = 0 time = 600
* CHECK dout0_2 vdout0_2ck59 = 3.3 time = 600
* CHECK dout0_3 vdout0_3ck59 = 3.3 time = 600
* CHECK dout0_4 vdout0_4ck59 = 3.3 time = 600
* CHECK dout0_5 vdout0_5ck59 = 0 time = 600
* CHECK dout0_6 vdout0_6ck59 = 3.3 time = 600
* CHECK dout0_7 vdout0_7ck59 = 3.3 time = 600
* CHECK dout0_8 vdout0_8ck59 = 0 time = 600
* CHECK dout0_9 vdout0_9ck59 = 0 time = 600
* CHECK dout0_10 vdout0_10ck59 = 3.3 time = 600
* CHECK dout0_11 vdout0_11ck59 = 0 time = 600
* CHECK dout0_12 vdout0_12ck59 = 3.3 time = 600
* CHECK dout0_13 vdout0_13ck59 = 0 time = 600
* CHECK dout0_14 vdout0_14ck59 = 3.3 time = 600
* CHECK dout0_15 vdout0_15ck59 = 3.3 time = 600
* CHECK dout0_16 vdout0_16ck59 = 0 time = 600
* CHECK dout0_17 vdout0_17ck59 = 0 time = 600
* CHECK dout0_18 vdout0_18ck59 = 3.3 time = 600
* CHECK dout0_19 vdout0_19ck59 = 0 time = 600
* CHECK dout0_20 vdout0_20ck59 = 0 time = 600
* CHECK dout0_21 vdout0_21ck59 = 3.3 time = 600
* CHECK dout0_22 vdout0_22ck59 = 3.3 time = 600
* CHECK dout0_23 vdout0_23ck59 = 3.3 time = 600
* CHECK dout0_24 vdout0_24ck59 = 0 time = 600
* CHECK dout0_25 vdout0_25ck59 = 3.3 time = 600
* CHECK dout0_26 vdout0_26ck59 = 3.3 time = 600
* CHECK dout0_27 vdout0_27ck59 = 0 time = 600
* CHECK dout0_28 vdout0_28ck59 = 3.3 time = 600
* CHECK dout0_29 vdout0_29ck59 = 3.3 time = 600
* CHECK dout0_30 vdout0_30ck59 = 0 time = 600
* CHECK dout0_31 vdout0_31ck59 = 0 time = 600
* CHECK dout1_0 vdout1_0ck59 = 0 time = 600
* CHECK dout1_1 vdout1_1ck59 = 3.3 time = 600
* CHECK dout1_2 vdout1_2ck59 = 0 time = 600
* CHECK dout1_3 vdout1_3ck59 = 0 time = 600
* CHECK dout1_4 vdout1_4ck59 = 0 time = 600
* CHECK dout1_5 vdout1_5ck59 = 3.3 time = 600
* CHECK dout1_6 vdout1_6ck59 = 0 time = 600
* CHECK dout1_7 vdout1_7ck59 = 0 time = 600
* CHECK dout1_8 vdout1_8ck59 = 0 time = 600
* CHECK dout1_9 vdout1_9ck59 = 0 time = 600
* CHECK dout1_10 vdout1_10ck59 = 0 time = 600
* CHECK dout1_11 vdout1_11ck59 = 3.3 time = 600
* CHECK dout1_12 vdout1_12ck59 = 3.3 time = 600
* CHECK dout1_13 vdout1_13ck59 = 0 time = 600
* CHECK dout1_14 vdout1_14ck59 = 3.3 time = 600
* CHECK dout1_15 vdout1_15ck59 = 0 time = 600
* CHECK dout1_16 vdout1_16ck59 = 0 time = 600
* CHECK dout1_17 vdout1_17ck59 = 3.3 time = 600
* CHECK dout1_18 vdout1_18ck59 = 0 time = 600
* CHECK dout1_19 vdout1_19ck59 = 0 time = 600
* CHECK dout1_20 vdout1_20ck59 = 3.3 time = 600
* CHECK dout1_21 vdout1_21ck59 = 0 time = 600
* CHECK dout1_22 vdout1_22ck59 = 0 time = 600
* CHECK dout1_23 vdout1_23ck59 = 0 time = 600
* CHECK dout1_24 vdout1_24ck59 = 3.3 time = 600
* CHECK dout1_25 vdout1_25ck59 = 3.3 time = 600
* CHECK dout1_26 vdout1_26ck59 = 0 time = 600
* CHECK dout1_27 vdout1_27ck59 = 3.3 time = 600
* CHECK dout1_28 vdout1_28ck59 = 0 time = 600
* CHECK dout1_29 vdout1_29ck59 = 3.3 time = 600
* CHECK dout1_30 vdout1_30ck59 = 0 time = 600
* CHECK dout1_31 vdout1_31ck59 = 3.3 time = 600
* CHECK dout0_0 vdout0_0ck60 = 0 time = 610
* CHECK dout0_1 vdout0_1ck60 = 3.3 time = 610
* CHECK dout0_2 vdout0_2ck60 = 0 time = 610
* CHECK dout0_3 vdout0_3ck60 = 0 time = 610
* CHECK dout0_4 vdout0_4ck60 = 0 time = 610
* CHECK dout0_5 vdout0_5ck60 = 3.3 time = 610
* CHECK dout0_6 vdout0_6ck60 = 0 time = 610
* CHECK dout0_7 vdout0_7ck60 = 0 time = 610
* CHECK dout0_8 vdout0_8ck60 = 0 time = 610
* CHECK dout0_9 vdout0_9ck60 = 0 time = 610
* CHECK dout0_10 vdout0_10ck60 = 0 time = 610
* CHECK dout0_11 vdout0_11ck60 = 3.3 time = 610
* CHECK dout0_12 vdout0_12ck60 = 3.3 time = 610
* CHECK dout0_13 vdout0_13ck60 = 0 time = 610
* CHECK dout0_14 vdout0_14ck60 = 3.3 time = 610
* CHECK dout0_15 vdout0_15ck60 = 0 time = 610
* CHECK dout0_16 vdout0_16ck60 = 0 time = 610
* CHECK dout0_17 vdout0_17ck60 = 3.3 time = 610
* CHECK dout0_18 vdout0_18ck60 = 0 time = 610
* CHECK dout0_19 vdout0_19ck60 = 0 time = 610
* CHECK dout0_20 vdout0_20ck60 = 3.3 time = 610
* CHECK dout0_21 vdout0_21ck60 = 0 time = 610
* CHECK dout0_22 vdout0_22ck60 = 0 time = 610
* CHECK dout0_23 vdout0_23ck60 = 0 time = 610
* CHECK dout0_24 vdout0_24ck60 = 3.3 time = 610
* CHECK dout0_25 vdout0_25ck60 = 3.3 time = 610
* CHECK dout0_26 vdout0_26ck60 = 0 time = 610
* CHECK dout0_27 vdout0_27ck60 = 3.3 time = 610
* CHECK dout0_28 vdout0_28ck60 = 0 time = 610
* CHECK dout0_29 vdout0_29ck60 = 3.3 time = 610
* CHECK dout0_30 vdout0_30ck60 = 0 time = 610
* CHECK dout0_31 vdout0_31ck60 = 3.3 time = 610
* CHECK dout1_0 vdout1_0ck60 = 0 time = 610
* CHECK dout1_1 vdout1_1ck60 = 3.3 time = 610
* CHECK dout1_2 vdout1_2ck60 = 0 time = 610
* CHECK dout1_3 vdout1_3ck60 = 0 time = 610
* CHECK dout1_4 vdout1_4ck60 = 0 time = 610
* CHECK dout1_5 vdout1_5ck60 = 3.3 time = 610
* CHECK dout1_6 vdout1_6ck60 = 0 time = 610
* CHECK dout1_7 vdout1_7ck60 = 0 time = 610
* CHECK dout1_8 vdout1_8ck60 = 0 time = 610
* CHECK dout1_9 vdout1_9ck60 = 0 time = 610
* CHECK dout1_10 vdout1_10ck60 = 0 time = 610
* CHECK dout1_11 vdout1_11ck60 = 3.3 time = 610
* CHECK dout1_12 vdout1_12ck60 = 3.3 time = 610
* CHECK dout1_13 vdout1_13ck60 = 0 time = 610
* CHECK dout1_14 vdout1_14ck60 = 3.3 time = 610
* CHECK dout1_15 vdout1_15ck60 = 0 time = 610
* CHECK dout1_16 vdout1_16ck60 = 0 time = 610
* CHECK dout1_17 vdout1_17ck60 = 3.3 time = 610
* CHECK dout1_18 vdout1_18ck60 = 0 time = 610
* CHECK dout1_19 vdout1_19ck60 = 0 time = 610
* CHECK dout1_20 vdout1_20ck60 = 3.3 time = 610
* CHECK dout1_21 vdout1_21ck60 = 0 time = 610
* CHECK dout1_22 vdout1_22ck60 = 0 time = 610
* CHECK dout1_23 vdout1_23ck60 = 0 time = 610
* CHECK dout1_24 vdout1_24ck60 = 3.3 time = 610
* CHECK dout1_25 vdout1_25ck60 = 3.3 time = 610
* CHECK dout1_26 vdout1_26ck60 = 0 time = 610
* CHECK dout1_27 vdout1_27ck60 = 3.3 time = 610
* CHECK dout1_28 vdout1_28ck60 = 0 time = 610
* CHECK dout1_29 vdout1_29ck60 = 3.3 time = 610
* CHECK dout1_30 vdout1_30ck60 = 0 time = 610
* CHECK dout1_31 vdout1_31ck60 = 3.3 time = 610
* CHECK dout1_0 vdout1_0ck62 = 3.3 time = 630
* CHECK dout1_1 vdout1_1ck62 = 3.3 time = 630
* CHECK dout1_2 vdout1_2ck62 = 3.3 time = 630
* CHECK dout1_3 vdout1_3ck62 = 3.3 time = 630
* CHECK dout1_4 vdout1_4ck62 = 3.3 time = 630
* CHECK dout1_5 vdout1_5ck62 = 3.3 time = 630
* CHECK dout1_6 vdout1_6ck62 = 0 time = 630
* CHECK dout1_7 vdout1_7ck62 = 3.3 time = 630
* CHECK dout1_8 vdout1_8ck62 = 0 time = 630
* CHECK dout1_9 vdout1_9ck62 = 0 time = 630
* CHECK dout1_10 vdout1_10ck62 = 0 time = 630
* CHECK dout1_11 vdout1_11ck62 = 3.3 time = 630
* CHECK dout1_12 vdout1_12ck62 = 3.3 time = 630
* CHECK dout1_13 vdout1_13ck62 = 3.3 time = 630
* CHECK dout1_14 vdout1_14ck62 = 0 time = 630
* CHECK dout1_15 vdout1_15ck62 = 0 time = 630
* CHECK dout1_16 vdout1_16ck62 = 0 time = 630
* CHECK dout1_17 vdout1_17ck62 = 3.3 time = 630
* CHECK dout1_18 vdout1_18ck62 = 3.3 time = 630
* CHECK dout1_19 vdout1_19ck62 = 3.3 time = 630
* CHECK dout1_20 vdout1_20ck62 = 0 time = 630
* CHECK dout1_21 vdout1_21ck62 = 0 time = 630
* CHECK dout1_22 vdout1_22ck62 = 3.3 time = 630
* CHECK dout1_23 vdout1_23ck62 = 3.3 time = 630
* CHECK dout1_24 vdout1_24ck62 = 3.3 time = 630
* CHECK dout1_25 vdout1_25ck62 = 0 time = 630
* CHECK dout1_26 vdout1_26ck62 = 3.3 time = 630
* CHECK dout1_27 vdout1_27ck62 = 3.3 time = 630
* CHECK dout1_28 vdout1_28ck62 = 0 time = 630
* CHECK dout1_29 vdout1_29ck62 = 0 time = 630
* CHECK dout1_30 vdout1_30ck62 = 3.3 time = 630
* CHECK dout1_31 vdout1_31ck62 = 3.3 time = 630
* CHECK dout0_0 vdout0_0ck63 = 0 time = 640
* CHECK dout0_1 vdout0_1ck63 = 3.3 time = 640
* CHECK dout0_2 vdout0_2ck63 = 0 time = 640
* CHECK dout0_3 vdout0_3ck63 = 0 time = 640
* CHECK dout0_4 vdout0_4ck63 = 0 time = 640
* CHECK dout0_5 vdout0_5ck63 = 3.3 time = 640
* CHECK dout0_6 vdout0_6ck63 = 0 time = 640
* CHECK dout0_7 vdout0_7ck63 = 0 time = 640
* CHECK dout0_8 vdout0_8ck63 = 0 time = 640
* CHECK dout0_9 vdout0_9ck63 = 0 time = 640
* CHECK dout0_10 vdout0_10ck63 = 0 time = 640
* CHECK dout0_11 vdout0_11ck63 = 3.3 time = 640
* CHECK dout0_12 vdout0_12ck63 = 3.3 time = 640
* CHECK dout0_13 vdout0_13ck63 = 0 time = 640
* CHECK dout0_14 vdout0_14ck63 = 3.3 time = 640
* CHECK dout0_15 vdout0_15ck63 = 0 time = 640
* CHECK dout0_16 vdout0_16ck63 = 0 time = 640
* CHECK dout0_17 vdout0_17ck63 = 3.3 time = 640
* CHECK dout0_18 vdout0_18ck63 = 0 time = 640
* CHECK dout0_19 vdout0_19ck63 = 0 time = 640
* CHECK dout0_20 vdout0_20ck63 = 3.3 time = 640
* CHECK dout0_21 vdout0_21ck63 = 0 time = 640
* CHECK dout0_22 vdout0_22ck63 = 0 time = 640
* CHECK dout0_23 vdout0_23ck63 = 0 time = 640
* CHECK dout0_24 vdout0_24ck63 = 3.3 time = 640
* CHECK dout0_25 vdout0_25ck63 = 3.3 time = 640
* CHECK dout0_26 vdout0_26ck63 = 0 time = 640
* CHECK dout0_27 vdout0_27ck63 = 3.3 time = 640
* CHECK dout0_28 vdout0_28ck63 = 0 time = 640
* CHECK dout0_29 vdout0_29ck63 = 3.3 time = 640
* CHECK dout0_30 vdout0_30ck63 = 0 time = 640
* CHECK dout0_31 vdout0_31ck63 = 3.3 time = 640
* CHECK dout1_0 vdout1_0ck64 = 0 time = 650
* CHECK dout1_1 vdout1_1ck64 = 3.3 time = 650
* CHECK dout1_2 vdout1_2ck64 = 0 time = 650
* CHECK dout1_3 vdout1_3ck64 = 0 time = 650
* CHECK dout1_4 vdout1_4ck64 = 0 time = 650
* CHECK dout1_5 vdout1_5ck64 = 3.3 time = 650
* CHECK dout1_6 vdout1_6ck64 = 0 time = 650
* CHECK dout1_7 vdout1_7ck64 = 0 time = 650
* CHECK dout1_8 vdout1_8ck64 = 0 time = 650
* CHECK dout1_9 vdout1_9ck64 = 0 time = 650
* CHECK dout1_10 vdout1_10ck64 = 0 time = 650
* CHECK dout1_11 vdout1_11ck64 = 3.3 time = 650
* CHECK dout1_12 vdout1_12ck64 = 3.3 time = 650
* CHECK dout1_13 vdout1_13ck64 = 0 time = 650
* CHECK dout1_14 vdout1_14ck64 = 3.3 time = 650
* CHECK dout1_15 vdout1_15ck64 = 0 time = 650
* CHECK dout1_16 vdout1_16ck64 = 0 time = 650
* CHECK dout1_17 vdout1_17ck64 = 3.3 time = 650
* CHECK dout1_18 vdout1_18ck64 = 0 time = 650
* CHECK dout1_19 vdout1_19ck64 = 0 time = 650
* CHECK dout1_20 vdout1_20ck64 = 3.3 time = 650
* CHECK dout1_21 vdout1_21ck64 = 0 time = 650
* CHECK dout1_22 vdout1_22ck64 = 0 time = 650
* CHECK dout1_23 vdout1_23ck64 = 0 time = 650
* CHECK dout1_24 vdout1_24ck64 = 3.3 time = 650
* CHECK dout1_25 vdout1_25ck64 = 3.3 time = 650
* CHECK dout1_26 vdout1_26ck64 = 0 time = 650
* CHECK dout1_27 vdout1_27ck64 = 3.3 time = 650
* CHECK dout1_28 vdout1_28ck64 = 0 time = 650
* CHECK dout1_29 vdout1_29ck64 = 3.3 time = 650
* CHECK dout1_30 vdout1_30ck64 = 0 time = 650
* CHECK dout1_31 vdout1_31ck64 = 3.3 time = 650
* CHECK dout1_0 vdout1_0ck65 = 0 time = 660
* CHECK dout1_1 vdout1_1ck65 = 3.3 time = 660
* CHECK dout1_2 vdout1_2ck65 = 0 time = 660
* CHECK dout1_3 vdout1_3ck65 = 0 time = 660
* CHECK dout1_4 vdout1_4ck65 = 0 time = 660
* CHECK dout1_5 vdout1_5ck65 = 3.3 time = 660
* CHECK dout1_6 vdout1_6ck65 = 0 time = 660
* CHECK dout1_7 vdout1_7ck65 = 0 time = 660
* CHECK dout1_8 vdout1_8ck65 = 0 time = 660
* CHECK dout1_9 vdout1_9ck65 = 0 time = 660
* CHECK dout1_10 vdout1_10ck65 = 0 time = 660
* CHECK dout1_11 vdout1_11ck65 = 3.3 time = 660
* CHECK dout1_12 vdout1_12ck65 = 3.3 time = 660
* CHECK dout1_13 vdout1_13ck65 = 0 time = 660
* CHECK dout1_14 vdout1_14ck65 = 3.3 time = 660
* CHECK dout1_15 vdout1_15ck65 = 0 time = 660
* CHECK dout1_16 vdout1_16ck65 = 0 time = 660
* CHECK dout1_17 vdout1_17ck65 = 3.3 time = 660
* CHECK dout1_18 vdout1_18ck65 = 0 time = 660
* CHECK dout1_19 vdout1_19ck65 = 0 time = 660
* CHECK dout1_20 vdout1_20ck65 = 3.3 time = 660
* CHECK dout1_21 vdout1_21ck65 = 0 time = 660
* CHECK dout1_22 vdout1_22ck65 = 0 time = 660
* CHECK dout1_23 vdout1_23ck65 = 0 time = 660
* CHECK dout1_24 vdout1_24ck65 = 3.3 time = 660
* CHECK dout1_25 vdout1_25ck65 = 3.3 time = 660
* CHECK dout1_26 vdout1_26ck65 = 0 time = 660
* CHECK dout1_27 vdout1_27ck65 = 3.3 time = 660
* CHECK dout1_28 vdout1_28ck65 = 0 time = 660
* CHECK dout1_29 vdout1_29ck65 = 3.3 time = 660
* CHECK dout1_30 vdout1_30ck65 = 0 time = 660
* CHECK dout1_31 vdout1_31ck65 = 3.3 time = 660
* CHECK dout0_0 vdout0_0ck66 = 3.3 time = 670
* CHECK dout0_1 vdout0_1ck66 = 3.3 time = 670
* CHECK dout0_2 vdout0_2ck66 = 3.3 time = 670
* CHECK dout0_3 vdout0_3ck66 = 3.3 time = 670
* CHECK dout0_4 vdout0_4ck66 = 3.3 time = 670
* CHECK dout0_5 vdout0_5ck66 = 3.3 time = 670
* CHECK dout0_6 vdout0_6ck66 = 0 time = 670
* CHECK dout0_7 vdout0_7ck66 = 3.3 time = 670
* CHECK dout0_8 vdout0_8ck66 = 0 time = 670
* CHECK dout0_9 vdout0_9ck66 = 0 time = 670
* CHECK dout0_10 vdout0_10ck66 = 0 time = 670
* CHECK dout0_11 vdout0_11ck66 = 3.3 time = 670
* CHECK dout0_12 vdout0_12ck66 = 3.3 time = 670
* CHECK dout0_13 vdout0_13ck66 = 3.3 time = 670
* CHECK dout0_14 vdout0_14ck66 = 0 time = 670
* CHECK dout0_15 vdout0_15ck66 = 0 time = 670
* CHECK dout0_16 vdout0_16ck66 = 0 time = 670
* CHECK dout0_17 vdout0_17ck66 = 3.3 time = 670
* CHECK dout0_18 vdout0_18ck66 = 3.3 time = 670
* CHECK dout0_19 vdout0_19ck66 = 3.3 time = 670
* CHECK dout0_20 vdout0_20ck66 = 0 time = 670
* CHECK dout0_21 vdout0_21ck66 = 0 time = 670
* CHECK dout0_22 vdout0_22ck66 = 3.3 time = 670
* CHECK dout0_23 vdout0_23ck66 = 3.3 time = 670
* CHECK dout0_24 vdout0_24ck66 = 3.3 time = 670
* CHECK dout0_25 vdout0_25ck66 = 0 time = 670
* CHECK dout0_26 vdout0_26ck66 = 3.3 time = 670
* CHECK dout0_27 vdout0_27ck66 = 3.3 time = 670
* CHECK dout0_28 vdout0_28ck66 = 0 time = 670
* CHECK dout0_29 vdout0_29ck66 = 0 time = 670
* CHECK dout0_30 vdout0_30ck66 = 3.3 time = 670
* CHECK dout0_31 vdout0_31ck66 = 3.3 time = 670
* CHECK dout0_0 vdout0_0ck67 = 0 time = 680
* CHECK dout0_1 vdout0_1ck67 = 0 time = 680
* CHECK dout0_2 vdout0_2ck67 = 0 time = 680
* CHECK dout0_3 vdout0_3ck67 = 0 time = 680
* CHECK dout0_4 vdout0_4ck67 = 3.3 time = 680
* CHECK dout0_5 vdout0_5ck67 = 3.3 time = 680
* CHECK dout0_6 vdout0_6ck67 = 3.3 time = 680
* CHECK dout0_7 vdout0_7ck67 = 3.3 time = 680
* CHECK dout0_8 vdout0_8ck67 = 0 time = 680
* CHECK dout0_9 vdout0_9ck67 = 3.3 time = 680
* CHECK dout0_10 vdout0_10ck67 = 0 time = 680
* CHECK dout0_11 vdout0_11ck67 = 3.3 time = 680
* CHECK dout0_12 vdout0_12ck67 = 0 time = 680
* CHECK dout0_13 vdout0_13ck67 = 0 time = 680
* CHECK dout0_14 vdout0_14ck67 = 0 time = 680
* CHECK dout0_15 vdout0_15ck67 = 3.3 time = 680
* CHECK dout0_16 vdout0_16ck67 = 0 time = 680
* CHECK dout0_17 vdout0_17ck67 = 3.3 time = 680
* CHECK dout0_18 vdout0_18ck67 = 3.3 time = 680
* CHECK dout0_19 vdout0_19ck67 = 3.3 time = 680
* CHECK dout0_20 vdout0_20ck67 = 0 time = 680
* CHECK dout0_21 vdout0_21ck67 = 3.3 time = 680
* CHECK dout0_22 vdout0_22ck67 = 3.3 time = 680
* CHECK dout0_23 vdout0_23ck67 = 3.3 time = 680
* CHECK dout0_24 vdout0_24ck67 = 3.3 time = 680
* CHECK dout0_25 vdout0_25ck67 = 0 time = 680
* CHECK dout0_26 vdout0_26ck67 = 3.3 time = 680
* CHECK dout0_27 vdout0_27ck67 = 0 time = 680
* CHECK dout0_28 vdout0_28ck67 = 3.3 time = 680
* CHECK dout0_29 vdout0_29ck67 = 3.3 time = 680
* CHECK dout0_30 vdout0_30ck67 = 3.3 time = 680
* CHECK dout0_31 vdout0_31ck67 = 0 time = 680
* CHECK dout1_0 vdout1_0ck67 = 0 time = 680
* CHECK dout1_1 vdout1_1ck67 = 0 time = 680
* CHECK dout1_2 vdout1_2ck67 = 0 time = 680
* CHECK dout1_3 vdout1_3ck67 = 0 time = 680
* CHECK dout1_4 vdout1_4ck67 = 3.3 time = 680
* CHECK dout1_5 vdout1_5ck67 = 3.3 time = 680
* CHECK dout1_6 vdout1_6ck67 = 3.3 time = 680
* CHECK dout1_7 vdout1_7ck67 = 3.3 time = 680
* CHECK dout1_8 vdout1_8ck67 = 0 time = 680
* CHECK dout1_9 vdout1_9ck67 = 3.3 time = 680
* CHECK dout1_10 vdout1_10ck67 = 0 time = 680
* CHECK dout1_11 vdout1_11ck67 = 3.3 time = 680
* CHECK dout1_12 vdout1_12ck67 = 0 time = 680
* CHECK dout1_13 vdout1_13ck67 = 0 time = 680
* CHECK dout1_14 vdout1_14ck67 = 0 time = 680
* CHECK dout1_15 vdout1_15ck67 = 3.3 time = 680
* CHECK dout1_16 vdout1_16ck67 = 0 time = 680
* CHECK dout1_17 vdout1_17ck67 = 3.3 time = 680
* CHECK dout1_18 vdout1_18ck67 = 3.3 time = 680
* CHECK dout1_19 vdout1_19ck67 = 3.3 time = 680
* CHECK dout1_20 vdout1_20ck67 = 0 time = 680
* CHECK dout1_21 vdout1_21ck67 = 3.3 time = 680
* CHECK dout1_22 vdout1_22ck67 = 3.3 time = 680
* CHECK dout1_23 vdout1_23ck67 = 3.3 time = 680
* CHECK dout1_24 vdout1_24ck67 = 3.3 time = 680
* CHECK dout1_25 vdout1_25ck67 = 0 time = 680
* CHECK dout1_26 vdout1_26ck67 = 3.3 time = 680
* CHECK dout1_27 vdout1_27ck67 = 0 time = 680
* CHECK dout1_28 vdout1_28ck67 = 3.3 time = 680
* CHECK dout1_29 vdout1_29ck67 = 3.3 time = 680
* CHECK dout1_30 vdout1_30ck67 = 3.3 time = 680
* CHECK dout1_31 vdout1_31ck67 = 0 time = 680
* CHECK dout0_0 vdout0_0ck69 = 0 time = 700
* CHECK dout0_1 vdout0_1ck69 = 0 time = 700
* CHECK dout0_2 vdout0_2ck69 = 0 time = 700
* CHECK dout0_3 vdout0_3ck69 = 0 time = 700
* CHECK dout0_4 vdout0_4ck69 = 3.3 time = 700
* CHECK dout0_5 vdout0_5ck69 = 3.3 time = 700
* CHECK dout0_6 vdout0_6ck69 = 3.3 time = 700
* CHECK dout0_7 vdout0_7ck69 = 3.3 time = 700
* CHECK dout0_8 vdout0_8ck69 = 0 time = 700
* CHECK dout0_9 vdout0_9ck69 = 3.3 time = 700
* CHECK dout0_10 vdout0_10ck69 = 0 time = 700
* CHECK dout0_11 vdout0_11ck69 = 3.3 time = 700
* CHECK dout0_12 vdout0_12ck69 = 0 time = 700
* CHECK dout0_13 vdout0_13ck69 = 0 time = 700
* CHECK dout0_14 vdout0_14ck69 = 0 time = 700
* CHECK dout0_15 vdout0_15ck69 = 3.3 time = 700
* CHECK dout0_16 vdout0_16ck69 = 0 time = 700
* CHECK dout0_17 vdout0_17ck69 = 3.3 time = 700
* CHECK dout0_18 vdout0_18ck69 = 3.3 time = 700
* CHECK dout0_19 vdout0_19ck69 = 3.3 time = 700
* CHECK dout0_20 vdout0_20ck69 = 0 time = 700
* CHECK dout0_21 vdout0_21ck69 = 3.3 time = 700
* CHECK dout0_22 vdout0_22ck69 = 3.3 time = 700
* CHECK dout0_23 vdout0_23ck69 = 3.3 time = 700
* CHECK dout0_24 vdout0_24ck69 = 3.3 time = 700
* CHECK dout0_25 vdout0_25ck69 = 0 time = 700
* CHECK dout0_26 vdout0_26ck69 = 3.3 time = 700
* CHECK dout0_27 vdout0_27ck69 = 0 time = 700
* CHECK dout0_28 vdout0_28ck69 = 3.3 time = 700
* CHECK dout0_29 vdout0_29ck69 = 3.3 time = 700
* CHECK dout0_30 vdout0_30ck69 = 3.3 time = 700
* CHECK dout0_31 vdout0_31ck69 = 0 time = 700
* CHECK dout0_0 vdout0_0ck70 = 0 time = 710
* CHECK dout0_1 vdout0_1ck70 = 0 time = 710
* CHECK dout0_2 vdout0_2ck70 = 0 time = 710
* CHECK dout0_3 vdout0_3ck70 = 0 time = 710
* CHECK dout0_4 vdout0_4ck70 = 3.3 time = 710
* CHECK dout0_5 vdout0_5ck70 = 3.3 time = 710
* CHECK dout0_6 vdout0_6ck70 = 3.3 time = 710
* CHECK dout0_7 vdout0_7ck70 = 3.3 time = 710
* CHECK dout0_8 vdout0_8ck70 = 0 time = 710
* CHECK dout0_9 vdout0_9ck70 = 3.3 time = 710
* CHECK dout0_10 vdout0_10ck70 = 0 time = 710
* CHECK dout0_11 vdout0_11ck70 = 3.3 time = 710
* CHECK dout0_12 vdout0_12ck70 = 0 time = 710
* CHECK dout0_13 vdout0_13ck70 = 0 time = 710
* CHECK dout0_14 vdout0_14ck70 = 0 time = 710
* CHECK dout0_15 vdout0_15ck70 = 3.3 time = 710
* CHECK dout0_16 vdout0_16ck70 = 0 time = 710
* CHECK dout0_17 vdout0_17ck70 = 3.3 time = 710
* CHECK dout0_18 vdout0_18ck70 = 3.3 time = 710
* CHECK dout0_19 vdout0_19ck70 = 3.3 time = 710
* CHECK dout0_20 vdout0_20ck70 = 0 time = 710
* CHECK dout0_21 vdout0_21ck70 = 3.3 time = 710
* CHECK dout0_22 vdout0_22ck70 = 3.3 time = 710
* CHECK dout0_23 vdout0_23ck70 = 3.3 time = 710
* CHECK dout0_24 vdout0_24ck70 = 3.3 time = 710
* CHECK dout0_25 vdout0_25ck70 = 0 time = 710
* CHECK dout0_26 vdout0_26ck70 = 3.3 time = 710
* CHECK dout0_27 vdout0_27ck70 = 0 time = 710
* CHECK dout0_28 vdout0_28ck70 = 3.3 time = 710
* CHECK dout0_29 vdout0_29ck70 = 3.3 time = 710
* CHECK dout0_30 vdout0_30ck70 = 3.3 time = 710
* CHECK dout0_31 vdout0_31ck70 = 0 time = 710
* CHECK dout0_0 vdout0_0ck72 = 3.3 time = 730
* CHECK dout0_1 vdout0_1ck72 = 3.3 time = 730
* CHECK dout0_2 vdout0_2ck72 = 0 time = 730
* CHECK dout0_3 vdout0_3ck72 = 3.3 time = 730
* CHECK dout0_4 vdout0_4ck72 = 3.3 time = 730
* CHECK dout0_5 vdout0_5ck72 = 3.3 time = 730
* CHECK dout0_6 vdout0_6ck72 = 0 time = 730
* CHECK dout0_7 vdout0_7ck72 = 3.3 time = 730
* CHECK dout0_8 vdout0_8ck72 = 3.3 time = 730
* CHECK dout0_9 vdout0_9ck72 = 3.3 time = 730
* CHECK dout0_10 vdout0_10ck72 = 0 time = 730
* CHECK dout0_11 vdout0_11ck72 = 0 time = 730
* CHECK dout0_12 vdout0_12ck72 = 0 time = 730
* CHECK dout0_13 vdout0_13ck72 = 0 time = 730
* CHECK dout0_14 vdout0_14ck72 = 3.3 time = 730
* CHECK dout0_15 vdout0_15ck72 = 0 time = 730
* CHECK dout0_16 vdout0_16ck72 = 3.3 time = 730
* CHECK dout0_17 vdout0_17ck72 = 0 time = 730
* CHECK dout0_18 vdout0_18ck72 = 3.3 time = 730
* CHECK dout0_19 vdout0_19ck72 = 3.3 time = 730
* CHECK dout0_20 vdout0_20ck72 = 3.3 time = 730
* CHECK dout0_21 vdout0_21ck72 = 3.3 time = 730
* CHECK dout0_22 vdout0_22ck72 = 3.3 time = 730
* CHECK dout0_23 vdout0_23ck72 = 3.3 time = 730
* CHECK dout0_24 vdout0_24ck72 = 0 time = 730
* CHECK dout0_25 vdout0_25ck72 = 3.3 time = 730
* CHECK dout0_26 vdout0_26ck72 = 3.3 time = 730
* CHECK dout0_27 vdout0_27ck72 = 3.3 time = 730
* CHECK dout0_28 vdout0_28ck72 = 3.3 time = 730
* CHECK dout0_29 vdout0_29ck72 = 0 time = 730
* CHECK dout0_30 vdout0_30ck72 = 0 time = 730
* CHECK dout0_31 vdout0_31ck72 = 3.3 time = 730
* CHECK dout0_0 vdout0_0ck73 = 0 time = 740
* CHECK dout0_1 vdout0_1ck73 = 3.3 time = 740
* CHECK dout0_2 vdout0_2ck73 = 3.3 time = 740
* CHECK dout0_3 vdout0_3ck73 = 0 time = 740
* CHECK dout0_4 vdout0_4ck73 = 0 time = 740
* CHECK dout0_5 vdout0_5ck73 = 0 time = 740
* CHECK dout0_6 vdout0_6ck73 = 3.3 time = 740
* CHECK dout0_7 vdout0_7ck73 = 3.3 time = 740
* CHECK dout0_8 vdout0_8ck73 = 0 time = 740
* CHECK dout0_9 vdout0_9ck73 = 3.3 time = 740
* CHECK dout0_10 vdout0_10ck73 = 3.3 time = 740
* CHECK dout0_11 vdout0_11ck73 = 3.3 time = 740
* CHECK dout0_12 vdout0_12ck73 = 0 time = 740
* CHECK dout0_13 vdout0_13ck73 = 0 time = 740
* CHECK dout0_14 vdout0_14ck73 = 3.3 time = 740
* CHECK dout0_15 vdout0_15ck73 = 0 time = 740
* CHECK dout0_16 vdout0_16ck73 = 0 time = 740
* CHECK dout0_17 vdout0_17ck73 = 0 time = 740
* CHECK dout0_18 vdout0_18ck73 = 3.3 time = 740
* CHECK dout0_19 vdout0_19ck73 = 0 time = 740
* CHECK dout0_20 vdout0_20ck73 = 0 time = 740
* CHECK dout0_21 vdout0_21ck73 = 0 time = 740
* CHECK dout0_22 vdout0_22ck73 = 0 time = 740
* CHECK dout0_23 vdout0_23ck73 = 0 time = 740
* CHECK dout0_24 vdout0_24ck73 = 0 time = 740
* CHECK dout0_25 vdout0_25ck73 = 0 time = 740
* CHECK dout0_26 vdout0_26ck73 = 3.3 time = 740
* CHECK dout0_27 vdout0_27ck73 = 3.3 time = 740
* CHECK dout0_28 vdout0_28ck73 = 0 time = 740
* CHECK dout0_29 vdout0_29ck73 = 3.3 time = 740
* CHECK dout0_30 vdout0_30ck73 = 3.3 time = 740
* CHECK dout0_31 vdout0_31ck73 = 0 time = 740
* CHECK dout1_0 vdout1_0ck73 = 0 time = 740
* CHECK dout1_1 vdout1_1ck73 = 3.3 time = 740
* CHECK dout1_2 vdout1_2ck73 = 3.3 time = 740
* CHECK dout1_3 vdout1_3ck73 = 0 time = 740
* CHECK dout1_4 vdout1_4ck73 = 0 time = 740
* CHECK dout1_5 vdout1_5ck73 = 0 time = 740
* CHECK dout1_6 vdout1_6ck73 = 3.3 time = 740
* CHECK dout1_7 vdout1_7ck73 = 3.3 time = 740
* CHECK dout1_8 vdout1_8ck73 = 0 time = 740
* CHECK dout1_9 vdout1_9ck73 = 3.3 time = 740
* CHECK dout1_10 vdout1_10ck73 = 3.3 time = 740
* CHECK dout1_11 vdout1_11ck73 = 3.3 time = 740
* CHECK dout1_12 vdout1_12ck73 = 0 time = 740
* CHECK dout1_13 vdout1_13ck73 = 0 time = 740
* CHECK dout1_14 vdout1_14ck73 = 3.3 time = 740
* CHECK dout1_15 vdout1_15ck73 = 0 time = 740
* CHECK dout1_16 vdout1_16ck73 = 0 time = 740
* CHECK dout1_17 vdout1_17ck73 = 0 time = 740
* CHECK dout1_18 vdout1_18ck73 = 3.3 time = 740
* CHECK dout1_19 vdout1_19ck73 = 0 time = 740
* CHECK dout1_20 vdout1_20ck73 = 0 time = 740
* CHECK dout1_21 vdout1_21ck73 = 0 time = 740
* CHECK dout1_22 vdout1_22ck73 = 0 time = 740
* CHECK dout1_23 vdout1_23ck73 = 0 time = 740
* CHECK dout1_24 vdout1_24ck73 = 0 time = 740
* CHECK dout1_25 vdout1_25ck73 = 0 time = 740
* CHECK dout1_26 vdout1_26ck73 = 3.3 time = 740
* CHECK dout1_27 vdout1_27ck73 = 3.3 time = 740
* CHECK dout1_28 vdout1_28ck73 = 0 time = 740
* CHECK dout1_29 vdout1_29ck73 = 3.3 time = 740
* CHECK dout1_30 vdout1_30ck73 = 3.3 time = 740
* CHECK dout1_31 vdout1_31ck73 = 0 time = 740
* CHECK dout1_0 vdout1_0ck74 = 0 time = 750
* CHECK dout1_1 vdout1_1ck74 = 3.3 time = 750
* CHECK dout1_2 vdout1_2ck74 = 0 time = 750
* CHECK dout1_3 vdout1_3ck74 = 3.3 time = 750
* CHECK dout1_4 vdout1_4ck74 = 3.3 time = 750
* CHECK dout1_5 vdout1_5ck74 = 0 time = 750
* CHECK dout1_6 vdout1_6ck74 = 0 time = 750
* CHECK dout1_7 vdout1_7ck74 = 0 time = 750
* CHECK dout1_8 vdout1_8ck74 = 0 time = 750
* CHECK dout1_9 vdout1_9ck74 = 0 time = 750
* CHECK dout1_10 vdout1_10ck74 = 0 time = 750
* CHECK dout1_11 vdout1_11ck74 = 0 time = 750
* CHECK dout1_12 vdout1_12ck74 = 3.3 time = 750
* CHECK dout1_13 vdout1_13ck74 = 0 time = 750
* CHECK dout1_14 vdout1_14ck74 = 3.3 time = 750
* CHECK dout1_15 vdout1_15ck74 = 3.3 time = 750
* CHECK dout1_16 vdout1_16ck74 = 3.3 time = 750
* CHECK dout1_17 vdout1_17ck74 = 0 time = 750
* CHECK dout1_18 vdout1_18ck74 = 3.3 time = 750
* CHECK dout1_19 vdout1_19ck74 = 3.3 time = 750
* CHECK dout1_20 vdout1_20ck74 = 3.3 time = 750
* CHECK dout1_21 vdout1_21ck74 = 3.3 time = 750
* CHECK dout1_22 vdout1_22ck74 = 3.3 time = 750
* CHECK dout1_23 vdout1_23ck74 = 3.3 time = 750
* CHECK dout1_24 vdout1_24ck74 = 3.3 time = 750
* CHECK dout1_25 vdout1_25ck74 = 0 time = 750
* CHECK dout1_26 vdout1_26ck74 = 3.3 time = 750
* CHECK dout1_27 vdout1_27ck74 = 0 time = 750
* CHECK dout1_28 vdout1_28ck74 = 0 time = 750
* CHECK dout1_29 vdout1_29ck74 = 0 time = 750
* CHECK dout1_30 vdout1_30ck74 = 0 time = 750
* CHECK dout1_31 vdout1_31ck74 = 0 time = 750
* CHECK dout0_0 vdout0_0ck75 = 0 time = 760
* CHECK dout0_1 vdout0_1ck75 = 3.3 time = 760
* CHECK dout0_2 vdout0_2ck75 = 0 time = 760
* CHECK dout0_3 vdout0_3ck75 = 3.3 time = 760
* CHECK dout0_4 vdout0_4ck75 = 3.3 time = 760
* CHECK dout0_5 vdout0_5ck75 = 0 time = 760
* CHECK dout0_6 vdout0_6ck75 = 0 time = 760
* CHECK dout0_7 vdout0_7ck75 = 0 time = 760
* CHECK dout0_8 vdout0_8ck75 = 0 time = 760
* CHECK dout0_9 vdout0_9ck75 = 0 time = 760
* CHECK dout0_10 vdout0_10ck75 = 0 time = 760
* CHECK dout0_11 vdout0_11ck75 = 0 time = 760
* CHECK dout0_12 vdout0_12ck75 = 3.3 time = 760
* CHECK dout0_13 vdout0_13ck75 = 0 time = 760
* CHECK dout0_14 vdout0_14ck75 = 3.3 time = 760
* CHECK dout0_15 vdout0_15ck75 = 3.3 time = 760
* CHECK dout0_16 vdout0_16ck75 = 3.3 time = 760
* CHECK dout0_17 vdout0_17ck75 = 0 time = 760
* CHECK dout0_18 vdout0_18ck75 = 3.3 time = 760
* CHECK dout0_19 vdout0_19ck75 = 3.3 time = 760
* CHECK dout0_20 vdout0_20ck75 = 3.3 time = 760
* CHECK dout0_21 vdout0_21ck75 = 3.3 time = 760
* CHECK dout0_22 vdout0_22ck75 = 3.3 time = 760
* CHECK dout0_23 vdout0_23ck75 = 3.3 time = 760
* CHECK dout0_24 vdout0_24ck75 = 3.3 time = 760
* CHECK dout0_25 vdout0_25ck75 = 0 time = 760
* CHECK dout0_26 vdout0_26ck75 = 3.3 time = 760
* CHECK dout0_27 vdout0_27ck75 = 0 time = 760
* CHECK dout0_28 vdout0_28ck75 = 0 time = 760
* CHECK dout0_29 vdout0_29ck75 = 0 time = 760
* CHECK dout0_30 vdout0_30ck75 = 0 time = 760
* CHECK dout0_31 vdout0_31ck75 = 0 time = 760
* CHECK dout1_0 vdout1_0ck75 = 0 time = 760
* CHECK dout1_1 vdout1_1ck75 = 3.3 time = 760
* CHECK dout1_2 vdout1_2ck75 = 0 time = 760
* CHECK dout1_3 vdout1_3ck75 = 3.3 time = 760
* CHECK dout1_4 vdout1_4ck75 = 3.3 time = 760
* CHECK dout1_5 vdout1_5ck75 = 0 time = 760
* CHECK dout1_6 vdout1_6ck75 = 0 time = 760
* CHECK dout1_7 vdout1_7ck75 = 0 time = 760
* CHECK dout1_8 vdout1_8ck75 = 0 time = 760
* CHECK dout1_9 vdout1_9ck75 = 0 time = 760
* CHECK dout1_10 vdout1_10ck75 = 0 time = 760
* CHECK dout1_11 vdout1_11ck75 = 0 time = 760
* CHECK dout1_12 vdout1_12ck75 = 3.3 time = 760
* CHECK dout1_13 vdout1_13ck75 = 0 time = 760
* CHECK dout1_14 vdout1_14ck75 = 3.3 time = 760
* CHECK dout1_15 vdout1_15ck75 = 3.3 time = 760
* CHECK dout1_16 vdout1_16ck75 = 3.3 time = 760
* CHECK dout1_17 vdout1_17ck75 = 0 time = 760
* CHECK dout1_18 vdout1_18ck75 = 3.3 time = 760
* CHECK dout1_19 vdout1_19ck75 = 3.3 time = 760
* CHECK dout1_20 vdout1_20ck75 = 3.3 time = 760
* CHECK dout1_21 vdout1_21ck75 = 3.3 time = 760
* CHECK dout1_22 vdout1_22ck75 = 3.3 time = 760
* CHECK dout1_23 vdout1_23ck75 = 3.3 time = 760
* CHECK dout1_24 vdout1_24ck75 = 3.3 time = 760
* CHECK dout1_25 vdout1_25ck75 = 0 time = 760
* CHECK dout1_26 vdout1_26ck75 = 3.3 time = 760
* CHECK dout1_27 vdout1_27ck75 = 0 time = 760
* CHECK dout1_28 vdout1_28ck75 = 0 time = 760
* CHECK dout1_29 vdout1_29ck75 = 0 time = 760
* CHECK dout1_30 vdout1_30ck75 = 0 time = 760
* CHECK dout1_31 vdout1_31ck75 = 0 time = 760
* CHECK dout0_0 vdout0_0ck76 = 0 time = 770
* CHECK dout0_1 vdout0_1ck76 = 3.3 time = 770
* CHECK dout0_2 vdout0_2ck76 = 3.3 time = 770
* CHECK dout0_3 vdout0_3ck76 = 0 time = 770
* CHECK dout0_4 vdout0_4ck76 = 0 time = 770
* CHECK dout0_5 vdout0_5ck76 = 0 time = 770
* CHECK dout0_6 vdout0_6ck76 = 3.3 time = 770
* CHECK dout0_7 vdout0_7ck76 = 3.3 time = 770
* CHECK dout0_8 vdout0_8ck76 = 0 time = 770
* CHECK dout0_9 vdout0_9ck76 = 3.3 time = 770
* CHECK dout0_10 vdout0_10ck76 = 3.3 time = 770
* CHECK dout0_11 vdout0_11ck76 = 3.3 time = 770
* CHECK dout0_12 vdout0_12ck76 = 0 time = 770
* CHECK dout0_13 vdout0_13ck76 = 0 time = 770
* CHECK dout0_14 vdout0_14ck76 = 3.3 time = 770
* CHECK dout0_15 vdout0_15ck76 = 0 time = 770
* CHECK dout0_16 vdout0_16ck76 = 0 time = 770
* CHECK dout0_17 vdout0_17ck76 = 0 time = 770
* CHECK dout0_18 vdout0_18ck76 = 3.3 time = 770
* CHECK dout0_19 vdout0_19ck76 = 0 time = 770
* CHECK dout0_20 vdout0_20ck76 = 0 time = 770
* CHECK dout0_21 vdout0_21ck76 = 0 time = 770
* CHECK dout0_22 vdout0_22ck76 = 0 time = 770
* CHECK dout0_23 vdout0_23ck76 = 0 time = 770
* CHECK dout0_24 vdout0_24ck76 = 0 time = 770
* CHECK dout0_25 vdout0_25ck76 = 0 time = 770
* CHECK dout0_26 vdout0_26ck76 = 3.3 time = 770
* CHECK dout0_27 vdout0_27ck76 = 3.3 time = 770
* CHECK dout0_28 vdout0_28ck76 = 0 time = 770
* CHECK dout0_29 vdout0_29ck76 = 3.3 time = 770
* CHECK dout0_30 vdout0_30ck76 = 3.3 time = 770
* CHECK dout0_31 vdout0_31ck76 = 0 time = 770
* CHECK dout1_0 vdout1_0ck76 = 0 time = 770
* CHECK dout1_1 vdout1_1ck76 = 3.3 time = 770
* CHECK dout1_2 vdout1_2ck76 = 0 time = 770
* CHECK dout1_3 vdout1_3ck76 = 3.3 time = 770
* CHECK dout1_4 vdout1_4ck76 = 3.3 time = 770
* CHECK dout1_5 vdout1_5ck76 = 0 time = 770
* CHECK dout1_6 vdout1_6ck76 = 0 time = 770
* CHECK dout1_7 vdout1_7ck76 = 0 time = 770
* CHECK dout1_8 vdout1_8ck76 = 0 time = 770
* CHECK dout1_9 vdout1_9ck76 = 0 time = 770
* CHECK dout1_10 vdout1_10ck76 = 0 time = 770
* CHECK dout1_11 vdout1_11ck76 = 0 time = 770
* CHECK dout1_12 vdout1_12ck76 = 3.3 time = 770
* CHECK dout1_13 vdout1_13ck76 = 0 time = 770
* CHECK dout1_14 vdout1_14ck76 = 3.3 time = 770
* CHECK dout1_15 vdout1_15ck76 = 3.3 time = 770
* CHECK dout1_16 vdout1_16ck76 = 3.3 time = 770
* CHECK dout1_17 vdout1_17ck76 = 0 time = 770
* CHECK dout1_18 vdout1_18ck76 = 3.3 time = 770
* CHECK dout1_19 vdout1_19ck76 = 3.3 time = 770
* CHECK dout1_20 vdout1_20ck76 = 3.3 time = 770
* CHECK dout1_21 vdout1_21ck76 = 3.3 time = 770
* CHECK dout1_22 vdout1_22ck76 = 3.3 time = 770
* CHECK dout1_23 vdout1_23ck76 = 3.3 time = 770
* CHECK dout1_24 vdout1_24ck76 = 3.3 time = 770
* CHECK dout1_25 vdout1_25ck76 = 0 time = 770
* CHECK dout1_26 vdout1_26ck76 = 3.3 time = 770
* CHECK dout1_27 vdout1_27ck76 = 0 time = 770
* CHECK dout1_28 vdout1_28ck76 = 0 time = 770
* CHECK dout1_29 vdout1_29ck76 = 0 time = 770
* CHECK dout1_30 vdout1_30ck76 = 0 time = 770
* CHECK dout1_31 vdout1_31ck76 = 0 time = 770
* CHECK dout0_0 vdout0_0ck77 = 0 time = 780
* CHECK dout0_1 vdout0_1ck77 = 3.3 time = 780
* CHECK dout0_2 vdout0_2ck77 = 3.3 time = 780
* CHECK dout0_3 vdout0_3ck77 = 0 time = 780
* CHECK dout0_4 vdout0_4ck77 = 0 time = 780
* CHECK dout0_5 vdout0_5ck77 = 0 time = 780
* CHECK dout0_6 vdout0_6ck77 = 3.3 time = 780
* CHECK dout0_7 vdout0_7ck77 = 3.3 time = 780
* CHECK dout0_8 vdout0_8ck77 = 0 time = 780
* CHECK dout0_9 vdout0_9ck77 = 3.3 time = 780
* CHECK dout0_10 vdout0_10ck77 = 3.3 time = 780
* CHECK dout0_11 vdout0_11ck77 = 3.3 time = 780
* CHECK dout0_12 vdout0_12ck77 = 0 time = 780
* CHECK dout0_13 vdout0_13ck77 = 0 time = 780
* CHECK dout0_14 vdout0_14ck77 = 3.3 time = 780
* CHECK dout0_15 vdout0_15ck77 = 0 time = 780
* CHECK dout0_16 vdout0_16ck77 = 0 time = 780
* CHECK dout0_17 vdout0_17ck77 = 0 time = 780
* CHECK dout0_18 vdout0_18ck77 = 3.3 time = 780
* CHECK dout0_19 vdout0_19ck77 = 0 time = 780
* CHECK dout0_20 vdout0_20ck77 = 0 time = 780
* CHECK dout0_21 vdout0_21ck77 = 0 time = 780
* CHECK dout0_22 vdout0_22ck77 = 0 time = 780
* CHECK dout0_23 vdout0_23ck77 = 0 time = 780
* CHECK dout0_24 vdout0_24ck77 = 0 time = 780
* CHECK dout0_25 vdout0_25ck77 = 0 time = 780
* CHECK dout0_26 vdout0_26ck77 = 3.3 time = 780
* CHECK dout0_27 vdout0_27ck77 = 3.3 time = 780
* CHECK dout0_28 vdout0_28ck77 = 0 time = 780
* CHECK dout0_29 vdout0_29ck77 = 3.3 time = 780
* CHECK dout0_30 vdout0_30ck77 = 3.3 time = 780
* CHECK dout0_31 vdout0_31ck77 = 0 time = 780
* CHECK dout1_0 vdout1_0ck77 = 0 time = 780
* CHECK dout1_1 vdout1_1ck77 = 3.3 time = 780
* CHECK dout1_2 vdout1_2ck77 = 3.3 time = 780
* CHECK dout1_3 vdout1_3ck77 = 0 time = 780
* CHECK dout1_4 vdout1_4ck77 = 0 time = 780
* CHECK dout1_5 vdout1_5ck77 = 0 time = 780
* CHECK dout1_6 vdout1_6ck77 = 3.3 time = 780
* CHECK dout1_7 vdout1_7ck77 = 3.3 time = 780
* CHECK dout1_8 vdout1_8ck77 = 0 time = 780
* CHECK dout1_9 vdout1_9ck77 = 3.3 time = 780
* CHECK dout1_10 vdout1_10ck77 = 3.3 time = 780
* CHECK dout1_11 vdout1_11ck77 = 3.3 time = 780
* CHECK dout1_12 vdout1_12ck77 = 0 time = 780
* CHECK dout1_13 vdout1_13ck77 = 0 time = 780
* CHECK dout1_14 vdout1_14ck77 = 3.3 time = 780
* CHECK dout1_15 vdout1_15ck77 = 0 time = 780
* CHECK dout1_16 vdout1_16ck77 = 0 time = 780
* CHECK dout1_17 vdout1_17ck77 = 0 time = 780
* CHECK dout1_18 vdout1_18ck77 = 3.3 time = 780
* CHECK dout1_19 vdout1_19ck77 = 0 time = 780
* CHECK dout1_20 vdout1_20ck77 = 0 time = 780
* CHECK dout1_21 vdout1_21ck77 = 0 time = 780
* CHECK dout1_22 vdout1_22ck77 = 0 time = 780
* CHECK dout1_23 vdout1_23ck77 = 0 time = 780
* CHECK dout1_24 vdout1_24ck77 = 0 time = 780
* CHECK dout1_25 vdout1_25ck77 = 0 time = 780
* CHECK dout1_26 vdout1_26ck77 = 3.3 time = 780
* CHECK dout1_27 vdout1_27ck77 = 3.3 time = 780
* CHECK dout1_28 vdout1_28ck77 = 0 time = 780
* CHECK dout1_29 vdout1_29ck77 = 3.3 time = 780
* CHECK dout1_30 vdout1_30ck77 = 3.3 time = 780
* CHECK dout1_31 vdout1_31ck77 = 0 time = 780
* CHECK dout1_0 vdout1_0ck79 = 3.3 time = 800
* CHECK dout1_1 vdout1_1ck79 = 3.3 time = 800
* CHECK dout1_2 vdout1_2ck79 = 3.3 time = 800
* CHECK dout1_3 vdout1_3ck79 = 3.3 time = 800
* CHECK dout1_4 vdout1_4ck79 = 3.3 time = 800
* CHECK dout1_5 vdout1_5ck79 = 3.3 time = 800
* CHECK dout1_6 vdout1_6ck79 = 3.3 time = 800
* CHECK dout1_7 vdout1_7ck79 = 3.3 time = 800
* CHECK dout1_8 vdout1_8ck79 = 0 time = 800
* CHECK dout1_9 vdout1_9ck79 = 0 time = 800
* CHECK dout1_10 vdout1_10ck79 = 0 time = 800
* CHECK dout1_11 vdout1_11ck79 = 3.3 time = 800
* CHECK dout1_12 vdout1_12ck79 = 3.3 time = 800
* CHECK dout1_13 vdout1_13ck79 = 3.3 time = 800
* CHECK dout1_14 vdout1_14ck79 = 0 time = 800
* CHECK dout1_15 vdout1_15ck79 = 0 time = 800
* CHECK dout1_16 vdout1_16ck79 = 0 time = 800
* CHECK dout1_17 vdout1_17ck79 = 0 time = 800
* CHECK dout1_18 vdout1_18ck79 = 0 time = 800
* CHECK dout1_19 vdout1_19ck79 = 0 time = 800
* CHECK dout1_20 vdout1_20ck79 = 0 time = 800
* CHECK dout1_21 vdout1_21ck79 = 3.3 time = 800
* CHECK dout1_22 vdout1_22ck79 = 3.3 time = 800
* CHECK dout1_23 vdout1_23ck79 = 0 time = 800
* CHECK dout1_24 vdout1_24ck79 = 0 time = 800
* CHECK dout1_25 vdout1_25ck79 = 3.3 time = 800
* CHECK dout1_26 vdout1_26ck79 = 3.3 time = 800
* CHECK dout1_27 vdout1_27ck79 = 0 time = 800
* CHECK dout1_28 vdout1_28ck79 = 3.3 time = 800
* CHECK dout1_29 vdout1_29ck79 = 0 time = 800
* CHECK dout1_30 vdout1_30ck79 = 0 time = 800
* CHECK dout1_31 vdout1_31ck79 = 0 time = 800
* CHECK dout1_0 vdout1_0ck80 = 3.3 time = 810
* CHECK dout1_1 vdout1_1ck80 = 3.3 time = 810
* CHECK dout1_2 vdout1_2ck80 = 3.3 time = 810
* CHECK dout1_3 vdout1_3ck80 = 3.3 time = 810
* CHECK dout1_4 vdout1_4ck80 = 3.3 time = 810
* CHECK dout1_5 vdout1_5ck80 = 3.3 time = 810
* CHECK dout1_6 vdout1_6ck80 = 3.3 time = 810
* CHECK dout1_7 vdout1_7ck80 = 3.3 time = 810
* CHECK dout1_8 vdout1_8ck80 = 0 time = 810
* CHECK dout1_9 vdout1_9ck80 = 0 time = 810
* CHECK dout1_10 vdout1_10ck80 = 0 time = 810
* CHECK dout1_11 vdout1_11ck80 = 3.3 time = 810
* CHECK dout1_12 vdout1_12ck80 = 3.3 time = 810
* CHECK dout1_13 vdout1_13ck80 = 3.3 time = 810
* CHECK dout1_14 vdout1_14ck80 = 0 time = 810
* CHECK dout1_15 vdout1_15ck80 = 0 time = 810
* CHECK dout1_16 vdout1_16ck80 = 0 time = 810
* CHECK dout1_17 vdout1_17ck80 = 0 time = 810
* CHECK dout1_18 vdout1_18ck80 = 0 time = 810
* CHECK dout1_19 vdout1_19ck80 = 0 time = 810
* CHECK dout1_20 vdout1_20ck80 = 0 time = 810
* CHECK dout1_21 vdout1_21ck80 = 3.3 time = 810
* CHECK dout1_22 vdout1_22ck80 = 3.3 time = 810
* CHECK dout1_23 vdout1_23ck80 = 0 time = 810
* CHECK dout1_24 vdout1_24ck80 = 0 time = 810
* CHECK dout1_25 vdout1_25ck80 = 3.3 time = 810
* CHECK dout1_26 vdout1_26ck80 = 3.3 time = 810
* CHECK dout1_27 vdout1_27ck80 = 0 time = 810
* CHECK dout1_28 vdout1_28ck80 = 3.3 time = 810
* CHECK dout1_29 vdout1_29ck80 = 0 time = 810
* CHECK dout1_30 vdout1_30ck80 = 0 time = 810
* CHECK dout1_31 vdout1_31ck80 = 0 time = 810
* CHECK dout1_0 vdout1_0ck81 = 3.3 time = 820
* CHECK dout1_1 vdout1_1ck81 = 3.3 time = 820
* CHECK dout1_2 vdout1_2ck81 = 3.3 time = 820
* CHECK dout1_3 vdout1_3ck81 = 3.3 time = 820
* CHECK dout1_4 vdout1_4ck81 = 3.3 time = 820
* CHECK dout1_5 vdout1_5ck81 = 3.3 time = 820
* CHECK dout1_6 vdout1_6ck81 = 3.3 time = 820
* CHECK dout1_7 vdout1_7ck81 = 3.3 time = 820
* CHECK dout1_8 vdout1_8ck81 = 0 time = 820
* CHECK dout1_9 vdout1_9ck81 = 0 time = 820
* CHECK dout1_10 vdout1_10ck81 = 0 time = 820
* CHECK dout1_11 vdout1_11ck81 = 3.3 time = 820
* CHECK dout1_12 vdout1_12ck81 = 3.3 time = 820
* CHECK dout1_13 vdout1_13ck81 = 3.3 time = 820
* CHECK dout1_14 vdout1_14ck81 = 0 time = 820
* CHECK dout1_15 vdout1_15ck81 = 0 time = 820
* CHECK dout1_16 vdout1_16ck81 = 0 time = 820
* CHECK dout1_17 vdout1_17ck81 = 0 time = 820
* CHECK dout1_18 vdout1_18ck81 = 0 time = 820
* CHECK dout1_19 vdout1_19ck81 = 0 time = 820
* CHECK dout1_20 vdout1_20ck81 = 0 time = 820
* CHECK dout1_21 vdout1_21ck81 = 3.3 time = 820
* CHECK dout1_22 vdout1_22ck81 = 3.3 time = 820
* CHECK dout1_23 vdout1_23ck81 = 0 time = 820
* CHECK dout1_24 vdout1_24ck81 = 0 time = 820
* CHECK dout1_25 vdout1_25ck81 = 3.3 time = 820
* CHECK dout1_26 vdout1_26ck81 = 3.3 time = 820
* CHECK dout1_27 vdout1_27ck81 = 0 time = 820
* CHECK dout1_28 vdout1_28ck81 = 3.3 time = 820
* CHECK dout1_29 vdout1_29ck81 = 0 time = 820
* CHECK dout1_30 vdout1_30ck81 = 0 time = 820
* CHECK dout1_31 vdout1_31ck81 = 0 time = 820
* CHECK dout0_0 vdout0_0ck82 = 3.3 time = 830
* CHECK dout0_1 vdout0_1ck82 = 0 time = 830
* CHECK dout0_2 vdout0_2ck82 = 0 time = 830
* CHECK dout0_3 vdout0_3ck82 = 3.3 time = 830
* CHECK dout0_4 vdout0_4ck82 = 0 time = 830
* CHECK dout0_5 vdout0_5ck82 = 3.3 time = 830
* CHECK dout0_6 vdout0_6ck82 = 0 time = 830
* CHECK dout0_7 vdout0_7ck82 = 3.3 time = 830
* CHECK dout0_8 vdout0_8ck82 = 3.3 time = 830
* CHECK dout0_9 vdout0_9ck82 = 3.3 time = 830
* CHECK dout0_10 vdout0_10ck82 = 3.3 time = 830
* CHECK dout0_11 vdout0_11ck82 = 3.3 time = 830
* CHECK dout0_12 vdout0_12ck82 = 3.3 time = 830
* CHECK dout0_13 vdout0_13ck82 = 3.3 time = 830
* CHECK dout0_14 vdout0_14ck82 = 3.3 time = 830
* CHECK dout0_15 vdout0_15ck82 = 0 time = 830
* CHECK dout0_16 vdout0_16ck82 = 3.3 time = 830
* CHECK dout0_17 vdout0_17ck82 = 3.3 time = 830
* CHECK dout0_18 vdout0_18ck82 = 3.3 time = 830
* CHECK dout0_19 vdout0_19ck82 = 0 time = 830
* CHECK dout0_20 vdout0_20ck82 = 3.3 time = 830
* CHECK dout0_21 vdout0_21ck82 = 0 time = 830
* CHECK dout0_22 vdout0_22ck82 = 0 time = 830
* CHECK dout0_23 vdout0_23ck82 = 3.3 time = 830
* CHECK dout0_24 vdout0_24ck82 = 3.3 time = 830
* CHECK dout0_25 vdout0_25ck82 = 3.3 time = 830
* CHECK dout0_26 vdout0_26ck82 = 3.3 time = 830
* CHECK dout0_27 vdout0_27ck82 = 0 time = 830
* CHECK dout0_28 vdout0_28ck82 = 0 time = 830
* CHECK dout0_29 vdout0_29ck82 = 3.3 time = 830
* CHECK dout0_30 vdout0_30ck82 = 0 time = 830
* CHECK dout0_31 vdout0_31ck82 = 0 time = 830
* CHECK dout1_0 vdout1_0ck82 = 3.3 time = 830
* CHECK dout1_1 vdout1_1ck82 = 0 time = 830
* CHECK dout1_2 vdout1_2ck82 = 0 time = 830
* CHECK dout1_3 vdout1_3ck82 = 3.3 time = 830
* CHECK dout1_4 vdout1_4ck82 = 0 time = 830
* CHECK dout1_5 vdout1_5ck82 = 3.3 time = 830
* CHECK dout1_6 vdout1_6ck82 = 0 time = 830
* CHECK dout1_7 vdout1_7ck82 = 3.3 time = 830
* CHECK dout1_8 vdout1_8ck82 = 3.3 time = 830
* CHECK dout1_9 vdout1_9ck82 = 3.3 time = 830
* CHECK dout1_10 vdout1_10ck82 = 3.3 time = 830
* CHECK dout1_11 vdout1_11ck82 = 3.3 time = 830
* CHECK dout1_12 vdout1_12ck82 = 3.3 time = 830
* CHECK dout1_13 vdout1_13ck82 = 3.3 time = 830
* CHECK dout1_14 vdout1_14ck82 = 3.3 time = 830
* CHECK dout1_15 vdout1_15ck82 = 0 time = 830
* CHECK dout1_16 vdout1_16ck82 = 3.3 time = 830
* CHECK dout1_17 vdout1_17ck82 = 3.3 time = 830
* CHECK dout1_18 vdout1_18ck82 = 3.3 time = 830
* CHECK dout1_19 vdout1_19ck82 = 0 time = 830
* CHECK dout1_20 vdout1_20ck82 = 3.3 time = 830
* CHECK dout1_21 vdout1_21ck82 = 0 time = 830
* CHECK dout1_22 vdout1_22ck82 = 0 time = 830
* CHECK dout1_23 vdout1_23ck82 = 3.3 time = 830
* CHECK dout1_24 vdout1_24ck82 = 3.3 time = 830
* CHECK dout1_25 vdout1_25ck82 = 3.3 time = 830
* CHECK dout1_26 vdout1_26ck82 = 3.3 time = 830
* CHECK dout1_27 vdout1_27ck82 = 0 time = 830
* CHECK dout1_28 vdout1_28ck82 = 0 time = 830
* CHECK dout1_29 vdout1_29ck82 = 3.3 time = 830
* CHECK dout1_30 vdout1_30ck82 = 0 time = 830
* CHECK dout1_31 vdout1_31ck82 = 0 time = 830
* CHECK dout1_0 vdout1_0ck83 = 3.3 time = 840
* CHECK dout1_1 vdout1_1ck83 = 0 time = 840
* CHECK dout1_2 vdout1_2ck83 = 0 time = 840
* CHECK dout1_3 vdout1_3ck83 = 3.3 time = 840
* CHECK dout1_4 vdout1_4ck83 = 0 time = 840
* CHECK dout1_5 vdout1_5ck83 = 3.3 time = 840
* CHECK dout1_6 vdout1_6ck83 = 0 time = 840
* CHECK dout1_7 vdout1_7ck83 = 3.3 time = 840
* CHECK dout1_8 vdout1_8ck83 = 3.3 time = 840
* CHECK dout1_9 vdout1_9ck83 = 3.3 time = 840
* CHECK dout1_10 vdout1_10ck83 = 3.3 time = 840
* CHECK dout1_11 vdout1_11ck83 = 3.3 time = 840
* CHECK dout1_12 vdout1_12ck83 = 3.3 time = 840
* CHECK dout1_13 vdout1_13ck83 = 3.3 time = 840
* CHECK dout1_14 vdout1_14ck83 = 3.3 time = 840
* CHECK dout1_15 vdout1_15ck83 = 0 time = 840
* CHECK dout1_16 vdout1_16ck83 = 3.3 time = 840
* CHECK dout1_17 vdout1_17ck83 = 3.3 time = 840
* CHECK dout1_18 vdout1_18ck83 = 3.3 time = 840
* CHECK dout1_19 vdout1_19ck83 = 0 time = 840
* CHECK dout1_20 vdout1_20ck83 = 3.3 time = 840
* CHECK dout1_21 vdout1_21ck83 = 0 time = 840
* CHECK dout1_22 vdout1_22ck83 = 0 time = 840
* CHECK dout1_23 vdout1_23ck83 = 3.3 time = 840
* CHECK dout1_24 vdout1_24ck83 = 3.3 time = 840
* CHECK dout1_25 vdout1_25ck83 = 3.3 time = 840
* CHECK dout1_26 vdout1_26ck83 = 3.3 time = 840
* CHECK dout1_27 vdout1_27ck83 = 0 time = 840
* CHECK dout1_28 vdout1_28ck83 = 0 time = 840
* CHECK dout1_29 vdout1_29ck83 = 3.3 time = 840
* CHECK dout1_30 vdout1_30ck83 = 0 time = 840
* CHECK dout1_31 vdout1_31ck83 = 0 time = 840
* CHECK dout0_0 vdout0_0ck84 = 3.3 time = 850
* CHECK dout0_1 vdout0_1ck84 = 3.3 time = 850
* CHECK dout0_2 vdout0_2ck84 = 3.3 time = 850
* CHECK dout0_3 vdout0_3ck84 = 3.3 time = 850
* CHECK dout0_4 vdout0_4ck84 = 3.3 time = 850
* CHECK dout0_5 vdout0_5ck84 = 3.3 time = 850
* CHECK dout0_6 vdout0_6ck84 = 3.3 time = 850
* CHECK dout0_7 vdout0_7ck84 = 3.3 time = 850
* CHECK dout0_8 vdout0_8ck84 = 0 time = 850
* CHECK dout0_9 vdout0_9ck84 = 0 time = 850
* CHECK dout0_10 vdout0_10ck84 = 0 time = 850
* CHECK dout0_11 vdout0_11ck84 = 3.3 time = 850
* CHECK dout0_12 vdout0_12ck84 = 3.3 time = 850
* CHECK dout0_13 vdout0_13ck84 = 3.3 time = 850
* CHECK dout0_14 vdout0_14ck84 = 0 time = 850
* CHECK dout0_15 vdout0_15ck84 = 0 time = 850
* CHECK dout0_16 vdout0_16ck84 = 0 time = 850
* CHECK dout0_17 vdout0_17ck84 = 0 time = 850
* CHECK dout0_18 vdout0_18ck84 = 0 time = 850
* CHECK dout0_19 vdout0_19ck84 = 0 time = 850
* CHECK dout0_20 vdout0_20ck84 = 0 time = 850
* CHECK dout0_21 vdout0_21ck84 = 3.3 time = 850
* CHECK dout0_22 vdout0_22ck84 = 3.3 time = 850
* CHECK dout0_23 vdout0_23ck84 = 0 time = 850
* CHECK dout0_24 vdout0_24ck84 = 0 time = 850
* CHECK dout0_25 vdout0_25ck84 = 3.3 time = 850
* CHECK dout0_26 vdout0_26ck84 = 3.3 time = 850
* CHECK dout0_27 vdout0_27ck84 = 0 time = 850
* CHECK dout0_28 vdout0_28ck84 = 3.3 time = 850
* CHECK dout0_29 vdout0_29ck84 = 0 time = 850
* CHECK dout0_30 vdout0_30ck84 = 0 time = 850
* CHECK dout0_31 vdout0_31ck84 = 0 time = 850
* CHECK dout0_0 vdout0_0ck86 = 3.3 time = 870
* CHECK dout0_1 vdout0_1ck86 = 3.3 time = 870
* CHECK dout0_2 vdout0_2ck86 = 3.3 time = 870
* CHECK dout0_3 vdout0_3ck86 = 3.3 time = 870
* CHECK dout0_4 vdout0_4ck86 = 3.3 time = 870
* CHECK dout0_5 vdout0_5ck86 = 3.3 time = 870
* CHECK dout0_6 vdout0_6ck86 = 3.3 time = 870
* CHECK dout0_7 vdout0_7ck86 = 3.3 time = 870
* CHECK dout0_8 vdout0_8ck86 = 0 time = 870
* CHECK dout0_9 vdout0_9ck86 = 0 time = 870
* CHECK dout0_10 vdout0_10ck86 = 0 time = 870
* CHECK dout0_11 vdout0_11ck86 = 3.3 time = 870
* CHECK dout0_12 vdout0_12ck86 = 3.3 time = 870
* CHECK dout0_13 vdout0_13ck86 = 3.3 time = 870
* CHECK dout0_14 vdout0_14ck86 = 0 time = 870
* CHECK dout0_15 vdout0_15ck86 = 0 time = 870
* CHECK dout0_16 vdout0_16ck86 = 0 time = 870
* CHECK dout0_17 vdout0_17ck86 = 0 time = 870
* CHECK dout0_18 vdout0_18ck86 = 0 time = 870
* CHECK dout0_19 vdout0_19ck86 = 0 time = 870
* CHECK dout0_20 vdout0_20ck86 = 0 time = 870
* CHECK dout0_21 vdout0_21ck86 = 3.3 time = 870
* CHECK dout0_22 vdout0_22ck86 = 3.3 time = 870
* CHECK dout0_23 vdout0_23ck86 = 0 time = 870
* CHECK dout0_24 vdout0_24ck86 = 0 time = 870
* CHECK dout0_25 vdout0_25ck86 = 3.3 time = 870
* CHECK dout0_26 vdout0_26ck86 = 3.3 time = 870
* CHECK dout0_27 vdout0_27ck86 = 0 time = 870
* CHECK dout0_28 vdout0_28ck86 = 3.3 time = 870
* CHECK dout0_29 vdout0_29ck86 = 0 time = 870
* CHECK dout0_30 vdout0_30ck86 = 0 time = 870
* CHECK dout0_31 vdout0_31ck86 = 0 time = 870
* CHECK dout0_0 vdout0_0ck87 = 3.3 time = 880
* CHECK dout0_1 vdout0_1ck87 = 0 time = 880
* CHECK dout0_2 vdout0_2ck87 = 0 time = 880
* CHECK dout0_3 vdout0_3ck87 = 3.3 time = 880
* CHECK dout0_4 vdout0_4ck87 = 0 time = 880
* CHECK dout0_5 vdout0_5ck87 = 0 time = 880
* CHECK dout0_6 vdout0_6ck87 = 3.3 time = 880
* CHECK dout0_7 vdout0_7ck87 = 0 time = 880
* CHECK dout0_8 vdout0_8ck87 = 0 time = 880
* CHECK dout0_9 vdout0_9ck87 = 3.3 time = 880
* CHECK dout0_10 vdout0_10ck87 = 3.3 time = 880
* CHECK dout0_11 vdout0_11ck87 = 3.3 time = 880
* CHECK dout0_12 vdout0_12ck87 = 0 time = 880
* CHECK dout0_13 vdout0_13ck87 = 3.3 time = 880
* CHECK dout0_14 vdout0_14ck87 = 0 time = 880
* CHECK dout0_15 vdout0_15ck87 = 0 time = 880
* CHECK dout0_16 vdout0_16ck87 = 3.3 time = 880
* CHECK dout0_17 vdout0_17ck87 = 3.3 time = 880
* CHECK dout0_18 vdout0_18ck87 = 0 time = 880
* CHECK dout0_19 vdout0_19ck87 = 0 time = 880
* CHECK dout0_20 vdout0_20ck87 = 0 time = 880
* CHECK dout0_21 vdout0_21ck87 = 0 time = 880
* CHECK dout0_22 vdout0_22ck87 = 0 time = 880
* CHECK dout0_23 vdout0_23ck87 = 0 time = 880
* CHECK dout0_24 vdout0_24ck87 = 0 time = 880
* CHECK dout0_25 vdout0_25ck87 = 3.3 time = 880
* CHECK dout0_26 vdout0_26ck87 = 0 time = 880
* CHECK dout0_27 vdout0_27ck87 = 0 time = 880
* CHECK dout0_28 vdout0_28ck87 = 0 time = 880
* CHECK dout0_29 vdout0_29ck87 = 3.3 time = 880
* CHECK dout0_30 vdout0_30ck87 = 0 time = 880
* CHECK dout0_31 vdout0_31ck87 = 0 time = 880
* CHECK dout1_0 vdout1_0ck88 = 0 time = 890
* CHECK dout1_1 vdout1_1ck88 = 3.3 time = 890
* CHECK dout1_2 vdout1_2ck88 = 0 time = 890
* CHECK dout1_3 vdout1_3ck88 = 3.3 time = 890
* CHECK dout1_4 vdout1_4ck88 = 0 time = 890
* CHECK dout1_5 vdout1_5ck88 = 3.3 time = 890
* CHECK dout1_6 vdout1_6ck88 = 0 time = 890
* CHECK dout1_7 vdout1_7ck88 = 0 time = 890
* CHECK dout1_8 vdout1_8ck88 = 3.3 time = 890
* CHECK dout1_9 vdout1_9ck88 = 0 time = 890
* CHECK dout1_10 vdout1_10ck88 = 0 time = 890
* CHECK dout1_11 vdout1_11ck88 = 0 time = 890
* CHECK dout1_12 vdout1_12ck88 = 0 time = 890
* CHECK dout1_13 vdout1_13ck88 = 3.3 time = 890
* CHECK dout1_14 vdout1_14ck88 = 0 time = 890
* CHECK dout1_15 vdout1_15ck88 = 0 time = 890
* CHECK dout1_16 vdout1_16ck88 = 3.3 time = 890
* CHECK dout1_17 vdout1_17ck88 = 3.3 time = 890
* CHECK dout1_18 vdout1_18ck88 = 3.3 time = 890
* CHECK dout1_19 vdout1_19ck88 = 0 time = 890
* CHECK dout1_20 vdout1_20ck88 = 3.3 time = 890
* CHECK dout1_21 vdout1_21ck88 = 3.3 time = 890
* CHECK dout1_22 vdout1_22ck88 = 0 time = 890
* CHECK dout1_23 vdout1_23ck88 = 3.3 time = 890
* CHECK dout1_24 vdout1_24ck88 = 0 time = 890
* CHECK dout1_25 vdout1_25ck88 = 0 time = 890
* CHECK dout1_26 vdout1_26ck88 = 3.3 time = 890
* CHECK dout1_27 vdout1_27ck88 = 0 time = 890
* CHECK dout1_28 vdout1_28ck88 = 3.3 time = 890
* CHECK dout1_29 vdout1_29ck88 = 0 time = 890
* CHECK dout1_30 vdout1_30ck88 = 3.3 time = 890
* CHECK dout1_31 vdout1_31ck88 = 3.3 time = 890
* CHECK dout0_0 vdout0_0ck90 = 3.3 time = 910
* CHECK dout0_1 vdout0_1ck90 = 0 time = 910
* CHECK dout0_2 vdout0_2ck90 = 0 time = 910
* CHECK dout0_3 vdout0_3ck90 = 3.3 time = 910
* CHECK dout0_4 vdout0_4ck90 = 0 time = 910
* CHECK dout0_5 vdout0_5ck90 = 0 time = 910
* CHECK dout0_6 vdout0_6ck90 = 3.3 time = 910
* CHECK dout0_7 vdout0_7ck90 = 0 time = 910
* CHECK dout0_8 vdout0_8ck90 = 0 time = 910
* CHECK dout0_9 vdout0_9ck90 = 3.3 time = 910
* CHECK dout0_10 vdout0_10ck90 = 3.3 time = 910
* CHECK dout0_11 vdout0_11ck90 = 3.3 time = 910
* CHECK dout0_12 vdout0_12ck90 = 0 time = 910
* CHECK dout0_13 vdout0_13ck90 = 3.3 time = 910
* CHECK dout0_14 vdout0_14ck90 = 0 time = 910
* CHECK dout0_15 vdout0_15ck90 = 0 time = 910
* CHECK dout0_16 vdout0_16ck90 = 3.3 time = 910
* CHECK dout0_17 vdout0_17ck90 = 3.3 time = 910
* CHECK dout0_18 vdout0_18ck90 = 0 time = 910
* CHECK dout0_19 vdout0_19ck90 = 0 time = 910
* CHECK dout0_20 vdout0_20ck90 = 0 time = 910
* CHECK dout0_21 vdout0_21ck90 = 0 time = 910
* CHECK dout0_22 vdout0_22ck90 = 0 time = 910
* CHECK dout0_23 vdout0_23ck90 = 0 time = 910
* CHECK dout0_24 vdout0_24ck90 = 0 time = 910
* CHECK dout0_25 vdout0_25ck90 = 3.3 time = 910
* CHECK dout0_26 vdout0_26ck90 = 0 time = 910
* CHECK dout0_27 vdout0_27ck90 = 0 time = 910
* CHECK dout0_28 vdout0_28ck90 = 0 time = 910
* CHECK dout0_29 vdout0_29ck90 = 3.3 time = 910
* CHECK dout0_30 vdout0_30ck90 = 0 time = 910
* CHECK dout0_31 vdout0_31ck90 = 0 time = 910
* CHECK dout1_0 vdout1_0ck90 = 0 time = 910
* CHECK dout1_1 vdout1_1ck90 = 3.3 time = 910
* CHECK dout1_2 vdout1_2ck90 = 0 time = 910
* CHECK dout1_3 vdout1_3ck90 = 3.3 time = 910
* CHECK dout1_4 vdout1_4ck90 = 0 time = 910
* CHECK dout1_5 vdout1_5ck90 = 3.3 time = 910
* CHECK dout1_6 vdout1_6ck90 = 0 time = 910
* CHECK dout1_7 vdout1_7ck90 = 0 time = 910
* CHECK dout1_8 vdout1_8ck90 = 3.3 time = 910
* CHECK dout1_9 vdout1_9ck90 = 0 time = 910
* CHECK dout1_10 vdout1_10ck90 = 0 time = 910
* CHECK dout1_11 vdout1_11ck90 = 0 time = 910
* CHECK dout1_12 vdout1_12ck90 = 0 time = 910
* CHECK dout1_13 vdout1_13ck90 = 3.3 time = 910
* CHECK dout1_14 vdout1_14ck90 = 0 time = 910
* CHECK dout1_15 vdout1_15ck90 = 0 time = 910
* CHECK dout1_16 vdout1_16ck90 = 3.3 time = 910
* CHECK dout1_17 vdout1_17ck90 = 3.3 time = 910
* CHECK dout1_18 vdout1_18ck90 = 3.3 time = 910
* CHECK dout1_19 vdout1_19ck90 = 0 time = 910
* CHECK dout1_20 vdout1_20ck90 = 3.3 time = 910
* CHECK dout1_21 vdout1_21ck90 = 3.3 time = 910
* CHECK dout1_22 vdout1_22ck90 = 0 time = 910
* CHECK dout1_23 vdout1_23ck90 = 3.3 time = 910
* CHECK dout1_24 vdout1_24ck90 = 0 time = 910
* CHECK dout1_25 vdout1_25ck90 = 0 time = 910
* CHECK dout1_26 vdout1_26ck90 = 3.3 time = 910
* CHECK dout1_27 vdout1_27ck90 = 0 time = 910
* CHECK dout1_28 vdout1_28ck90 = 3.3 time = 910
* CHECK dout1_29 vdout1_29ck90 = 0 time = 910
* CHECK dout1_30 vdout1_30ck90 = 3.3 time = 910
* CHECK dout1_31 vdout1_31ck90 = 3.3 time = 910
* CHECK dout0_0 vdout0_0ck91 = 3.3 time = 920
* CHECK dout0_1 vdout0_1ck91 = 0 time = 920
* CHECK dout0_2 vdout0_2ck91 = 0 time = 920
* CHECK dout0_3 vdout0_3ck91 = 3.3 time = 920
* CHECK dout0_4 vdout0_4ck91 = 0 time = 920
* CHECK dout0_5 vdout0_5ck91 = 0 time = 920
* CHECK dout0_6 vdout0_6ck91 = 3.3 time = 920
* CHECK dout0_7 vdout0_7ck91 = 0 time = 920
* CHECK dout0_8 vdout0_8ck91 = 0 time = 920
* CHECK dout0_9 vdout0_9ck91 = 3.3 time = 920
* CHECK dout0_10 vdout0_10ck91 = 3.3 time = 920
* CHECK dout0_11 vdout0_11ck91 = 3.3 time = 920
* CHECK dout0_12 vdout0_12ck91 = 0 time = 920
* CHECK dout0_13 vdout0_13ck91 = 3.3 time = 920
* CHECK dout0_14 vdout0_14ck91 = 0 time = 920
* CHECK dout0_15 vdout0_15ck91 = 0 time = 920
* CHECK dout0_16 vdout0_16ck91 = 3.3 time = 920
* CHECK dout0_17 vdout0_17ck91 = 3.3 time = 920
* CHECK dout0_18 vdout0_18ck91 = 0 time = 920
* CHECK dout0_19 vdout0_19ck91 = 0 time = 920
* CHECK dout0_20 vdout0_20ck91 = 0 time = 920
* CHECK dout0_21 vdout0_21ck91 = 0 time = 920
* CHECK dout0_22 vdout0_22ck91 = 0 time = 920
* CHECK dout0_23 vdout0_23ck91 = 0 time = 920
* CHECK dout0_24 vdout0_24ck91 = 0 time = 920
* CHECK dout0_25 vdout0_25ck91 = 3.3 time = 920
* CHECK dout0_26 vdout0_26ck91 = 0 time = 920
* CHECK dout0_27 vdout0_27ck91 = 0 time = 920
* CHECK dout0_28 vdout0_28ck91 = 0 time = 920
* CHECK dout0_29 vdout0_29ck91 = 3.3 time = 920
* CHECK dout0_30 vdout0_30ck91 = 0 time = 920
* CHECK dout0_31 vdout0_31ck91 = 0 time = 920
* CHECK dout1_0 vdout1_0ck91 = 0 time = 920
* CHECK dout1_1 vdout1_1ck91 = 3.3 time = 920
* CHECK dout1_2 vdout1_2ck91 = 0 time = 920
* CHECK dout1_3 vdout1_3ck91 = 3.3 time = 920
* CHECK dout1_4 vdout1_4ck91 = 0 time = 920
* CHECK dout1_5 vdout1_5ck91 = 3.3 time = 920
* CHECK dout1_6 vdout1_6ck91 = 0 time = 920
* CHECK dout1_7 vdout1_7ck91 = 0 time = 920
* CHECK dout1_8 vdout1_8ck91 = 3.3 time = 920
* CHECK dout1_9 vdout1_9ck91 = 0 time = 920
* CHECK dout1_10 vdout1_10ck91 = 0 time = 920
* CHECK dout1_11 vdout1_11ck91 = 0 time = 920
* CHECK dout1_12 vdout1_12ck91 = 0 time = 920
* CHECK dout1_13 vdout1_13ck91 = 3.3 time = 920
* CHECK dout1_14 vdout1_14ck91 = 0 time = 920
* CHECK dout1_15 vdout1_15ck91 = 0 time = 920
* CHECK dout1_16 vdout1_16ck91 = 3.3 time = 920
* CHECK dout1_17 vdout1_17ck91 = 3.3 time = 920
* CHECK dout1_18 vdout1_18ck91 = 3.3 time = 920
* CHECK dout1_19 vdout1_19ck91 = 0 time = 920
* CHECK dout1_20 vdout1_20ck91 = 3.3 time = 920
* CHECK dout1_21 vdout1_21ck91 = 3.3 time = 920
* CHECK dout1_22 vdout1_22ck91 = 0 time = 920
* CHECK dout1_23 vdout1_23ck91 = 3.3 time = 920
* CHECK dout1_24 vdout1_24ck91 = 0 time = 920
* CHECK dout1_25 vdout1_25ck91 = 0 time = 920
* CHECK dout1_26 vdout1_26ck91 = 3.3 time = 920
* CHECK dout1_27 vdout1_27ck91 = 0 time = 920
* CHECK dout1_28 vdout1_28ck91 = 3.3 time = 920
* CHECK dout1_29 vdout1_29ck91 = 0 time = 920
* CHECK dout1_30 vdout1_30ck91 = 3.3 time = 920
* CHECK dout1_31 vdout1_31ck91 = 3.3 time = 920
* CHECK dout0_0 vdout0_0ck92 = 3.3 time = 930
* CHECK dout0_1 vdout0_1ck92 = 0 time = 930
* CHECK dout0_2 vdout0_2ck92 = 0 time = 930
* CHECK dout0_3 vdout0_3ck92 = 3.3 time = 930
* CHECK dout0_4 vdout0_4ck92 = 0 time = 930
* CHECK dout0_5 vdout0_5ck92 = 0 time = 930
* CHECK dout0_6 vdout0_6ck92 = 3.3 time = 930
* CHECK dout0_7 vdout0_7ck92 = 0 time = 930
* CHECK dout0_8 vdout0_8ck92 = 0 time = 930
* CHECK dout0_9 vdout0_9ck92 = 3.3 time = 930
* CHECK dout0_10 vdout0_10ck92 = 3.3 time = 930
* CHECK dout0_11 vdout0_11ck92 = 3.3 time = 930
* CHECK dout0_12 vdout0_12ck92 = 0 time = 930
* CHECK dout0_13 vdout0_13ck92 = 3.3 time = 930
* CHECK dout0_14 vdout0_14ck92 = 0 time = 930
* CHECK dout0_15 vdout0_15ck92 = 0 time = 930
* CHECK dout0_16 vdout0_16ck92 = 3.3 time = 930
* CHECK dout0_17 vdout0_17ck92 = 3.3 time = 930
* CHECK dout0_18 vdout0_18ck92 = 0 time = 930
* CHECK dout0_19 vdout0_19ck92 = 0 time = 930
* CHECK dout0_20 vdout0_20ck92 = 0 time = 930
* CHECK dout0_21 vdout0_21ck92 = 0 time = 930
* CHECK dout0_22 vdout0_22ck92 = 0 time = 930
* CHECK dout0_23 vdout0_23ck92 = 0 time = 930
* CHECK dout0_24 vdout0_24ck92 = 0 time = 930
* CHECK dout0_25 vdout0_25ck92 = 3.3 time = 930
* CHECK dout0_26 vdout0_26ck92 = 0 time = 930
* CHECK dout0_27 vdout0_27ck92 = 0 time = 930
* CHECK dout0_28 vdout0_28ck92 = 0 time = 930
* CHECK dout0_29 vdout0_29ck92 = 3.3 time = 930
* CHECK dout0_30 vdout0_30ck92 = 0 time = 930
* CHECK dout0_31 vdout0_31ck92 = 0 time = 930
* CHECK dout1_0 vdout1_0ck92 = 0 time = 930
* CHECK dout1_1 vdout1_1ck92 = 3.3 time = 930
* CHECK dout1_2 vdout1_2ck92 = 0 time = 930
* CHECK dout1_3 vdout1_3ck92 = 3.3 time = 930
* CHECK dout1_4 vdout1_4ck92 = 0 time = 930
* CHECK dout1_5 vdout1_5ck92 = 3.3 time = 930
* CHECK dout1_6 vdout1_6ck92 = 0 time = 930
* CHECK dout1_7 vdout1_7ck92 = 0 time = 930
* CHECK dout1_8 vdout1_8ck92 = 3.3 time = 930
* CHECK dout1_9 vdout1_9ck92 = 0 time = 930
* CHECK dout1_10 vdout1_10ck92 = 0 time = 930
* CHECK dout1_11 vdout1_11ck92 = 0 time = 930
* CHECK dout1_12 vdout1_12ck92 = 0 time = 930
* CHECK dout1_13 vdout1_13ck92 = 3.3 time = 930
* CHECK dout1_14 vdout1_14ck92 = 0 time = 930
* CHECK dout1_15 vdout1_15ck92 = 0 time = 930
* CHECK dout1_16 vdout1_16ck92 = 3.3 time = 930
* CHECK dout1_17 vdout1_17ck92 = 3.3 time = 930
* CHECK dout1_18 vdout1_18ck92 = 3.3 time = 930
* CHECK dout1_19 vdout1_19ck92 = 0 time = 930
* CHECK dout1_20 vdout1_20ck92 = 3.3 time = 930
* CHECK dout1_21 vdout1_21ck92 = 3.3 time = 930
* CHECK dout1_22 vdout1_22ck92 = 0 time = 930
* CHECK dout1_23 vdout1_23ck92 = 3.3 time = 930
* CHECK dout1_24 vdout1_24ck92 = 0 time = 930
* CHECK dout1_25 vdout1_25ck92 = 0 time = 930
* CHECK dout1_26 vdout1_26ck92 = 3.3 time = 930
* CHECK dout1_27 vdout1_27ck92 = 0 time = 930
* CHECK dout1_28 vdout1_28ck92 = 3.3 time = 930
* CHECK dout1_29 vdout1_29ck92 = 0 time = 930
* CHECK dout1_30 vdout1_30ck92 = 3.3 time = 930
* CHECK dout1_31 vdout1_31ck92 = 3.3 time = 930
* CHECK dout0_0 vdout0_0ck93 = 3.3 time = 940
* CHECK dout0_1 vdout0_1ck93 = 0 time = 940
* CHECK dout0_2 vdout0_2ck93 = 0 time = 940
* CHECK dout0_3 vdout0_3ck93 = 3.3 time = 940
* CHECK dout0_4 vdout0_4ck93 = 0 time = 940
* CHECK dout0_5 vdout0_5ck93 = 0 time = 940
* CHECK dout0_6 vdout0_6ck93 = 3.3 time = 940
* CHECK dout0_7 vdout0_7ck93 = 0 time = 940
* CHECK dout0_8 vdout0_8ck93 = 0 time = 940
* CHECK dout0_9 vdout0_9ck93 = 3.3 time = 940
* CHECK dout0_10 vdout0_10ck93 = 3.3 time = 940
* CHECK dout0_11 vdout0_11ck93 = 3.3 time = 940
* CHECK dout0_12 vdout0_12ck93 = 0 time = 940
* CHECK dout0_13 vdout0_13ck93 = 3.3 time = 940
* CHECK dout0_14 vdout0_14ck93 = 0 time = 940
* CHECK dout0_15 vdout0_15ck93 = 0 time = 940
* CHECK dout0_16 vdout0_16ck93 = 3.3 time = 940
* CHECK dout0_17 vdout0_17ck93 = 3.3 time = 940
* CHECK dout0_18 vdout0_18ck93 = 0 time = 940
* CHECK dout0_19 vdout0_19ck93 = 0 time = 940
* CHECK dout0_20 vdout0_20ck93 = 0 time = 940
* CHECK dout0_21 vdout0_21ck93 = 0 time = 940
* CHECK dout0_22 vdout0_22ck93 = 0 time = 940
* CHECK dout0_23 vdout0_23ck93 = 0 time = 940
* CHECK dout0_24 vdout0_24ck93 = 0 time = 940
* CHECK dout0_25 vdout0_25ck93 = 3.3 time = 940
* CHECK dout0_26 vdout0_26ck93 = 0 time = 940
* CHECK dout0_27 vdout0_27ck93 = 0 time = 940
* CHECK dout0_28 vdout0_28ck93 = 0 time = 940
* CHECK dout0_29 vdout0_29ck93 = 3.3 time = 940
* CHECK dout0_30 vdout0_30ck93 = 0 time = 940
* CHECK dout0_31 vdout0_31ck93 = 0 time = 940
* CHECK dout1_0 vdout1_0ck93 = 0 time = 940
* CHECK dout1_1 vdout1_1ck93 = 3.3 time = 940
* CHECK dout1_2 vdout1_2ck93 = 0 time = 940
* CHECK dout1_3 vdout1_3ck93 = 3.3 time = 940
* CHECK dout1_4 vdout1_4ck93 = 0 time = 940
* CHECK dout1_5 vdout1_5ck93 = 3.3 time = 940
* CHECK dout1_6 vdout1_6ck93 = 0 time = 940
* CHECK dout1_7 vdout1_7ck93 = 0 time = 940
* CHECK dout1_8 vdout1_8ck93 = 3.3 time = 940
* CHECK dout1_9 vdout1_9ck93 = 0 time = 940
* CHECK dout1_10 vdout1_10ck93 = 0 time = 940
* CHECK dout1_11 vdout1_11ck93 = 0 time = 940
* CHECK dout1_12 vdout1_12ck93 = 0 time = 940
* CHECK dout1_13 vdout1_13ck93 = 3.3 time = 940
* CHECK dout1_14 vdout1_14ck93 = 0 time = 940
* CHECK dout1_15 vdout1_15ck93 = 0 time = 940
* CHECK dout1_16 vdout1_16ck93 = 3.3 time = 940
* CHECK dout1_17 vdout1_17ck93 = 3.3 time = 940
* CHECK dout1_18 vdout1_18ck93 = 3.3 time = 940
* CHECK dout1_19 vdout1_19ck93 = 0 time = 940
* CHECK dout1_20 vdout1_20ck93 = 3.3 time = 940
* CHECK dout1_21 vdout1_21ck93 = 3.3 time = 940
* CHECK dout1_22 vdout1_22ck93 = 0 time = 940
* CHECK dout1_23 vdout1_23ck93 = 3.3 time = 940
* CHECK dout1_24 vdout1_24ck93 = 0 time = 940
* CHECK dout1_25 vdout1_25ck93 = 0 time = 940
* CHECK dout1_26 vdout1_26ck93 = 3.3 time = 940
* CHECK dout1_27 vdout1_27ck93 = 0 time = 940
* CHECK dout1_28 vdout1_28ck93 = 3.3 time = 940
* CHECK dout1_29 vdout1_29ck93 = 0 time = 940
* CHECK dout1_30 vdout1_30ck93 = 3.3 time = 940
* CHECK dout1_31 vdout1_31ck93 = 3.3 time = 940
* CHECK dout0_0 vdout0_0ck94 = 3.3 time = 950
* CHECK dout0_1 vdout0_1ck94 = 0 time = 950
* CHECK dout0_2 vdout0_2ck94 = 0 time = 950
* CHECK dout0_3 vdout0_3ck94 = 3.3 time = 950
* CHECK dout0_4 vdout0_4ck94 = 0 time = 950
* CHECK dout0_5 vdout0_5ck94 = 0 time = 950
* CHECK dout0_6 vdout0_6ck94 = 3.3 time = 950
* CHECK dout0_7 vdout0_7ck94 = 0 time = 950
* CHECK dout0_8 vdout0_8ck94 = 0 time = 950
* CHECK dout0_9 vdout0_9ck94 = 3.3 time = 950
* CHECK dout0_10 vdout0_10ck94 = 3.3 time = 950
* CHECK dout0_11 vdout0_11ck94 = 3.3 time = 950
* CHECK dout0_12 vdout0_12ck94 = 0 time = 950
* CHECK dout0_13 vdout0_13ck94 = 3.3 time = 950
* CHECK dout0_14 vdout0_14ck94 = 0 time = 950
* CHECK dout0_15 vdout0_15ck94 = 0 time = 950
* CHECK dout0_16 vdout0_16ck94 = 3.3 time = 950
* CHECK dout0_17 vdout0_17ck94 = 3.3 time = 950
* CHECK dout0_18 vdout0_18ck94 = 0 time = 950
* CHECK dout0_19 vdout0_19ck94 = 0 time = 950
* CHECK dout0_20 vdout0_20ck94 = 0 time = 950
* CHECK dout0_21 vdout0_21ck94 = 0 time = 950
* CHECK dout0_22 vdout0_22ck94 = 0 time = 950
* CHECK dout0_23 vdout0_23ck94 = 0 time = 950
* CHECK dout0_24 vdout0_24ck94 = 0 time = 950
* CHECK dout0_25 vdout0_25ck94 = 3.3 time = 950
* CHECK dout0_26 vdout0_26ck94 = 0 time = 950
* CHECK dout0_27 vdout0_27ck94 = 0 time = 950
* CHECK dout0_28 vdout0_28ck94 = 0 time = 950
* CHECK dout0_29 vdout0_29ck94 = 3.3 time = 950
* CHECK dout0_30 vdout0_30ck94 = 0 time = 950
* CHECK dout0_31 vdout0_31ck94 = 0 time = 950
* CHECK dout0_0 vdout0_0ck95 = 0 time = 960
* CHECK dout0_1 vdout0_1ck95 = 3.3 time = 960
* CHECK dout0_2 vdout0_2ck95 = 3.3 time = 960
* CHECK dout0_3 vdout0_3ck95 = 0 time = 960
* CHECK dout0_4 vdout0_4ck95 = 0 time = 960
* CHECK dout0_5 vdout0_5ck95 = 3.3 time = 960
* CHECK dout0_6 vdout0_6ck95 = 0 time = 960
* CHECK dout0_7 vdout0_7ck95 = 3.3 time = 960
* CHECK dout0_8 vdout0_8ck95 = 0 time = 960
* CHECK dout0_9 vdout0_9ck95 = 0 time = 960
* CHECK dout0_10 vdout0_10ck95 = 3.3 time = 960
* CHECK dout0_11 vdout0_11ck95 = 0 time = 960
* CHECK dout0_12 vdout0_12ck95 = 0 time = 960
* CHECK dout0_13 vdout0_13ck95 = 3.3 time = 960
* CHECK dout0_14 vdout0_14ck95 = 0 time = 960
* CHECK dout0_15 vdout0_15ck95 = 0 time = 960
* CHECK dout0_16 vdout0_16ck95 = 3.3 time = 960
* CHECK dout0_17 vdout0_17ck95 = 3.3 time = 960
* CHECK dout0_18 vdout0_18ck95 = 0 time = 960
* CHECK dout0_19 vdout0_19ck95 = 0 time = 960
* CHECK dout0_20 vdout0_20ck95 = 0 time = 960
* CHECK dout0_21 vdout0_21ck95 = 3.3 time = 960
* CHECK dout0_22 vdout0_22ck95 = 0 time = 960
* CHECK dout0_23 vdout0_23ck95 = 3.3 time = 960
* CHECK dout0_24 vdout0_24ck95 = 0 time = 960
* CHECK dout0_25 vdout0_25ck95 = 0 time = 960
* CHECK dout0_26 vdout0_26ck95 = 0 time = 960
* CHECK dout0_27 vdout0_27ck95 = 3.3 time = 960
* CHECK dout0_28 vdout0_28ck95 = 0 time = 960
* CHECK dout0_29 vdout0_29ck95 = 0 time = 960
* CHECK dout0_30 vdout0_30ck95 = 3.3 time = 960
* CHECK dout0_31 vdout0_31ck95 = 0 time = 960
* CHECK dout0_0 vdout0_0ck96 = 0 time = 970
* CHECK dout0_1 vdout0_1ck96 = 0 time = 970
* CHECK dout0_2 vdout0_2ck96 = 0 time = 970
* CHECK dout0_3 vdout0_3ck96 = 3.3 time = 970
* CHECK dout0_4 vdout0_4ck96 = 0 time = 970
* CHECK dout0_5 vdout0_5ck96 = 0 time = 970
* CHECK dout0_6 vdout0_6ck96 = 0 time = 970
* CHECK dout0_7 vdout0_7ck96 = 0 time = 970
* CHECK dout0_8 vdout0_8ck96 = 3.3 time = 970
* CHECK dout0_9 vdout0_9ck96 = 3.3 time = 970
* CHECK dout0_10 vdout0_10ck96 = 0 time = 970
* CHECK dout0_11 vdout0_11ck96 = 0 time = 970
* CHECK dout0_12 vdout0_12ck96 = 3.3 time = 970
* CHECK dout0_13 vdout0_13ck96 = 3.3 time = 970
* CHECK dout0_14 vdout0_14ck96 = 3.3 time = 970
* CHECK dout0_15 vdout0_15ck96 = 3.3 time = 970
* CHECK dout0_16 vdout0_16ck96 = 3.3 time = 970
* CHECK dout0_17 vdout0_17ck96 = 3.3 time = 970
* CHECK dout0_18 vdout0_18ck96 = 3.3 time = 970
* CHECK dout0_19 vdout0_19ck96 = 3.3 time = 970
* CHECK dout0_20 vdout0_20ck96 = 0 time = 970
* CHECK dout0_21 vdout0_21ck96 = 3.3 time = 970
* CHECK dout0_22 vdout0_22ck96 = 0 time = 970
* CHECK dout0_23 vdout0_23ck96 = 0 time = 970
* CHECK dout0_24 vdout0_24ck96 = 0 time = 970
* CHECK dout0_25 vdout0_25ck96 = 3.3 time = 970
* CHECK dout0_26 vdout0_26ck96 = 0 time = 970
* CHECK dout0_27 vdout0_27ck96 = 3.3 time = 970
* CHECK dout0_28 vdout0_28ck96 = 3.3 time = 970
* CHECK dout0_29 vdout0_29ck96 = 0 time = 970
* CHECK dout0_30 vdout0_30ck96 = 0 time = 970
* CHECK dout0_31 vdout0_31ck96 = 0 time = 970
* CHECK dout1_0 vdout1_0ck96 = 0 time = 970
* CHECK dout1_1 vdout1_1ck96 = 0 time = 970
* CHECK dout1_2 vdout1_2ck96 = 0 time = 970
* CHECK dout1_3 vdout1_3ck96 = 3.3 time = 970
* CHECK dout1_4 vdout1_4ck96 = 0 time = 970
* CHECK dout1_5 vdout1_5ck96 = 0 time = 970
* CHECK dout1_6 vdout1_6ck96 = 0 time = 970
* CHECK dout1_7 vdout1_7ck96 = 0 time = 970
* CHECK dout1_8 vdout1_8ck96 = 3.3 time = 970
* CHECK dout1_9 vdout1_9ck96 = 3.3 time = 970
* CHECK dout1_10 vdout1_10ck96 = 0 time = 970
* CHECK dout1_11 vdout1_11ck96 = 0 time = 970
* CHECK dout1_12 vdout1_12ck96 = 3.3 time = 970
* CHECK dout1_13 vdout1_13ck96 = 3.3 time = 970
* CHECK dout1_14 vdout1_14ck96 = 3.3 time = 970
* CHECK dout1_15 vdout1_15ck96 = 3.3 time = 970
* CHECK dout1_16 vdout1_16ck96 = 3.3 time = 970
* CHECK dout1_17 vdout1_17ck96 = 3.3 time = 970
* CHECK dout1_18 vdout1_18ck96 = 3.3 time = 970
* CHECK dout1_19 vdout1_19ck96 = 3.3 time = 970
* CHECK dout1_20 vdout1_20ck96 = 0 time = 970
* CHECK dout1_21 vdout1_21ck96 = 3.3 time = 970
* CHECK dout1_22 vdout1_22ck96 = 0 time = 970
* CHECK dout1_23 vdout1_23ck96 = 0 time = 970
* CHECK dout1_24 vdout1_24ck96 = 0 time = 970
* CHECK dout1_25 vdout1_25ck96 = 3.3 time = 970
* CHECK dout1_26 vdout1_26ck96 = 0 time = 970
* CHECK dout1_27 vdout1_27ck96 = 3.3 time = 970
* CHECK dout1_28 vdout1_28ck96 = 3.3 time = 970
* CHECK dout1_29 vdout1_29ck96 = 0 time = 970
* CHECK dout1_30 vdout1_30ck96 = 0 time = 970
* CHECK dout1_31 vdout1_31ck96 = 0 time = 970
* CHECK dout0_0 vdout0_0ck97 = 0 time = 980
* CHECK dout0_1 vdout0_1ck97 = 3.3 time = 980
* CHECK dout0_2 vdout0_2ck97 = 3.3 time = 980
* CHECK dout0_3 vdout0_3ck97 = 0 time = 980
* CHECK dout0_4 vdout0_4ck97 = 0 time = 980
* CHECK dout0_5 vdout0_5ck97 = 3.3 time = 980
* CHECK dout0_6 vdout0_6ck97 = 0 time = 980
* CHECK dout0_7 vdout0_7ck97 = 3.3 time = 980
* CHECK dout0_8 vdout0_8ck97 = 0 time = 980
* CHECK dout0_9 vdout0_9ck97 = 0 time = 980
* CHECK dout0_10 vdout0_10ck97 = 3.3 time = 980
* CHECK dout0_11 vdout0_11ck97 = 0 time = 980
* CHECK dout0_12 vdout0_12ck97 = 0 time = 980
* CHECK dout0_13 vdout0_13ck97 = 3.3 time = 980
* CHECK dout0_14 vdout0_14ck97 = 0 time = 980
* CHECK dout0_15 vdout0_15ck97 = 0 time = 980
* CHECK dout0_16 vdout0_16ck97 = 3.3 time = 980
* CHECK dout0_17 vdout0_17ck97 = 3.3 time = 980
* CHECK dout0_18 vdout0_18ck97 = 0 time = 980
* CHECK dout0_19 vdout0_19ck97 = 0 time = 980
* CHECK dout0_20 vdout0_20ck97 = 0 time = 980
* CHECK dout0_21 vdout0_21ck97 = 3.3 time = 980
* CHECK dout0_22 vdout0_22ck97 = 0 time = 980
* CHECK dout0_23 vdout0_23ck97 = 3.3 time = 980
* CHECK dout0_24 vdout0_24ck97 = 0 time = 980
* CHECK dout0_25 vdout0_25ck97 = 0 time = 980
* CHECK dout0_26 vdout0_26ck97 = 0 time = 980
* CHECK dout0_27 vdout0_27ck97 = 3.3 time = 980
* CHECK dout0_28 vdout0_28ck97 = 0 time = 980
* CHECK dout0_29 vdout0_29ck97 = 0 time = 980
* CHECK dout0_30 vdout0_30ck97 = 3.3 time = 980
* CHECK dout0_31 vdout0_31ck97 = 0 time = 980
* CHECK dout1_0 vdout1_0ck98 = 0 time = 990
* CHECK dout1_1 vdout1_1ck98 = 0 time = 990
* CHECK dout1_2 vdout1_2ck98 = 0 time = 990
* CHECK dout1_3 vdout1_3ck98 = 3.3 time = 990
* CHECK dout1_4 vdout1_4ck98 = 0 time = 990
* CHECK dout1_5 vdout1_5ck98 = 0 time = 990
* CHECK dout1_6 vdout1_6ck98 = 0 time = 990
* CHECK dout1_7 vdout1_7ck98 = 0 time = 990
* CHECK dout1_8 vdout1_8ck98 = 3.3 time = 990
* CHECK dout1_9 vdout1_9ck98 = 3.3 time = 990
* CHECK dout1_10 vdout1_10ck98 = 0 time = 990
* CHECK dout1_11 vdout1_11ck98 = 0 time = 990
* CHECK dout1_12 vdout1_12ck98 = 3.3 time = 990
* CHECK dout1_13 vdout1_13ck98 = 3.3 time = 990
* CHECK dout1_14 vdout1_14ck98 = 3.3 time = 990
* CHECK dout1_15 vdout1_15ck98 = 3.3 time = 990
* CHECK dout1_16 vdout1_16ck98 = 3.3 time = 990
* CHECK dout1_17 vdout1_17ck98 = 3.3 time = 990
* CHECK dout1_18 vdout1_18ck98 = 3.3 time = 990
* CHECK dout1_19 vdout1_19ck98 = 3.3 time = 990
* CHECK dout1_20 vdout1_20ck98 = 0 time = 990
* CHECK dout1_21 vdout1_21ck98 = 3.3 time = 990
* CHECK dout1_22 vdout1_22ck98 = 0 time = 990
* CHECK dout1_23 vdout1_23ck98 = 0 time = 990
* CHECK dout1_24 vdout1_24ck98 = 0 time = 990
* CHECK dout1_25 vdout1_25ck98 = 3.3 time = 990
* CHECK dout1_26 vdout1_26ck98 = 0 time = 990
* CHECK dout1_27 vdout1_27ck98 = 3.3 time = 990
* CHECK dout1_28 vdout1_28ck98 = 3.3 time = 990
* CHECK dout1_29 vdout1_29ck98 = 0 time = 990
* CHECK dout1_30 vdout1_30ck98 = 0 time = 990
* CHECK dout1_31 vdout1_31ck98 = 0 time = 990
* CHECK dout0_0 vdout0_0ck103 = 0 time = 1040
* CHECK dout0_1 vdout0_1ck103 = 3.3 time = 1040
* CHECK dout0_2 vdout0_2ck103 = 3.3 time = 1040
* CHECK dout0_3 vdout0_3ck103 = 0 time = 1040
* CHECK dout0_4 vdout0_4ck103 = 0 time = 1040
* CHECK dout0_5 vdout0_5ck103 = 3.3 time = 1040
* CHECK dout0_6 vdout0_6ck103 = 0 time = 1040
* CHECK dout0_7 vdout0_7ck103 = 3.3 time = 1040
* CHECK dout0_8 vdout0_8ck103 = 0 time = 1040
* CHECK dout0_9 vdout0_9ck103 = 0 time = 1040
* CHECK dout0_10 vdout0_10ck103 = 3.3 time = 1040
* CHECK dout0_11 vdout0_11ck103 = 0 time = 1040
* CHECK dout0_12 vdout0_12ck103 = 0 time = 1040
* CHECK dout0_13 vdout0_13ck103 = 3.3 time = 1040
* CHECK dout0_14 vdout0_14ck103 = 0 time = 1040
* CHECK dout0_15 vdout0_15ck103 = 0 time = 1040
* CHECK dout0_16 vdout0_16ck103 = 3.3 time = 1040
* CHECK dout0_17 vdout0_17ck103 = 3.3 time = 1040
* CHECK dout0_18 vdout0_18ck103 = 0 time = 1040
* CHECK dout0_19 vdout0_19ck103 = 0 time = 1040
* CHECK dout0_20 vdout0_20ck103 = 0 time = 1040
* CHECK dout0_21 vdout0_21ck103 = 3.3 time = 1040
* CHECK dout0_22 vdout0_22ck103 = 0 time = 1040
* CHECK dout0_23 vdout0_23ck103 = 3.3 time = 1040
* CHECK dout0_24 vdout0_24ck103 = 0 time = 1040
* CHECK dout0_25 vdout0_25ck103 = 0 time = 1040
* CHECK dout0_26 vdout0_26ck103 = 0 time = 1040
* CHECK dout0_27 vdout0_27ck103 = 3.3 time = 1040
* CHECK dout0_28 vdout0_28ck103 = 0 time = 1040
* CHECK dout0_29 vdout0_29ck103 = 0 time = 1040
* CHECK dout0_30 vdout0_30ck103 = 3.3 time = 1040
* CHECK dout0_31 vdout0_31ck103 = 0 time = 1040
* CHECK dout1_0 vdout1_0ck103 = 3.3 time = 1040
* CHECK dout1_1 vdout1_1ck103 = 0 time = 1040
* CHECK dout1_2 vdout1_2ck103 = 0 time = 1040
* CHECK dout1_3 vdout1_3ck103 = 3.3 time = 1040
* CHECK dout1_4 vdout1_4ck103 = 0 time = 1040
* CHECK dout1_5 vdout1_5ck103 = 3.3 time = 1040
* CHECK dout1_6 vdout1_6ck103 = 0 time = 1040
* CHECK dout1_7 vdout1_7ck103 = 0 time = 1040
* CHECK dout1_8 vdout1_8ck103 = 0 time = 1040
* CHECK dout1_9 vdout1_9ck103 = 0 time = 1040
* CHECK dout1_10 vdout1_10ck103 = 3.3 time = 1040
* CHECK dout1_11 vdout1_11ck103 = 3.3 time = 1040
* CHECK dout1_12 vdout1_12ck103 = 3.3 time = 1040
* CHECK dout1_13 vdout1_13ck103 = 3.3 time = 1040
* CHECK dout1_14 vdout1_14ck103 = 0 time = 1040
* CHECK dout1_15 vdout1_15ck103 = 0 time = 1040
* CHECK dout1_16 vdout1_16ck103 = 3.3 time = 1040
* CHECK dout1_17 vdout1_17ck103 = 3.3 time = 1040
* CHECK dout1_18 vdout1_18ck103 = 3.3 time = 1040
* CHECK dout1_19 vdout1_19ck103 = 3.3 time = 1040
* CHECK dout1_20 vdout1_20ck103 = 0 time = 1040
* CHECK dout1_21 vdout1_21ck103 = 0 time = 1040
* CHECK dout1_22 vdout1_22ck103 = 0 time = 1040
* CHECK dout1_23 vdout1_23ck103 = 0 time = 1040
* CHECK dout1_24 vdout1_24ck103 = 0 time = 1040
* CHECK dout1_25 vdout1_25ck103 = 0 time = 1040
* CHECK dout1_26 vdout1_26ck103 = 3.3 time = 1040
* CHECK dout1_27 vdout1_27ck103 = 0 time = 1040
* CHECK dout1_28 vdout1_28ck103 = 0 time = 1040
* CHECK dout1_29 vdout1_29ck103 = 0 time = 1040
* CHECK dout1_30 vdout1_30ck103 = 3.3 time = 1040
* CHECK dout1_31 vdout1_31ck103 = 3.3 time = 1040
* CHECK dout0_0 vdout0_0ck104 = 3.3 time = 1050
* CHECK dout0_1 vdout0_1ck104 = 0 time = 1050
* CHECK dout0_2 vdout0_2ck104 = 0 time = 1050
* CHECK dout0_3 vdout0_3ck104 = 3.3 time = 1050
* CHECK dout0_4 vdout0_4ck104 = 0 time = 1050
* CHECK dout0_5 vdout0_5ck104 = 3.3 time = 1050
* CHECK dout0_6 vdout0_6ck104 = 0 time = 1050
* CHECK dout0_7 vdout0_7ck104 = 0 time = 1050
* CHECK dout0_8 vdout0_8ck104 = 0 time = 1050
* CHECK dout0_9 vdout0_9ck104 = 0 time = 1050
* CHECK dout0_10 vdout0_10ck104 = 3.3 time = 1050
* CHECK dout0_11 vdout0_11ck104 = 3.3 time = 1050
* CHECK dout0_12 vdout0_12ck104 = 3.3 time = 1050
* CHECK dout0_13 vdout0_13ck104 = 3.3 time = 1050
* CHECK dout0_14 vdout0_14ck104 = 0 time = 1050
* CHECK dout0_15 vdout0_15ck104 = 0 time = 1050
* CHECK dout0_16 vdout0_16ck104 = 3.3 time = 1050
* CHECK dout0_17 vdout0_17ck104 = 3.3 time = 1050
* CHECK dout0_18 vdout0_18ck104 = 3.3 time = 1050
* CHECK dout0_19 vdout0_19ck104 = 3.3 time = 1050
* CHECK dout0_20 vdout0_20ck104 = 0 time = 1050
* CHECK dout0_21 vdout0_21ck104 = 0 time = 1050
* CHECK dout0_22 vdout0_22ck104 = 0 time = 1050
* CHECK dout0_23 vdout0_23ck104 = 0 time = 1050
* CHECK dout0_24 vdout0_24ck104 = 0 time = 1050
* CHECK dout0_25 vdout0_25ck104 = 0 time = 1050
* CHECK dout0_26 vdout0_26ck104 = 3.3 time = 1050
* CHECK dout0_27 vdout0_27ck104 = 0 time = 1050
* CHECK dout0_28 vdout0_28ck104 = 0 time = 1050
* CHECK dout0_29 vdout0_29ck104 = 0 time = 1050
* CHECK dout0_30 vdout0_30ck104 = 3.3 time = 1050
* CHECK dout0_31 vdout0_31ck104 = 3.3 time = 1050
* CHECK dout0_0 vdout0_0ck106 = 0 time = 1070
* CHECK dout0_1 vdout0_1ck106 = 0 time = 1070
* CHECK dout0_2 vdout0_2ck106 = 0 time = 1070
* CHECK dout0_3 vdout0_3ck106 = 0 time = 1070
* CHECK dout0_4 vdout0_4ck106 = 3.3 time = 1070
* CHECK dout0_5 vdout0_5ck106 = 3.3 time = 1070
* CHECK dout0_6 vdout0_6ck106 = 3.3 time = 1070
* CHECK dout0_7 vdout0_7ck106 = 0 time = 1070
* CHECK dout0_8 vdout0_8ck106 = 3.3 time = 1070
* CHECK dout0_9 vdout0_9ck106 = 0 time = 1070
* CHECK dout0_10 vdout0_10ck106 = 0 time = 1070
* CHECK dout0_11 vdout0_11ck106 = 3.3 time = 1070
* CHECK dout0_12 vdout0_12ck106 = 0 time = 1070
* CHECK dout0_13 vdout0_13ck106 = 3.3 time = 1070
* CHECK dout0_14 vdout0_14ck106 = 0 time = 1070
* CHECK dout0_15 vdout0_15ck106 = 0 time = 1070
* CHECK dout0_16 vdout0_16ck106 = 3.3 time = 1070
* CHECK dout0_17 vdout0_17ck106 = 0 time = 1070
* CHECK dout0_18 vdout0_18ck106 = 3.3 time = 1070
* CHECK dout0_19 vdout0_19ck106 = 3.3 time = 1070
* CHECK dout0_20 vdout0_20ck106 = 0 time = 1070
* CHECK dout0_21 vdout0_21ck106 = 0 time = 1070
* CHECK dout0_22 vdout0_22ck106 = 3.3 time = 1070
* CHECK dout0_23 vdout0_23ck106 = 3.3 time = 1070
* CHECK dout0_24 vdout0_24ck106 = 0 time = 1070
* CHECK dout0_25 vdout0_25ck106 = 3.3 time = 1070
* CHECK dout0_26 vdout0_26ck106 = 0 time = 1070
* CHECK dout0_27 vdout0_27ck106 = 0 time = 1070
* CHECK dout0_28 vdout0_28ck106 = 0 time = 1070
* CHECK dout0_29 vdout0_29ck106 = 3.3 time = 1070
* CHECK dout0_30 vdout0_30ck106 = 3.3 time = 1070
* CHECK dout0_31 vdout0_31ck106 = 0 time = 1070
* CHECK dout1_0 vdout1_0ck106 = 3.3 time = 1070
* CHECK dout1_1 vdout1_1ck106 = 3.3 time = 1070
* CHECK dout1_2 vdout1_2ck106 = 0 time = 1070
* CHECK dout1_3 vdout1_3ck106 = 0 time = 1070
* CHECK dout1_4 vdout1_4ck106 = 3.3 time = 1070
* CHECK dout1_5 vdout1_5ck106 = 0 time = 1070
* CHECK dout1_6 vdout1_6ck106 = 0 time = 1070
* CHECK dout1_7 vdout1_7ck106 = 3.3 time = 1070
* CHECK dout1_8 vdout1_8ck106 = 3.3 time = 1070
* CHECK dout1_9 vdout1_9ck106 = 3.3 time = 1070
* CHECK dout1_10 vdout1_10ck106 = 0 time = 1070
* CHECK dout1_11 vdout1_11ck106 = 3.3 time = 1070
* CHECK dout1_12 vdout1_12ck106 = 0 time = 1070
* CHECK dout1_13 vdout1_13ck106 = 3.3 time = 1070
* CHECK dout1_14 vdout1_14ck106 = 0 time = 1070
* CHECK dout1_15 vdout1_15ck106 = 3.3 time = 1070
* CHECK dout1_16 vdout1_16ck106 = 0 time = 1070
* CHECK dout1_17 vdout1_17ck106 = 0 time = 1070
* CHECK dout1_18 vdout1_18ck106 = 3.3 time = 1070
* CHECK dout1_19 vdout1_19ck106 = 3.3 time = 1070
* CHECK dout1_20 vdout1_20ck106 = 3.3 time = 1070
* CHECK dout1_21 vdout1_21ck106 = 3.3 time = 1070
* CHECK dout1_22 vdout1_22ck106 = 0 time = 1070
* CHECK dout1_23 vdout1_23ck106 = 0 time = 1070
* CHECK dout1_24 vdout1_24ck106 = 3.3 time = 1070
* CHECK dout1_25 vdout1_25ck106 = 0 time = 1070
* CHECK dout1_26 vdout1_26ck106 = 0 time = 1070
* CHECK dout1_27 vdout1_27ck106 = 3.3 time = 1070
* CHECK dout1_28 vdout1_28ck106 = 0 time = 1070
* CHECK dout1_29 vdout1_29ck106 = 3.3 time = 1070
* CHECK dout1_30 vdout1_30ck106 = 0 time = 1070
* CHECK dout1_31 vdout1_31ck106 = 3.3 time = 1070
* CHECK dout1_0 vdout1_0ck108 = 3.3 time = 1090
* CHECK dout1_1 vdout1_1ck108 = 0 time = 1090
* CHECK dout1_2 vdout1_2ck108 = 0 time = 1090
* CHECK dout1_3 vdout1_3ck108 = 3.3 time = 1090
* CHECK dout1_4 vdout1_4ck108 = 0 time = 1090
* CHECK dout1_5 vdout1_5ck108 = 0 time = 1090
* CHECK dout1_6 vdout1_6ck108 = 3.3 time = 1090
* CHECK dout1_7 vdout1_7ck108 = 3.3 time = 1090
* CHECK dout1_8 vdout1_8ck108 = 0 time = 1090
* CHECK dout1_9 vdout1_9ck108 = 0 time = 1090
* CHECK dout1_10 vdout1_10ck108 = 3.3 time = 1090
* CHECK dout1_11 vdout1_11ck108 = 0 time = 1090
* CHECK dout1_12 vdout1_12ck108 = 0 time = 1090
* CHECK dout1_13 vdout1_13ck108 = 3.3 time = 1090
* CHECK dout1_14 vdout1_14ck108 = 3.3 time = 1090
* CHECK dout1_15 vdout1_15ck108 = 0 time = 1090
* CHECK dout1_16 vdout1_16ck108 = 3.3 time = 1090
* CHECK dout1_17 vdout1_17ck108 = 3.3 time = 1090
* CHECK dout1_18 vdout1_18ck108 = 0 time = 1090
* CHECK dout1_19 vdout1_19ck108 = 0 time = 1090
* CHECK dout1_20 vdout1_20ck108 = 0 time = 1090
* CHECK dout1_21 vdout1_21ck108 = 0 time = 1090
* CHECK dout1_22 vdout1_22ck108 = 0 time = 1090
* CHECK dout1_23 vdout1_23ck108 = 3.3 time = 1090
* CHECK dout1_24 vdout1_24ck108 = 3.3 time = 1090
* CHECK dout1_25 vdout1_25ck108 = 0 time = 1090
* CHECK dout1_26 vdout1_26ck108 = 3.3 time = 1090
* CHECK dout1_27 vdout1_27ck108 = 3.3 time = 1090
* CHECK dout1_28 vdout1_28ck108 = 3.3 time = 1090
* CHECK dout1_29 vdout1_29ck108 = 3.3 time = 1090
* CHECK dout1_30 vdout1_30ck108 = 3.3 time = 1090
* CHECK dout1_31 vdout1_31ck108 = 3.3 time = 1090
* CHECK dout1_0 vdout1_0ck109 = 3.3 time = 1100
* CHECK dout1_1 vdout1_1ck109 = 3.3 time = 1100
* CHECK dout1_2 vdout1_2ck109 = 0 time = 1100
* CHECK dout1_3 vdout1_3ck109 = 0 time = 1100
* CHECK dout1_4 vdout1_4ck109 = 3.3 time = 1100
* CHECK dout1_5 vdout1_5ck109 = 0 time = 1100
* CHECK dout1_6 vdout1_6ck109 = 0 time = 1100
* CHECK dout1_7 vdout1_7ck109 = 3.3 time = 1100
* CHECK dout1_8 vdout1_8ck109 = 3.3 time = 1100
* CHECK dout1_9 vdout1_9ck109 = 3.3 time = 1100
* CHECK dout1_10 vdout1_10ck109 = 0 time = 1100
* CHECK dout1_11 vdout1_11ck109 = 3.3 time = 1100
* CHECK dout1_12 vdout1_12ck109 = 0 time = 1100
* CHECK dout1_13 vdout1_13ck109 = 3.3 time = 1100
* CHECK dout1_14 vdout1_14ck109 = 0 time = 1100
* CHECK dout1_15 vdout1_15ck109 = 3.3 time = 1100
* CHECK dout1_16 vdout1_16ck109 = 0 time = 1100
* CHECK dout1_17 vdout1_17ck109 = 0 time = 1100
* CHECK dout1_18 vdout1_18ck109 = 3.3 time = 1100
* CHECK dout1_19 vdout1_19ck109 = 3.3 time = 1100
* CHECK dout1_20 vdout1_20ck109 = 3.3 time = 1100
* CHECK dout1_21 vdout1_21ck109 = 3.3 time = 1100
* CHECK dout1_22 vdout1_22ck109 = 0 time = 1100
* CHECK dout1_23 vdout1_23ck109 = 0 time = 1100
* CHECK dout1_24 vdout1_24ck109 = 3.3 time = 1100
* CHECK dout1_25 vdout1_25ck109 = 0 time = 1100
* CHECK dout1_26 vdout1_26ck109 = 0 time = 1100
* CHECK dout1_27 vdout1_27ck109 = 3.3 time = 1100
* CHECK dout1_28 vdout1_28ck109 = 0 time = 1100
* CHECK dout1_29 vdout1_29ck109 = 3.3 time = 1100
* CHECK dout1_30 vdout1_30ck109 = 0 time = 1100
* CHECK dout1_31 vdout1_31ck109 = 3.3 time = 1100
* CHECK dout0_0 vdout0_0ck110 = 3.3 time = 1110
* CHECK dout0_1 vdout0_1ck110 = 0 time = 1110
* CHECK dout0_2 vdout0_2ck110 = 0 time = 1110
* CHECK dout0_3 vdout0_3ck110 = 3.3 time = 1110
* CHECK dout0_4 vdout0_4ck110 = 0 time = 1110
* CHECK dout0_5 vdout0_5ck110 = 0 time = 1110
* CHECK dout0_6 vdout0_6ck110 = 3.3 time = 1110
* CHECK dout0_7 vdout0_7ck110 = 3.3 time = 1110
* CHECK dout0_8 vdout0_8ck110 = 0 time = 1110
* CHECK dout0_9 vdout0_9ck110 = 0 time = 1110
* CHECK dout0_10 vdout0_10ck110 = 3.3 time = 1110
* CHECK dout0_11 vdout0_11ck110 = 0 time = 1110
* CHECK dout0_12 vdout0_12ck110 = 0 time = 1110
* CHECK dout0_13 vdout0_13ck110 = 3.3 time = 1110
* CHECK dout0_14 vdout0_14ck110 = 3.3 time = 1110
* CHECK dout0_15 vdout0_15ck110 = 0 time = 1110
* CHECK dout0_16 vdout0_16ck110 = 3.3 time = 1110
* CHECK dout0_17 vdout0_17ck110 = 3.3 time = 1110
* CHECK dout0_18 vdout0_18ck110 = 0 time = 1110
* CHECK dout0_19 vdout0_19ck110 = 0 time = 1110
* CHECK dout0_20 vdout0_20ck110 = 0 time = 1110
* CHECK dout0_21 vdout0_21ck110 = 0 time = 1110
* CHECK dout0_22 vdout0_22ck110 = 0 time = 1110
* CHECK dout0_23 vdout0_23ck110 = 3.3 time = 1110
* CHECK dout0_24 vdout0_24ck110 = 3.3 time = 1110
* CHECK dout0_25 vdout0_25ck110 = 0 time = 1110
* CHECK dout0_26 vdout0_26ck110 = 3.3 time = 1110
* CHECK dout0_27 vdout0_27ck110 = 3.3 time = 1110
* CHECK dout0_28 vdout0_28ck110 = 3.3 time = 1110
* CHECK dout0_29 vdout0_29ck110 = 3.3 time = 1110
* CHECK dout0_30 vdout0_30ck110 = 3.3 time = 1110
* CHECK dout0_31 vdout0_31ck110 = 3.3 time = 1110
* CHECK dout0_0 vdout0_0ck111 = 3.3 time = 1120
* CHECK dout0_1 vdout0_1ck111 = 3.3 time = 1120
* CHECK dout0_2 vdout0_2ck111 = 0 time = 1120
* CHECK dout0_3 vdout0_3ck111 = 0 time = 1120
* CHECK dout0_4 vdout0_4ck111 = 3.3 time = 1120
* CHECK dout0_5 vdout0_5ck111 = 0 time = 1120
* CHECK dout0_6 vdout0_6ck111 = 0 time = 1120
* CHECK dout0_7 vdout0_7ck111 = 3.3 time = 1120
* CHECK dout0_8 vdout0_8ck111 = 3.3 time = 1120
* CHECK dout0_9 vdout0_9ck111 = 3.3 time = 1120
* CHECK dout0_10 vdout0_10ck111 = 0 time = 1120
* CHECK dout0_11 vdout0_11ck111 = 3.3 time = 1120
* CHECK dout0_12 vdout0_12ck111 = 0 time = 1120
* CHECK dout0_13 vdout0_13ck111 = 3.3 time = 1120
* CHECK dout0_14 vdout0_14ck111 = 0 time = 1120
* CHECK dout0_15 vdout0_15ck111 = 3.3 time = 1120
* CHECK dout0_16 vdout0_16ck111 = 0 time = 1120
* CHECK dout0_17 vdout0_17ck111 = 0 time = 1120
* CHECK dout0_18 vdout0_18ck111 = 3.3 time = 1120
* CHECK dout0_19 vdout0_19ck111 = 3.3 time = 1120
* CHECK dout0_20 vdout0_20ck111 = 3.3 time = 1120
* CHECK dout0_21 vdout0_21ck111 = 3.3 time = 1120
* CHECK dout0_22 vdout0_22ck111 = 0 time = 1120
* CHECK dout0_23 vdout0_23ck111 = 0 time = 1120
* CHECK dout0_24 vdout0_24ck111 = 3.3 time = 1120
* CHECK dout0_25 vdout0_25ck111 = 0 time = 1120
* CHECK dout0_26 vdout0_26ck111 = 0 time = 1120
* CHECK dout0_27 vdout0_27ck111 = 3.3 time = 1120
* CHECK dout0_28 vdout0_28ck111 = 0 time = 1120
* CHECK dout0_29 vdout0_29ck111 = 3.3 time = 1120
* CHECK dout0_30 vdout0_30ck111 = 0 time = 1120
* CHECK dout0_31 vdout0_31ck111 = 3.3 time = 1120
* CHECK dout0_0 vdout0_0ck112 = 3.3 time = 1130
* CHECK dout0_1 vdout0_1ck112 = 3.3 time = 1130
* CHECK dout0_2 vdout0_2ck112 = 0 time = 1130
* CHECK dout0_3 vdout0_3ck112 = 0 time = 1130
* CHECK dout0_4 vdout0_4ck112 = 3.3 time = 1130
* CHECK dout0_5 vdout0_5ck112 = 0 time = 1130
* CHECK dout0_6 vdout0_6ck112 = 0 time = 1130
* CHECK dout0_7 vdout0_7ck112 = 3.3 time = 1130
* CHECK dout0_8 vdout0_8ck112 = 3.3 time = 1130
* CHECK dout0_9 vdout0_9ck112 = 3.3 time = 1130
* CHECK dout0_10 vdout0_10ck112 = 0 time = 1130
* CHECK dout0_11 vdout0_11ck112 = 3.3 time = 1130
* CHECK dout0_12 vdout0_12ck112 = 0 time = 1130
* CHECK dout0_13 vdout0_13ck112 = 3.3 time = 1130
* CHECK dout0_14 vdout0_14ck112 = 0 time = 1130
* CHECK dout0_15 vdout0_15ck112 = 3.3 time = 1130
* CHECK dout0_16 vdout0_16ck112 = 0 time = 1130
* CHECK dout0_17 vdout0_17ck112 = 0 time = 1130
* CHECK dout0_18 vdout0_18ck112 = 3.3 time = 1130
* CHECK dout0_19 vdout0_19ck112 = 3.3 time = 1130
* CHECK dout0_20 vdout0_20ck112 = 3.3 time = 1130
* CHECK dout0_21 vdout0_21ck112 = 3.3 time = 1130
* CHECK dout0_22 vdout0_22ck112 = 0 time = 1130
* CHECK dout0_23 vdout0_23ck112 = 0 time = 1130
* CHECK dout0_24 vdout0_24ck112 = 3.3 time = 1130
* CHECK dout0_25 vdout0_25ck112 = 0 time = 1130
* CHECK dout0_26 vdout0_26ck112 = 0 time = 1130
* CHECK dout0_27 vdout0_27ck112 = 3.3 time = 1130
* CHECK dout0_28 vdout0_28ck112 = 0 time = 1130
* CHECK dout0_29 vdout0_29ck112 = 3.3 time = 1130
* CHECK dout0_30 vdout0_30ck112 = 0 time = 1130
* CHECK dout0_31 vdout0_31ck112 = 3.3 time = 1130
* CHECK dout1_0 vdout1_0ck112 = 0 time = 1130
* CHECK dout1_1 vdout1_1ck112 = 0 time = 1130
* CHECK dout1_2 vdout1_2ck112 = 0 time = 1130
* CHECK dout1_3 vdout1_3ck112 = 0 time = 1130
* CHECK dout1_4 vdout1_4ck112 = 0 time = 1130
* CHECK dout1_5 vdout1_5ck112 = 0 time = 1130
* CHECK dout1_6 vdout1_6ck112 = 0 time = 1130
* CHECK dout1_7 vdout1_7ck112 = 3.3 time = 1130
* CHECK dout1_8 vdout1_8ck112 = 0 time = 1130
* CHECK dout1_9 vdout1_9ck112 = 0 time = 1130
* CHECK dout1_10 vdout1_10ck112 = 0 time = 1130
* CHECK dout1_11 vdout1_11ck112 = 0 time = 1130
* CHECK dout1_12 vdout1_12ck112 = 3.3 time = 1130
* CHECK dout1_13 vdout1_13ck112 = 3.3 time = 1130
* CHECK dout1_14 vdout1_14ck112 = 3.3 time = 1130
* CHECK dout1_15 vdout1_15ck112 = 0 time = 1130
* CHECK dout1_16 vdout1_16ck112 = 0 time = 1130
* CHECK dout1_17 vdout1_17ck112 = 0 time = 1130
* CHECK dout1_18 vdout1_18ck112 = 0 time = 1130
* CHECK dout1_19 vdout1_19ck112 = 3.3 time = 1130
* CHECK dout1_20 vdout1_20ck112 = 3.3 time = 1130
* CHECK dout1_21 vdout1_21ck112 = 0 time = 1130
* CHECK dout1_22 vdout1_22ck112 = 0 time = 1130
* CHECK dout1_23 vdout1_23ck112 = 3.3 time = 1130
* CHECK dout1_24 vdout1_24ck112 = 3.3 time = 1130
* CHECK dout1_25 vdout1_25ck112 = 3.3 time = 1130
* CHECK dout1_26 vdout1_26ck112 = 0 time = 1130
* CHECK dout1_27 vdout1_27ck112 = 3.3 time = 1130
* CHECK dout1_28 vdout1_28ck112 = 3.3 time = 1130
* CHECK dout1_29 vdout1_29ck112 = 0 time = 1130
* CHECK dout1_30 vdout1_30ck112 = 0 time = 1130
* CHECK dout1_31 vdout1_31ck112 = 3.3 time = 1130
* CHECK dout0_0 vdout0_0ck113 = 3.3 time = 1140
* CHECK dout0_1 vdout0_1ck113 = 3.3 time = 1140
* CHECK dout0_2 vdout0_2ck113 = 0 time = 1140
* CHECK dout0_3 vdout0_3ck113 = 0 time = 1140
* CHECK dout0_4 vdout0_4ck113 = 3.3 time = 1140
* CHECK dout0_5 vdout0_5ck113 = 0 time = 1140
* CHECK dout0_6 vdout0_6ck113 = 0 time = 1140
* CHECK dout0_7 vdout0_7ck113 = 3.3 time = 1140
* CHECK dout0_8 vdout0_8ck113 = 3.3 time = 1140
* CHECK dout0_9 vdout0_9ck113 = 3.3 time = 1140
* CHECK dout0_10 vdout0_10ck113 = 0 time = 1140
* CHECK dout0_11 vdout0_11ck113 = 3.3 time = 1140
* CHECK dout0_12 vdout0_12ck113 = 0 time = 1140
* CHECK dout0_13 vdout0_13ck113 = 3.3 time = 1140
* CHECK dout0_14 vdout0_14ck113 = 0 time = 1140
* CHECK dout0_15 vdout0_15ck113 = 3.3 time = 1140
* CHECK dout0_16 vdout0_16ck113 = 0 time = 1140
* CHECK dout0_17 vdout0_17ck113 = 0 time = 1140
* CHECK dout0_18 vdout0_18ck113 = 3.3 time = 1140
* CHECK dout0_19 vdout0_19ck113 = 3.3 time = 1140
* CHECK dout0_20 vdout0_20ck113 = 3.3 time = 1140
* CHECK dout0_21 vdout0_21ck113 = 3.3 time = 1140
* CHECK dout0_22 vdout0_22ck113 = 0 time = 1140
* CHECK dout0_23 vdout0_23ck113 = 0 time = 1140
* CHECK dout0_24 vdout0_24ck113 = 3.3 time = 1140
* CHECK dout0_25 vdout0_25ck113 = 0 time = 1140
* CHECK dout0_26 vdout0_26ck113 = 0 time = 1140
* CHECK dout0_27 vdout0_27ck113 = 3.3 time = 1140
* CHECK dout0_28 vdout0_28ck113 = 0 time = 1140
* CHECK dout0_29 vdout0_29ck113 = 3.3 time = 1140
* CHECK dout0_30 vdout0_30ck113 = 0 time = 1140
* CHECK dout0_31 vdout0_31ck113 = 3.3 time = 1140
* CHECK dout1_0 vdout1_0ck113 = 3.3 time = 1140
* CHECK dout1_1 vdout1_1ck113 = 3.3 time = 1140
* CHECK dout1_2 vdout1_2ck113 = 0 time = 1140
* CHECK dout1_3 vdout1_3ck113 = 0 time = 1140
* CHECK dout1_4 vdout1_4ck113 = 3.3 time = 1140
* CHECK dout1_5 vdout1_5ck113 = 0 time = 1140
* CHECK dout1_6 vdout1_6ck113 = 0 time = 1140
* CHECK dout1_7 vdout1_7ck113 = 3.3 time = 1140
* CHECK dout1_8 vdout1_8ck113 = 3.3 time = 1140
* CHECK dout1_9 vdout1_9ck113 = 3.3 time = 1140
* CHECK dout1_10 vdout1_10ck113 = 0 time = 1140
* CHECK dout1_11 vdout1_11ck113 = 3.3 time = 1140
* CHECK dout1_12 vdout1_12ck113 = 0 time = 1140
* CHECK dout1_13 vdout1_13ck113 = 3.3 time = 1140
* CHECK dout1_14 vdout1_14ck113 = 0 time = 1140
* CHECK dout1_15 vdout1_15ck113 = 3.3 time = 1140
* CHECK dout1_16 vdout1_16ck113 = 0 time = 1140
* CHECK dout1_17 vdout1_17ck113 = 0 time = 1140
* CHECK dout1_18 vdout1_18ck113 = 3.3 time = 1140
* CHECK dout1_19 vdout1_19ck113 = 3.3 time = 1140
* CHECK dout1_20 vdout1_20ck113 = 3.3 time = 1140
* CHECK dout1_21 vdout1_21ck113 = 3.3 time = 1140
* CHECK dout1_22 vdout1_22ck113 = 0 time = 1140
* CHECK dout1_23 vdout1_23ck113 = 0 time = 1140
* CHECK dout1_24 vdout1_24ck113 = 3.3 time = 1140
* CHECK dout1_25 vdout1_25ck113 = 0 time = 1140
* CHECK dout1_26 vdout1_26ck113 = 0 time = 1140
* CHECK dout1_27 vdout1_27ck113 = 3.3 time = 1140
* CHECK dout1_28 vdout1_28ck113 = 0 time = 1140
* CHECK dout1_29 vdout1_29ck113 = 3.3 time = 1140
* CHECK dout1_30 vdout1_30ck113 = 0 time = 1140
* CHECK dout1_31 vdout1_31ck113 = 3.3 time = 1140
* CHECK dout1_0 vdout1_0ck115 = 3.3 time = 1160
* CHECK dout1_1 vdout1_1ck115 = 3.3 time = 1160
* CHECK dout1_2 vdout1_2ck115 = 3.3 time = 1160
* CHECK dout1_3 vdout1_3ck115 = 0 time = 1160
* CHECK dout1_4 vdout1_4ck115 = 3.3 time = 1160
* CHECK dout1_5 vdout1_5ck115 = 3.3 time = 1160
* CHECK dout1_6 vdout1_6ck115 = 3.3 time = 1160
* CHECK dout1_7 vdout1_7ck115 = 3.3 time = 1160
* CHECK dout1_8 vdout1_8ck115 = 3.3 time = 1160
* CHECK dout1_9 vdout1_9ck115 = 3.3 time = 1160
* CHECK dout1_10 vdout1_10ck115 = 0 time = 1160
* CHECK dout1_11 vdout1_11ck115 = 3.3 time = 1160
* CHECK dout1_12 vdout1_12ck115 = 3.3 time = 1160
* CHECK dout1_13 vdout1_13ck115 = 3.3 time = 1160
* CHECK dout1_14 vdout1_14ck115 = 0 time = 1160
* CHECK dout1_15 vdout1_15ck115 = 0 time = 1160
* CHECK dout1_16 vdout1_16ck115 = 3.3 time = 1160
* CHECK dout1_17 vdout1_17ck115 = 3.3 time = 1160
* CHECK dout1_18 vdout1_18ck115 = 3.3 time = 1160
* CHECK dout1_19 vdout1_19ck115 = 3.3 time = 1160
* CHECK dout1_20 vdout1_20ck115 = 3.3 time = 1160
* CHECK dout1_21 vdout1_21ck115 = 3.3 time = 1160
* CHECK dout1_22 vdout1_22ck115 = 3.3 time = 1160
* CHECK dout1_23 vdout1_23ck115 = 0 time = 1160
* CHECK dout1_24 vdout1_24ck115 = 0 time = 1160
* CHECK dout1_25 vdout1_25ck115 = 3.3 time = 1160
* CHECK dout1_26 vdout1_26ck115 = 0 time = 1160
* CHECK dout1_27 vdout1_27ck115 = 3.3 time = 1160
* CHECK dout1_28 vdout1_28ck115 = 0 time = 1160
* CHECK dout1_29 vdout1_29ck115 = 3.3 time = 1160
* CHECK dout1_30 vdout1_30ck115 = 0 time = 1160
* CHECK dout1_31 vdout1_31ck115 = 0 time = 1160
* CHECK dout0_0 vdout0_0ck116 = 3.3 time = 1170
* CHECK dout0_1 vdout0_1ck116 = 3.3 time = 1170
* CHECK dout0_2 vdout0_2ck116 = 3.3 time = 1170
* CHECK dout0_3 vdout0_3ck116 = 0 time = 1170
* CHECK dout0_4 vdout0_4ck116 = 3.3 time = 1170
* CHECK dout0_5 vdout0_5ck116 = 3.3 time = 1170
* CHECK dout0_6 vdout0_6ck116 = 3.3 time = 1170
* CHECK dout0_7 vdout0_7ck116 = 3.3 time = 1170
* CHECK dout0_8 vdout0_8ck116 = 3.3 time = 1170
* CHECK dout0_9 vdout0_9ck116 = 3.3 time = 1170
* CHECK dout0_10 vdout0_10ck116 = 0 time = 1170
* CHECK dout0_11 vdout0_11ck116 = 3.3 time = 1170
* CHECK dout0_12 vdout0_12ck116 = 3.3 time = 1170
* CHECK dout0_13 vdout0_13ck116 = 3.3 time = 1170
* CHECK dout0_14 vdout0_14ck116 = 0 time = 1170
* CHECK dout0_15 vdout0_15ck116 = 0 time = 1170
* CHECK dout0_16 vdout0_16ck116 = 3.3 time = 1170
* CHECK dout0_17 vdout0_17ck116 = 3.3 time = 1170
* CHECK dout0_18 vdout0_18ck116 = 3.3 time = 1170
* CHECK dout0_19 vdout0_19ck116 = 3.3 time = 1170
* CHECK dout0_20 vdout0_20ck116 = 3.3 time = 1170
* CHECK dout0_21 vdout0_21ck116 = 3.3 time = 1170
* CHECK dout0_22 vdout0_22ck116 = 3.3 time = 1170
* CHECK dout0_23 vdout0_23ck116 = 0 time = 1170
* CHECK dout0_24 vdout0_24ck116 = 0 time = 1170
* CHECK dout0_25 vdout0_25ck116 = 3.3 time = 1170
* CHECK dout0_26 vdout0_26ck116 = 0 time = 1170
* CHECK dout0_27 vdout0_27ck116 = 3.3 time = 1170
* CHECK dout0_28 vdout0_28ck116 = 0 time = 1170
* CHECK dout0_29 vdout0_29ck116 = 3.3 time = 1170
* CHECK dout0_30 vdout0_30ck116 = 0 time = 1170
* CHECK dout0_31 vdout0_31ck116 = 0 time = 1170
* CHECK dout0_0 vdout0_0ck117 = 0 time = 1180
* CHECK dout0_1 vdout0_1ck117 = 0 time = 1180
* CHECK dout0_2 vdout0_2ck117 = 0 time = 1180
* CHECK dout0_3 vdout0_3ck117 = 3.3 time = 1180
* CHECK dout0_4 vdout0_4ck117 = 0 time = 1180
* CHECK dout0_5 vdout0_5ck117 = 0 time = 1180
* CHECK dout0_6 vdout0_6ck117 = 0 time = 1180
* CHECK dout0_7 vdout0_7ck117 = 3.3 time = 1180
* CHECK dout0_8 vdout0_8ck117 = 3.3 time = 1180
* CHECK dout0_9 vdout0_9ck117 = 0 time = 1180
* CHECK dout0_10 vdout0_10ck117 = 0 time = 1180
* CHECK dout0_11 vdout0_11ck117 = 0 time = 1180
* CHECK dout0_12 vdout0_12ck117 = 3.3 time = 1180
* CHECK dout0_13 vdout0_13ck117 = 3.3 time = 1180
* CHECK dout0_14 vdout0_14ck117 = 0 time = 1180
* CHECK dout0_15 vdout0_15ck117 = 3.3 time = 1180
* CHECK dout0_16 vdout0_16ck117 = 0 time = 1180
* CHECK dout0_17 vdout0_17ck117 = 0 time = 1180
* CHECK dout0_18 vdout0_18ck117 = 0 time = 1180
* CHECK dout0_19 vdout0_19ck117 = 0 time = 1180
* CHECK dout0_20 vdout0_20ck117 = 0 time = 1180
* CHECK dout0_21 vdout0_21ck117 = 0 time = 1180
* CHECK dout0_22 vdout0_22ck117 = 3.3 time = 1180
* CHECK dout0_23 vdout0_23ck117 = 3.3 time = 1180
* CHECK dout0_24 vdout0_24ck117 = 0 time = 1180
* CHECK dout0_25 vdout0_25ck117 = 0 time = 1180
* CHECK dout0_26 vdout0_26ck117 = 0 time = 1180
* CHECK dout0_27 vdout0_27ck117 = 0 time = 1180
* CHECK dout0_28 vdout0_28ck117 = 0 time = 1180
* CHECK dout0_29 vdout0_29ck117 = 0 time = 1180
* CHECK dout0_30 vdout0_30ck117 = 3.3 time = 1180
* CHECK dout0_31 vdout0_31ck117 = 3.3 time = 1180
* CHECK dout1_0 vdout1_0ck117 = 0 time = 1180
* CHECK dout1_1 vdout1_1ck117 = 0 time = 1180
* CHECK dout1_2 vdout1_2ck117 = 0 time = 1180
* CHECK dout1_3 vdout1_3ck117 = 3.3 time = 1180
* CHECK dout1_4 vdout1_4ck117 = 0 time = 1180
* CHECK dout1_5 vdout1_5ck117 = 0 time = 1180
* CHECK dout1_6 vdout1_6ck117 = 0 time = 1180
* CHECK dout1_7 vdout1_7ck117 = 3.3 time = 1180
* CHECK dout1_8 vdout1_8ck117 = 3.3 time = 1180
* CHECK dout1_9 vdout1_9ck117 = 0 time = 1180
* CHECK dout1_10 vdout1_10ck117 = 0 time = 1180
* CHECK dout1_11 vdout1_11ck117 = 0 time = 1180
* CHECK dout1_12 vdout1_12ck117 = 3.3 time = 1180
* CHECK dout1_13 vdout1_13ck117 = 3.3 time = 1180
* CHECK dout1_14 vdout1_14ck117 = 0 time = 1180
* CHECK dout1_15 vdout1_15ck117 = 3.3 time = 1180
* CHECK dout1_16 vdout1_16ck117 = 0 time = 1180
* CHECK dout1_17 vdout1_17ck117 = 0 time = 1180
* CHECK dout1_18 vdout1_18ck117 = 0 time = 1180
* CHECK dout1_19 vdout1_19ck117 = 0 time = 1180
* CHECK dout1_20 vdout1_20ck117 = 0 time = 1180
* CHECK dout1_21 vdout1_21ck117 = 0 time = 1180
* CHECK dout1_22 vdout1_22ck117 = 3.3 time = 1180
* CHECK dout1_23 vdout1_23ck117 = 3.3 time = 1180
* CHECK dout1_24 vdout1_24ck117 = 0 time = 1180
* CHECK dout1_25 vdout1_25ck117 = 0 time = 1180
* CHECK dout1_26 vdout1_26ck117 = 0 time = 1180
* CHECK dout1_27 vdout1_27ck117 = 0 time = 1180
* CHECK dout1_28 vdout1_28ck117 = 0 time = 1180
* CHECK dout1_29 vdout1_29ck117 = 0 time = 1180
* CHECK dout1_30 vdout1_30ck117 = 3.3 time = 1180
* CHECK dout1_31 vdout1_31ck117 = 3.3 time = 1180
* CHECK dout0_0 vdout0_0ck118 = 0 time = 1190
* CHECK dout0_1 vdout0_1ck118 = 0 time = 1190
* CHECK dout0_2 vdout0_2ck118 = 0 time = 1190
* CHECK dout0_3 vdout0_3ck118 = 3.3 time = 1190
* CHECK dout0_4 vdout0_4ck118 = 0 time = 1190
* CHECK dout0_5 vdout0_5ck118 = 0 time = 1190
* CHECK dout0_6 vdout0_6ck118 = 0 time = 1190
* CHECK dout0_7 vdout0_7ck118 = 3.3 time = 1190
* CHECK dout0_8 vdout0_8ck118 = 3.3 time = 1190
* CHECK dout0_9 vdout0_9ck118 = 0 time = 1190
* CHECK dout0_10 vdout0_10ck118 = 0 time = 1190
* CHECK dout0_11 vdout0_11ck118 = 0 time = 1190
* CHECK dout0_12 vdout0_12ck118 = 3.3 time = 1190
* CHECK dout0_13 vdout0_13ck118 = 3.3 time = 1190
* CHECK dout0_14 vdout0_14ck118 = 0 time = 1190
* CHECK dout0_15 vdout0_15ck118 = 3.3 time = 1190
* CHECK dout0_16 vdout0_16ck118 = 0 time = 1190
* CHECK dout0_17 vdout0_17ck118 = 0 time = 1190
* CHECK dout0_18 vdout0_18ck118 = 0 time = 1190
* CHECK dout0_19 vdout0_19ck118 = 0 time = 1190
* CHECK dout0_20 vdout0_20ck118 = 0 time = 1190
* CHECK dout0_21 vdout0_21ck118 = 0 time = 1190
* CHECK dout0_22 vdout0_22ck118 = 3.3 time = 1190
* CHECK dout0_23 vdout0_23ck118 = 3.3 time = 1190
* CHECK dout0_24 vdout0_24ck118 = 0 time = 1190
* CHECK dout0_25 vdout0_25ck118 = 0 time = 1190
* CHECK dout0_26 vdout0_26ck118 = 0 time = 1190
* CHECK dout0_27 vdout0_27ck118 = 0 time = 1190
* CHECK dout0_28 vdout0_28ck118 = 0 time = 1190
* CHECK dout0_29 vdout0_29ck118 = 0 time = 1190
* CHECK dout0_30 vdout0_30ck118 = 3.3 time = 1190
* CHECK dout0_31 vdout0_31ck118 = 3.3 time = 1190
* CHECK dout1_0 vdout1_0ck119 = 3.3 time = 1200
* CHECK dout1_1 vdout1_1ck119 = 3.3 time = 1200
* CHECK dout1_2 vdout1_2ck119 = 3.3 time = 1200
* CHECK dout1_3 vdout1_3ck119 = 0 time = 1200
* CHECK dout1_4 vdout1_4ck119 = 3.3 time = 1200
* CHECK dout1_5 vdout1_5ck119 = 3.3 time = 1200
* CHECK dout1_6 vdout1_6ck119 = 3.3 time = 1200
* CHECK dout1_7 vdout1_7ck119 = 3.3 time = 1200
* CHECK dout1_8 vdout1_8ck119 = 3.3 time = 1200
* CHECK dout1_9 vdout1_9ck119 = 3.3 time = 1200
* CHECK dout1_10 vdout1_10ck119 = 0 time = 1200
* CHECK dout1_11 vdout1_11ck119 = 3.3 time = 1200
* CHECK dout1_12 vdout1_12ck119 = 3.3 time = 1200
* CHECK dout1_13 vdout1_13ck119 = 3.3 time = 1200
* CHECK dout1_14 vdout1_14ck119 = 0 time = 1200
* CHECK dout1_15 vdout1_15ck119 = 0 time = 1200
* CHECK dout1_16 vdout1_16ck119 = 3.3 time = 1200
* CHECK dout1_17 vdout1_17ck119 = 3.3 time = 1200
* CHECK dout1_18 vdout1_18ck119 = 3.3 time = 1200
* CHECK dout1_19 vdout1_19ck119 = 3.3 time = 1200
* CHECK dout1_20 vdout1_20ck119 = 3.3 time = 1200
* CHECK dout1_21 vdout1_21ck119 = 3.3 time = 1200
* CHECK dout1_22 vdout1_22ck119 = 3.3 time = 1200
* CHECK dout1_23 vdout1_23ck119 = 0 time = 1200
* CHECK dout1_24 vdout1_24ck119 = 0 time = 1200
* CHECK dout1_25 vdout1_25ck119 = 3.3 time = 1200
* CHECK dout1_26 vdout1_26ck119 = 0 time = 1200
* CHECK dout1_27 vdout1_27ck119 = 3.3 time = 1200
* CHECK dout1_28 vdout1_28ck119 = 0 time = 1200
* CHECK dout1_29 vdout1_29ck119 = 3.3 time = 1200
* CHECK dout1_30 vdout1_30ck119 = 0 time = 1200
* CHECK dout1_31 vdout1_31ck119 = 0 time = 1200
* CHECK dout0_0 vdout0_0ck120 = 0 time = 1210
* CHECK dout0_1 vdout0_1ck120 = 0 time = 1210
* CHECK dout0_2 vdout0_2ck120 = 0 time = 1210
* CHECK dout0_3 vdout0_3ck120 = 3.3 time = 1210
* CHECK dout0_4 vdout0_4ck120 = 0 time = 1210
* CHECK dout0_5 vdout0_5ck120 = 0 time = 1210
* CHECK dout0_6 vdout0_6ck120 = 0 time = 1210
* CHECK dout0_7 vdout0_7ck120 = 3.3 time = 1210
* CHECK dout0_8 vdout0_8ck120 = 3.3 time = 1210
* CHECK dout0_9 vdout0_9ck120 = 0 time = 1210
* CHECK dout0_10 vdout0_10ck120 = 0 time = 1210
* CHECK dout0_11 vdout0_11ck120 = 0 time = 1210
* CHECK dout0_12 vdout0_12ck120 = 3.3 time = 1210
* CHECK dout0_13 vdout0_13ck120 = 3.3 time = 1210
* CHECK dout0_14 vdout0_14ck120 = 0 time = 1210
* CHECK dout0_15 vdout0_15ck120 = 3.3 time = 1210
* CHECK dout0_16 vdout0_16ck120 = 0 time = 1210
* CHECK dout0_17 vdout0_17ck120 = 0 time = 1210
* CHECK dout0_18 vdout0_18ck120 = 0 time = 1210
* CHECK dout0_19 vdout0_19ck120 = 0 time = 1210
* CHECK dout0_20 vdout0_20ck120 = 0 time = 1210
* CHECK dout0_21 vdout0_21ck120 = 0 time = 1210
* CHECK dout0_22 vdout0_22ck120 = 3.3 time = 1210
* CHECK dout0_23 vdout0_23ck120 = 3.3 time = 1210
* CHECK dout0_24 vdout0_24ck120 = 0 time = 1210
* CHECK dout0_25 vdout0_25ck120 = 0 time = 1210
* CHECK dout0_26 vdout0_26ck120 = 0 time = 1210
* CHECK dout0_27 vdout0_27ck120 = 0 time = 1210
* CHECK dout0_28 vdout0_28ck120 = 0 time = 1210
* CHECK dout0_29 vdout0_29ck120 = 0 time = 1210
* CHECK dout0_30 vdout0_30ck120 = 3.3 time = 1210
* CHECK dout0_31 vdout0_31ck120 = 3.3 time = 1210
* CHECK dout1_0 vdout1_0ck120 = 0 time = 1210
* CHECK dout1_1 vdout1_1ck120 = 0 time = 1210
* CHECK dout1_2 vdout1_2ck120 = 0 time = 1210
* CHECK dout1_3 vdout1_3ck120 = 3.3 time = 1210
* CHECK dout1_4 vdout1_4ck120 = 0 time = 1210
* CHECK dout1_5 vdout1_5ck120 = 0 time = 1210
* CHECK dout1_6 vdout1_6ck120 = 0 time = 1210
* CHECK dout1_7 vdout1_7ck120 = 3.3 time = 1210
* CHECK dout1_8 vdout1_8ck120 = 3.3 time = 1210
* CHECK dout1_9 vdout1_9ck120 = 0 time = 1210
* CHECK dout1_10 vdout1_10ck120 = 0 time = 1210
* CHECK dout1_11 vdout1_11ck120 = 0 time = 1210
* CHECK dout1_12 vdout1_12ck120 = 3.3 time = 1210
* CHECK dout1_13 vdout1_13ck120 = 3.3 time = 1210
* CHECK dout1_14 vdout1_14ck120 = 0 time = 1210
* CHECK dout1_15 vdout1_15ck120 = 3.3 time = 1210
* CHECK dout1_16 vdout1_16ck120 = 0 time = 1210
* CHECK dout1_17 vdout1_17ck120 = 0 time = 1210
* CHECK dout1_18 vdout1_18ck120 = 0 time = 1210
* CHECK dout1_19 vdout1_19ck120 = 0 time = 1210
* CHECK dout1_20 vdout1_20ck120 = 0 time = 1210
* CHECK dout1_21 vdout1_21ck120 = 0 time = 1210
* CHECK dout1_22 vdout1_22ck120 = 3.3 time = 1210
* CHECK dout1_23 vdout1_23ck120 = 3.3 time = 1210
* CHECK dout1_24 vdout1_24ck120 = 0 time = 1210
* CHECK dout1_25 vdout1_25ck120 = 0 time = 1210
* CHECK dout1_26 vdout1_26ck120 = 0 time = 1210
* CHECK dout1_27 vdout1_27ck120 = 0 time = 1210
* CHECK dout1_28 vdout1_28ck120 = 0 time = 1210
* CHECK dout1_29 vdout1_29ck120 = 0 time = 1210
* CHECK dout1_30 vdout1_30ck120 = 3.3 time = 1210
* CHECK dout1_31 vdout1_31ck120 = 3.3 time = 1210
* CHECK dout0_0 vdout0_0ck121 = 0 time = 1220
* CHECK dout0_1 vdout0_1ck121 = 0 time = 1220
* CHECK dout0_2 vdout0_2ck121 = 0 time = 1220
* CHECK dout0_3 vdout0_3ck121 = 3.3 time = 1220
* CHECK dout0_4 vdout0_4ck121 = 0 time = 1220
* CHECK dout0_5 vdout0_5ck121 = 0 time = 1220
* CHECK dout0_6 vdout0_6ck121 = 0 time = 1220
* CHECK dout0_7 vdout0_7ck121 = 3.3 time = 1220
* CHECK dout0_8 vdout0_8ck121 = 3.3 time = 1220
* CHECK dout0_9 vdout0_9ck121 = 0 time = 1220
* CHECK dout0_10 vdout0_10ck121 = 0 time = 1220
* CHECK dout0_11 vdout0_11ck121 = 0 time = 1220
* CHECK dout0_12 vdout0_12ck121 = 3.3 time = 1220
* CHECK dout0_13 vdout0_13ck121 = 3.3 time = 1220
* CHECK dout0_14 vdout0_14ck121 = 0 time = 1220
* CHECK dout0_15 vdout0_15ck121 = 3.3 time = 1220
* CHECK dout0_16 vdout0_16ck121 = 0 time = 1220
* CHECK dout0_17 vdout0_17ck121 = 0 time = 1220
* CHECK dout0_18 vdout0_18ck121 = 0 time = 1220
* CHECK dout0_19 vdout0_19ck121 = 0 time = 1220
* CHECK dout0_20 vdout0_20ck121 = 0 time = 1220
* CHECK dout0_21 vdout0_21ck121 = 0 time = 1220
* CHECK dout0_22 vdout0_22ck121 = 3.3 time = 1220
* CHECK dout0_23 vdout0_23ck121 = 3.3 time = 1220
* CHECK dout0_24 vdout0_24ck121 = 0 time = 1220
* CHECK dout0_25 vdout0_25ck121 = 0 time = 1220
* CHECK dout0_26 vdout0_26ck121 = 0 time = 1220
* CHECK dout0_27 vdout0_27ck121 = 0 time = 1220
* CHECK dout0_28 vdout0_28ck121 = 0 time = 1220
* CHECK dout0_29 vdout0_29ck121 = 0 time = 1220
* CHECK dout0_30 vdout0_30ck121 = 3.3 time = 1220
* CHECK dout0_31 vdout0_31ck121 = 3.3 time = 1220
* CHECK dout0_0 vdout0_0ck122 = 3.3 time = 1230
* CHECK dout0_1 vdout0_1ck122 = 3.3 time = 1230
* CHECK dout0_2 vdout0_2ck122 = 0 time = 1230
* CHECK dout0_3 vdout0_3ck122 = 3.3 time = 1230
* CHECK dout0_4 vdout0_4ck122 = 3.3 time = 1230
* CHECK dout0_5 vdout0_5ck122 = 3.3 time = 1230
* CHECK dout0_6 vdout0_6ck122 = 0 time = 1230
* CHECK dout0_7 vdout0_7ck122 = 0 time = 1230
* CHECK dout0_8 vdout0_8ck122 = 0 time = 1230
* CHECK dout0_9 vdout0_9ck122 = 3.3 time = 1230
* CHECK dout0_10 vdout0_10ck122 = 0 time = 1230
* CHECK dout0_11 vdout0_11ck122 = 0 time = 1230
* CHECK dout0_12 vdout0_12ck122 = 0 time = 1230
* CHECK dout0_13 vdout0_13ck122 = 3.3 time = 1230
* CHECK dout0_14 vdout0_14ck122 = 3.3 time = 1230
* CHECK dout0_15 vdout0_15ck122 = 0 time = 1230
* CHECK dout0_16 vdout0_16ck122 = 0 time = 1230
* CHECK dout0_17 vdout0_17ck122 = 0 time = 1230
* CHECK dout0_18 vdout0_18ck122 = 0 time = 1230
* CHECK dout0_19 vdout0_19ck122 = 0 time = 1230
* CHECK dout0_20 vdout0_20ck122 = 0 time = 1230
* CHECK dout0_21 vdout0_21ck122 = 0 time = 1230
* CHECK dout0_22 vdout0_22ck122 = 3.3 time = 1230
* CHECK dout0_23 vdout0_23ck122 = 3.3 time = 1230
* CHECK dout0_24 vdout0_24ck122 = 3.3 time = 1230
* CHECK dout0_25 vdout0_25ck122 = 3.3 time = 1230
* CHECK dout0_26 vdout0_26ck122 = 0 time = 1230
* CHECK dout0_27 vdout0_27ck122 = 3.3 time = 1230
* CHECK dout0_28 vdout0_28ck122 = 3.3 time = 1230
* CHECK dout0_29 vdout0_29ck122 = 3.3 time = 1230
* CHECK dout0_30 vdout0_30ck122 = 3.3 time = 1230
* CHECK dout0_31 vdout0_31ck122 = 3.3 time = 1230
* CHECK dout1_0 vdout1_0ck122 = 3.3 time = 1230
* CHECK dout1_1 vdout1_1ck122 = 3.3 time = 1230
* CHECK dout1_2 vdout1_2ck122 = 0 time = 1230
* CHECK dout1_3 vdout1_3ck122 = 3.3 time = 1230
* CHECK dout1_4 vdout1_4ck122 = 3.3 time = 1230
* CHECK dout1_5 vdout1_5ck122 = 3.3 time = 1230
* CHECK dout1_6 vdout1_6ck122 = 0 time = 1230
* CHECK dout1_7 vdout1_7ck122 = 0 time = 1230
* CHECK dout1_8 vdout1_8ck122 = 0 time = 1230
* CHECK dout1_9 vdout1_9ck122 = 3.3 time = 1230
* CHECK dout1_10 vdout1_10ck122 = 0 time = 1230
* CHECK dout1_11 vdout1_11ck122 = 0 time = 1230
* CHECK dout1_12 vdout1_12ck122 = 0 time = 1230
* CHECK dout1_13 vdout1_13ck122 = 3.3 time = 1230
* CHECK dout1_14 vdout1_14ck122 = 3.3 time = 1230
* CHECK dout1_15 vdout1_15ck122 = 0 time = 1230
* CHECK dout1_16 vdout1_16ck122 = 0 time = 1230
* CHECK dout1_17 vdout1_17ck122 = 0 time = 1230
* CHECK dout1_18 vdout1_18ck122 = 0 time = 1230
* CHECK dout1_19 vdout1_19ck122 = 0 time = 1230
* CHECK dout1_20 vdout1_20ck122 = 0 time = 1230
* CHECK dout1_21 vdout1_21ck122 = 0 time = 1230
* CHECK dout1_22 vdout1_22ck122 = 3.3 time = 1230
* CHECK dout1_23 vdout1_23ck122 = 3.3 time = 1230
* CHECK dout1_24 vdout1_24ck122 = 3.3 time = 1230
* CHECK dout1_25 vdout1_25ck122 = 3.3 time = 1230
* CHECK dout1_26 vdout1_26ck122 = 0 time = 1230
* CHECK dout1_27 vdout1_27ck122 = 3.3 time = 1230
* CHECK dout1_28 vdout1_28ck122 = 3.3 time = 1230
* CHECK dout1_29 vdout1_29ck122 = 3.3 time = 1230
* CHECK dout1_30 vdout1_30ck122 = 3.3 time = 1230
* CHECK dout1_31 vdout1_31ck122 = 3.3 time = 1230
* CHECK dout0_0 vdout0_0ck123 = 3.3 time = 1240
* CHECK dout0_1 vdout0_1ck123 = 3.3 time = 1240
* CHECK dout0_2 vdout0_2ck123 = 3.3 time = 1240
* CHECK dout0_3 vdout0_3ck123 = 0 time = 1240
* CHECK dout0_4 vdout0_4ck123 = 3.3 time = 1240
* CHECK dout0_5 vdout0_5ck123 = 3.3 time = 1240
* CHECK dout0_6 vdout0_6ck123 = 3.3 time = 1240
* CHECK dout0_7 vdout0_7ck123 = 3.3 time = 1240
* CHECK dout0_8 vdout0_8ck123 = 3.3 time = 1240
* CHECK dout0_9 vdout0_9ck123 = 3.3 time = 1240
* CHECK dout0_10 vdout0_10ck123 = 0 time = 1240
* CHECK dout0_11 vdout0_11ck123 = 3.3 time = 1240
* CHECK dout0_12 vdout0_12ck123 = 3.3 time = 1240
* CHECK dout0_13 vdout0_13ck123 = 3.3 time = 1240
* CHECK dout0_14 vdout0_14ck123 = 0 time = 1240
* CHECK dout0_15 vdout0_15ck123 = 0 time = 1240
* CHECK dout0_16 vdout0_16ck123 = 3.3 time = 1240
* CHECK dout0_17 vdout0_17ck123 = 3.3 time = 1240
* CHECK dout0_18 vdout0_18ck123 = 3.3 time = 1240
* CHECK dout0_19 vdout0_19ck123 = 3.3 time = 1240
* CHECK dout0_20 vdout0_20ck123 = 3.3 time = 1240
* CHECK dout0_21 vdout0_21ck123 = 3.3 time = 1240
* CHECK dout0_22 vdout0_22ck123 = 3.3 time = 1240
* CHECK dout0_23 vdout0_23ck123 = 0 time = 1240
* CHECK dout0_24 vdout0_24ck123 = 0 time = 1240
* CHECK dout0_25 vdout0_25ck123 = 3.3 time = 1240
* CHECK dout0_26 vdout0_26ck123 = 0 time = 1240
* CHECK dout0_27 vdout0_27ck123 = 3.3 time = 1240
* CHECK dout0_28 vdout0_28ck123 = 0 time = 1240
* CHECK dout0_29 vdout0_29ck123 = 3.3 time = 1240
* CHECK dout0_30 vdout0_30ck123 = 0 time = 1240
* CHECK dout0_31 vdout0_31ck123 = 0 time = 1240
* CHECK dout0_0 vdout0_0ck125 = 3.3 time = 1260
* CHECK dout0_1 vdout0_1ck125 = 0 time = 1260
* CHECK dout0_2 vdout0_2ck125 = 0 time = 1260
* CHECK dout0_3 vdout0_3ck125 = 0 time = 1260
* CHECK dout0_4 vdout0_4ck125 = 3.3 time = 1260
* CHECK dout0_5 vdout0_5ck125 = 0 time = 1260
* CHECK dout0_6 vdout0_6ck125 = 3.3 time = 1260
* CHECK dout0_7 vdout0_7ck125 = 0 time = 1260
* CHECK dout0_8 vdout0_8ck125 = 0 time = 1260
* CHECK dout0_9 vdout0_9ck125 = 3.3 time = 1260
* CHECK dout0_10 vdout0_10ck125 = 0 time = 1260
* CHECK dout0_11 vdout0_11ck125 = 3.3 time = 1260
* CHECK dout0_12 vdout0_12ck125 = 3.3 time = 1260
* CHECK dout0_13 vdout0_13ck125 = 0 time = 1260
* CHECK dout0_14 vdout0_14ck125 = 0 time = 1260
* CHECK dout0_15 vdout0_15ck125 = 3.3 time = 1260
* CHECK dout0_16 vdout0_16ck125 = 0 time = 1260
* CHECK dout0_17 vdout0_17ck125 = 3.3 time = 1260
* CHECK dout0_18 vdout0_18ck125 = 0 time = 1260
* CHECK dout0_19 vdout0_19ck125 = 0 time = 1260
* CHECK dout0_20 vdout0_20ck125 = 0 time = 1260
* CHECK dout0_21 vdout0_21ck125 = 0 time = 1260
* CHECK dout0_22 vdout0_22ck125 = 3.3 time = 1260
* CHECK dout0_23 vdout0_23ck125 = 3.3 time = 1260
* CHECK dout0_24 vdout0_24ck125 = 0 time = 1260
* CHECK dout0_25 vdout0_25ck125 = 3.3 time = 1260
* CHECK dout0_26 vdout0_26ck125 = 3.3 time = 1260
* CHECK dout0_27 vdout0_27ck125 = 3.3 time = 1260
* CHECK dout0_28 vdout0_28ck125 = 0 time = 1260
* CHECK dout0_29 vdout0_29ck125 = 3.3 time = 1260
* CHECK dout0_30 vdout0_30ck125 = 0 time = 1260
* CHECK dout0_31 vdout0_31ck125 = 0 time = 1260
* CHECK dout1_0 vdout1_0ck127 = 3.3 time = 1280
* CHECK dout1_1 vdout1_1ck127 = 3.3 time = 1280
* CHECK dout1_2 vdout1_2ck127 = 0 time = 1280
* CHECK dout1_3 vdout1_3ck127 = 3.3 time = 1280
* CHECK dout1_4 vdout1_4ck127 = 3.3 time = 1280
* CHECK dout1_5 vdout1_5ck127 = 0 time = 1280
* CHECK dout1_6 vdout1_6ck127 = 3.3 time = 1280
* CHECK dout1_7 vdout1_7ck127 = 3.3 time = 1280
* CHECK dout1_8 vdout1_8ck127 = 0 time = 1280
* CHECK dout1_9 vdout1_9ck127 = 3.3 time = 1280
* CHECK dout1_10 vdout1_10ck127 = 3.3 time = 1280
* CHECK dout1_11 vdout1_11ck127 = 3.3 time = 1280
* CHECK dout1_12 vdout1_12ck127 = 3.3 time = 1280
* CHECK dout1_13 vdout1_13ck127 = 3.3 time = 1280
* CHECK dout1_14 vdout1_14ck127 = 3.3 time = 1280
* CHECK dout1_15 vdout1_15ck127 = 3.3 time = 1280
* CHECK dout1_16 vdout1_16ck127 = 0 time = 1280
* CHECK dout1_17 vdout1_17ck127 = 3.3 time = 1280
* CHECK dout1_18 vdout1_18ck127 = 0 time = 1280
* CHECK dout1_19 vdout1_19ck127 = 3.3 time = 1280
* CHECK dout1_20 vdout1_20ck127 = 0 time = 1280
* CHECK dout1_21 vdout1_21ck127 = 3.3 time = 1280
* CHECK dout1_22 vdout1_22ck127 = 0 time = 1280
* CHECK dout1_23 vdout1_23ck127 = 0 time = 1280
* CHECK dout1_24 vdout1_24ck127 = 3.3 time = 1280
* CHECK dout1_25 vdout1_25ck127 = 0 time = 1280
* CHECK dout1_26 vdout1_26ck127 = 0 time = 1280
* CHECK dout1_27 vdout1_27ck127 = 3.3 time = 1280
* CHECK dout1_28 vdout1_28ck127 = 0 time = 1280
* CHECK dout1_29 vdout1_29ck127 = 3.3 time = 1280
* CHECK dout1_30 vdout1_30ck127 = 3.3 time = 1280
* CHECK dout1_31 vdout1_31ck127 = 3.3 time = 1280
* CHECK dout0_0 vdout0_0ck130 = 3.3 time = 1310
* CHECK dout0_1 vdout0_1ck130 = 3.3 time = 1310
* CHECK dout0_2 vdout0_2ck130 = 0 time = 1310
* CHECK dout0_3 vdout0_3ck130 = 3.3 time = 1310
* CHECK dout0_4 vdout0_4ck130 = 0 time = 1310
* CHECK dout0_5 vdout0_5ck130 = 3.3 time = 1310
* CHECK dout0_6 vdout0_6ck130 = 0 time = 1310
* CHECK dout0_7 vdout0_7ck130 = 3.3 time = 1310
* CHECK dout0_8 vdout0_8ck130 = 0 time = 1310
* CHECK dout0_9 vdout0_9ck130 = 0 time = 1310
* CHECK dout0_10 vdout0_10ck130 = 0 time = 1310
* CHECK dout0_11 vdout0_11ck130 = 0 time = 1310
* CHECK dout0_12 vdout0_12ck130 = 3.3 time = 1310
* CHECK dout0_13 vdout0_13ck130 = 0 time = 1310
* CHECK dout0_14 vdout0_14ck130 = 3.3 time = 1310
* CHECK dout0_15 vdout0_15ck130 = 0 time = 1310
* CHECK dout0_16 vdout0_16ck130 = 0 time = 1310
* CHECK dout0_17 vdout0_17ck130 = 3.3 time = 1310
* CHECK dout0_18 vdout0_18ck130 = 0 time = 1310
* CHECK dout0_19 vdout0_19ck130 = 3.3 time = 1310
* CHECK dout0_20 vdout0_20ck130 = 0 time = 1310
* CHECK dout0_21 vdout0_21ck130 = 0 time = 1310
* CHECK dout0_22 vdout0_22ck130 = 0 time = 1310
* CHECK dout0_23 vdout0_23ck130 = 3.3 time = 1310
* CHECK dout0_24 vdout0_24ck130 = 3.3 time = 1310
* CHECK dout0_25 vdout0_25ck130 = 3.3 time = 1310
* CHECK dout0_26 vdout0_26ck130 = 3.3 time = 1310
* CHECK dout0_27 vdout0_27ck130 = 3.3 time = 1310
* CHECK dout0_28 vdout0_28ck130 = 0 time = 1310
* CHECK dout0_29 vdout0_29ck130 = 0 time = 1310
* CHECK dout0_30 vdout0_30ck130 = 3.3 time = 1310
* CHECK dout0_31 vdout0_31ck130 = 3.3 time = 1310
* CHECK dout1_0 vdout1_0ck130 = 3.3 time = 1310
* CHECK dout1_1 vdout1_1ck130 = 3.3 time = 1310
* CHECK dout1_2 vdout1_2ck130 = 3.3 time = 1310
* CHECK dout1_3 vdout1_3ck130 = 0 time = 1310
* CHECK dout1_4 vdout1_4ck130 = 0 time = 1310
* CHECK dout1_5 vdout1_5ck130 = 3.3 time = 1310
* CHECK dout1_6 vdout1_6ck130 = 3.3 time = 1310
* CHECK dout1_7 vdout1_7ck130 = 3.3 time = 1310
* CHECK dout1_8 vdout1_8ck130 = 0 time = 1310
* CHECK dout1_9 vdout1_9ck130 = 3.3 time = 1310
* CHECK dout1_10 vdout1_10ck130 = 0 time = 1310
* CHECK dout1_11 vdout1_11ck130 = 0 time = 1310
* CHECK dout1_12 vdout1_12ck130 = 0 time = 1310
* CHECK dout1_13 vdout1_13ck130 = 3.3 time = 1310
* CHECK dout1_14 vdout1_14ck130 = 0 time = 1310
* CHECK dout1_15 vdout1_15ck130 = 0 time = 1310
* CHECK dout1_16 vdout1_16ck130 = 0 time = 1310
* CHECK dout1_17 vdout1_17ck130 = 0 time = 1310
* CHECK dout1_18 vdout1_18ck130 = 0 time = 1310
* CHECK dout1_19 vdout1_19ck130 = 3.3 time = 1310
* CHECK dout1_20 vdout1_20ck130 = 3.3 time = 1310
* CHECK dout1_21 vdout1_21ck130 = 3.3 time = 1310
* CHECK dout1_22 vdout1_22ck130 = 0 time = 1310
* CHECK dout1_23 vdout1_23ck130 = 0 time = 1310
* CHECK dout1_24 vdout1_24ck130 = 3.3 time = 1310
* CHECK dout1_25 vdout1_25ck130 = 0 time = 1310
* CHECK dout1_26 vdout1_26ck130 = 3.3 time = 1310
* CHECK dout1_27 vdout1_27ck130 = 0 time = 1310
* CHECK dout1_28 vdout1_28ck130 = 3.3 time = 1310
* CHECK dout1_29 vdout1_29ck130 = 0 time = 1310
* CHECK dout1_30 vdout1_30ck130 = 0 time = 1310
* CHECK dout1_31 vdout1_31ck130 = 3.3 time = 1310
* CHECK dout0_0 vdout0_0ck131 = 3.3 time = 1320
* CHECK dout0_1 vdout0_1ck131 = 3.3 time = 1320
* CHECK dout0_2 vdout0_2ck131 = 0 time = 1320
* CHECK dout0_3 vdout0_3ck131 = 3.3 time = 1320
* CHECK dout0_4 vdout0_4ck131 = 0 time = 1320
* CHECK dout0_5 vdout0_5ck131 = 3.3 time = 1320
* CHECK dout0_6 vdout0_6ck131 = 0 time = 1320
* CHECK dout0_7 vdout0_7ck131 = 3.3 time = 1320
* CHECK dout0_8 vdout0_8ck131 = 0 time = 1320
* CHECK dout0_9 vdout0_9ck131 = 0 time = 1320
* CHECK dout0_10 vdout0_10ck131 = 0 time = 1320
* CHECK dout0_11 vdout0_11ck131 = 0 time = 1320
* CHECK dout0_12 vdout0_12ck131 = 3.3 time = 1320
* CHECK dout0_13 vdout0_13ck131 = 0 time = 1320
* CHECK dout0_14 vdout0_14ck131 = 3.3 time = 1320
* CHECK dout0_15 vdout0_15ck131 = 0 time = 1320
* CHECK dout0_16 vdout0_16ck131 = 0 time = 1320
* CHECK dout0_17 vdout0_17ck131 = 3.3 time = 1320
* CHECK dout0_18 vdout0_18ck131 = 0 time = 1320
* CHECK dout0_19 vdout0_19ck131 = 3.3 time = 1320
* CHECK dout0_20 vdout0_20ck131 = 0 time = 1320
* CHECK dout0_21 vdout0_21ck131 = 0 time = 1320
* CHECK dout0_22 vdout0_22ck131 = 0 time = 1320
* CHECK dout0_23 vdout0_23ck131 = 3.3 time = 1320
* CHECK dout0_24 vdout0_24ck131 = 3.3 time = 1320
* CHECK dout0_25 vdout0_25ck131 = 3.3 time = 1320
* CHECK dout0_26 vdout0_26ck131 = 3.3 time = 1320
* CHECK dout0_27 vdout0_27ck131 = 3.3 time = 1320
* CHECK dout0_28 vdout0_28ck131 = 0 time = 1320
* CHECK dout0_29 vdout0_29ck131 = 0 time = 1320
* CHECK dout0_30 vdout0_30ck131 = 3.3 time = 1320
* CHECK dout0_31 vdout0_31ck131 = 3.3 time = 1320
* CHECK dout1_0 vdout1_0ck132 = 0 time = 1330
* CHECK dout1_1 vdout1_1ck132 = 0 time = 1330
* CHECK dout1_2 vdout1_2ck132 = 0 time = 1330
* CHECK dout1_3 vdout1_3ck132 = 0 time = 1330
* CHECK dout1_4 vdout1_4ck132 = 0 time = 1330
* CHECK dout1_5 vdout1_5ck132 = 0 time = 1330
* CHECK dout1_6 vdout1_6ck132 = 3.3 time = 1330
* CHECK dout1_7 vdout1_7ck132 = 3.3 time = 1330
* CHECK dout1_8 vdout1_8ck132 = 0 time = 1330
* CHECK dout1_9 vdout1_9ck132 = 0 time = 1330
* CHECK dout1_10 vdout1_10ck132 = 3.3 time = 1330
* CHECK dout1_11 vdout1_11ck132 = 0 time = 1330
* CHECK dout1_12 vdout1_12ck132 = 0 time = 1330
* CHECK dout1_13 vdout1_13ck132 = 0 time = 1330
* CHECK dout1_14 vdout1_14ck132 = 3.3 time = 1330
* CHECK dout1_15 vdout1_15ck132 = 0 time = 1330
* CHECK dout1_16 vdout1_16ck132 = 0 time = 1330
* CHECK dout1_17 vdout1_17ck132 = 3.3 time = 1330
* CHECK dout1_18 vdout1_18ck132 = 3.3 time = 1330
* CHECK dout1_19 vdout1_19ck132 = 0 time = 1330
* CHECK dout1_20 vdout1_20ck132 = 0 time = 1330
* CHECK dout1_21 vdout1_21ck132 = 0 time = 1330
* CHECK dout1_22 vdout1_22ck132 = 3.3 time = 1330
* CHECK dout1_23 vdout1_23ck132 = 0 time = 1330
* CHECK dout1_24 vdout1_24ck132 = 0 time = 1330
* CHECK dout1_25 vdout1_25ck132 = 3.3 time = 1330
* CHECK dout1_26 vdout1_26ck132 = 0 time = 1330
* CHECK dout1_27 vdout1_27ck132 = 0 time = 1330
* CHECK dout1_28 vdout1_28ck132 = 3.3 time = 1330
* CHECK dout1_29 vdout1_29ck132 = 0 time = 1330
* CHECK dout1_30 vdout1_30ck132 = 3.3 time = 1330
* CHECK dout1_31 vdout1_31ck132 = 3.3 time = 1330
* CHECK dout0_0 vdout0_0ck133 = 0 time = 1340
* CHECK dout0_1 vdout0_1ck133 = 0 time = 1340
* CHECK dout0_2 vdout0_2ck133 = 0 time = 1340
* CHECK dout0_3 vdout0_3ck133 = 0 time = 1340
* CHECK dout0_4 vdout0_4ck133 = 0 time = 1340
* CHECK dout0_5 vdout0_5ck133 = 0 time = 1340
* CHECK dout0_6 vdout0_6ck133 = 3.3 time = 1340
* CHECK dout0_7 vdout0_7ck133 = 3.3 time = 1340
* CHECK dout0_8 vdout0_8ck133 = 0 time = 1340
* CHECK dout0_9 vdout0_9ck133 = 0 time = 1340
* CHECK dout0_10 vdout0_10ck133 = 3.3 time = 1340
* CHECK dout0_11 vdout0_11ck133 = 0 time = 1340
* CHECK dout0_12 vdout0_12ck133 = 0 time = 1340
* CHECK dout0_13 vdout0_13ck133 = 0 time = 1340
* CHECK dout0_14 vdout0_14ck133 = 3.3 time = 1340
* CHECK dout0_15 vdout0_15ck133 = 0 time = 1340
* CHECK dout0_16 vdout0_16ck133 = 0 time = 1340
* CHECK dout0_17 vdout0_17ck133 = 3.3 time = 1340
* CHECK dout0_18 vdout0_18ck133 = 3.3 time = 1340
* CHECK dout0_19 vdout0_19ck133 = 0 time = 1340
* CHECK dout0_20 vdout0_20ck133 = 0 time = 1340
* CHECK dout0_21 vdout0_21ck133 = 0 time = 1340
* CHECK dout0_22 vdout0_22ck133 = 3.3 time = 1340
* CHECK dout0_23 vdout0_23ck133 = 0 time = 1340
* CHECK dout0_24 vdout0_24ck133 = 0 time = 1340
* CHECK dout0_25 vdout0_25ck133 = 3.3 time = 1340
* CHECK dout0_26 vdout0_26ck133 = 0 time = 1340
* CHECK dout0_27 vdout0_27ck133 = 0 time = 1340
* CHECK dout0_28 vdout0_28ck133 = 3.3 time = 1340
* CHECK dout0_29 vdout0_29ck133 = 0 time = 1340
* CHECK dout0_30 vdout0_30ck133 = 3.3 time = 1340
* CHECK dout0_31 vdout0_31ck133 = 3.3 time = 1340
* CHECK dout1_0 vdout1_0ck133 = 0 time = 1340
* CHECK dout1_1 vdout1_1ck133 = 0 time = 1340
* CHECK dout1_2 vdout1_2ck133 = 0 time = 1340
* CHECK dout1_3 vdout1_3ck133 = 0 time = 1340
* CHECK dout1_4 vdout1_4ck133 = 0 time = 1340
* CHECK dout1_5 vdout1_5ck133 = 0 time = 1340
* CHECK dout1_6 vdout1_6ck133 = 3.3 time = 1340
* CHECK dout1_7 vdout1_7ck133 = 3.3 time = 1340
* CHECK dout1_8 vdout1_8ck133 = 0 time = 1340
* CHECK dout1_9 vdout1_9ck133 = 0 time = 1340
* CHECK dout1_10 vdout1_10ck133 = 3.3 time = 1340
* CHECK dout1_11 vdout1_11ck133 = 0 time = 1340
* CHECK dout1_12 vdout1_12ck133 = 0 time = 1340
* CHECK dout1_13 vdout1_13ck133 = 0 time = 1340
* CHECK dout1_14 vdout1_14ck133 = 3.3 time = 1340
* CHECK dout1_15 vdout1_15ck133 = 0 time = 1340
* CHECK dout1_16 vdout1_16ck133 = 0 time = 1340
* CHECK dout1_17 vdout1_17ck133 = 3.3 time = 1340
* CHECK dout1_18 vdout1_18ck133 = 3.3 time = 1340
* CHECK dout1_19 vdout1_19ck133 = 0 time = 1340
* CHECK dout1_20 vdout1_20ck133 = 0 time = 1340
* CHECK dout1_21 vdout1_21ck133 = 0 time = 1340
* CHECK dout1_22 vdout1_22ck133 = 3.3 time = 1340
* CHECK dout1_23 vdout1_23ck133 = 0 time = 1340
* CHECK dout1_24 vdout1_24ck133 = 0 time = 1340
* CHECK dout1_25 vdout1_25ck133 = 3.3 time = 1340
* CHECK dout1_26 vdout1_26ck133 = 0 time = 1340
* CHECK dout1_27 vdout1_27ck133 = 0 time = 1340
* CHECK dout1_28 vdout1_28ck133 = 3.3 time = 1340
* CHECK dout1_29 vdout1_29ck133 = 0 time = 1340
* CHECK dout1_30 vdout1_30ck133 = 3.3 time = 1340
* CHECK dout1_31 vdout1_31ck133 = 3.3 time = 1340
* CHECK dout1_0 vdout1_0ck134 = 3.3 time = 1350
* CHECK dout1_1 vdout1_1ck134 = 3.3 time = 1350
* CHECK dout1_2 vdout1_2ck134 = 0 time = 1350
* CHECK dout1_3 vdout1_3ck134 = 3.3 time = 1350
* CHECK dout1_4 vdout1_4ck134 = 0 time = 1350
* CHECK dout1_5 vdout1_5ck134 = 3.3 time = 1350
* CHECK dout1_6 vdout1_6ck134 = 0 time = 1350
* CHECK dout1_7 vdout1_7ck134 = 3.3 time = 1350
* CHECK dout1_8 vdout1_8ck134 = 0 time = 1350
* CHECK dout1_9 vdout1_9ck134 = 0 time = 1350
* CHECK dout1_10 vdout1_10ck134 = 0 time = 1350
* CHECK dout1_11 vdout1_11ck134 = 0 time = 1350
* CHECK dout1_12 vdout1_12ck134 = 3.3 time = 1350
* CHECK dout1_13 vdout1_13ck134 = 0 time = 1350
* CHECK dout1_14 vdout1_14ck134 = 3.3 time = 1350
* CHECK dout1_15 vdout1_15ck134 = 0 time = 1350
* CHECK dout1_16 vdout1_16ck134 = 0 time = 1350
* CHECK dout1_17 vdout1_17ck134 = 3.3 time = 1350
* CHECK dout1_18 vdout1_18ck134 = 0 time = 1350
* CHECK dout1_19 vdout1_19ck134 = 3.3 time = 1350
* CHECK dout1_20 vdout1_20ck134 = 0 time = 1350
* CHECK dout1_21 vdout1_21ck134 = 0 time = 1350
* CHECK dout1_22 vdout1_22ck134 = 0 time = 1350
* CHECK dout1_23 vdout1_23ck134 = 3.3 time = 1350
* CHECK dout1_24 vdout1_24ck134 = 3.3 time = 1350
* CHECK dout1_25 vdout1_25ck134 = 3.3 time = 1350
* CHECK dout1_26 vdout1_26ck134 = 3.3 time = 1350
* CHECK dout1_27 vdout1_27ck134 = 3.3 time = 1350
* CHECK dout1_28 vdout1_28ck134 = 0 time = 1350
* CHECK dout1_29 vdout1_29ck134 = 0 time = 1350
* CHECK dout1_30 vdout1_30ck134 = 3.3 time = 1350
* CHECK dout1_31 vdout1_31ck134 = 3.3 time = 1350
* CHECK dout0_0 vdout0_0ck135 = 3.3 time = 1360
* CHECK dout0_1 vdout0_1ck135 = 3.3 time = 1360
* CHECK dout0_2 vdout0_2ck135 = 0 time = 1360
* CHECK dout0_3 vdout0_3ck135 = 3.3 time = 1360
* CHECK dout0_4 vdout0_4ck135 = 0 time = 1360
* CHECK dout0_5 vdout0_5ck135 = 3.3 time = 1360
* CHECK dout0_6 vdout0_6ck135 = 0 time = 1360
* CHECK dout0_7 vdout0_7ck135 = 3.3 time = 1360
* CHECK dout0_8 vdout0_8ck135 = 0 time = 1360
* CHECK dout0_9 vdout0_9ck135 = 0 time = 1360
* CHECK dout0_10 vdout0_10ck135 = 0 time = 1360
* CHECK dout0_11 vdout0_11ck135 = 0 time = 1360
* CHECK dout0_12 vdout0_12ck135 = 3.3 time = 1360
* CHECK dout0_13 vdout0_13ck135 = 0 time = 1360
* CHECK dout0_14 vdout0_14ck135 = 3.3 time = 1360
* CHECK dout0_15 vdout0_15ck135 = 0 time = 1360
* CHECK dout0_16 vdout0_16ck135 = 0 time = 1360
* CHECK dout0_17 vdout0_17ck135 = 3.3 time = 1360
* CHECK dout0_18 vdout0_18ck135 = 0 time = 1360
* CHECK dout0_19 vdout0_19ck135 = 3.3 time = 1360
* CHECK dout0_20 vdout0_20ck135 = 0 time = 1360
* CHECK dout0_21 vdout0_21ck135 = 0 time = 1360
* CHECK dout0_22 vdout0_22ck135 = 0 time = 1360
* CHECK dout0_23 vdout0_23ck135 = 3.3 time = 1360
* CHECK dout0_24 vdout0_24ck135 = 3.3 time = 1360
* CHECK dout0_25 vdout0_25ck135 = 3.3 time = 1360
* CHECK dout0_26 vdout0_26ck135 = 3.3 time = 1360
* CHECK dout0_27 vdout0_27ck135 = 3.3 time = 1360
* CHECK dout0_28 vdout0_28ck135 = 0 time = 1360
* CHECK dout0_29 vdout0_29ck135 = 0 time = 1360
* CHECK dout0_30 vdout0_30ck135 = 3.3 time = 1360
* CHECK dout0_31 vdout0_31ck135 = 3.3 time = 1360
* CHECK dout1_0 vdout1_0ck137 = 3.3 time = 1380
* CHECK dout1_1 vdout1_1ck137 = 0 time = 1380
* CHECK dout1_2 vdout1_2ck137 = 0 time = 1380
* CHECK dout1_3 vdout1_3ck137 = 0 time = 1380
* CHECK dout1_4 vdout1_4ck137 = 0 time = 1380
* CHECK dout1_5 vdout1_5ck137 = 0 time = 1380
* CHECK dout1_6 vdout1_6ck137 = 3.3 time = 1380
* CHECK dout1_7 vdout1_7ck137 = 3.3 time = 1380
* CHECK dout1_8 vdout1_8ck137 = 0 time = 1380
* CHECK dout1_9 vdout1_9ck137 = 0 time = 1380
* CHECK dout1_10 vdout1_10ck137 = 3.3 time = 1380
* CHECK dout1_11 vdout1_11ck137 = 0 time = 1380
* CHECK dout1_12 vdout1_12ck137 = 3.3 time = 1380
* CHECK dout1_13 vdout1_13ck137 = 3.3 time = 1380
* CHECK dout1_14 vdout1_14ck137 = 0 time = 1380
* CHECK dout1_15 vdout1_15ck137 = 3.3 time = 1380
* CHECK dout1_16 vdout1_16ck137 = 3.3 time = 1380
* CHECK dout1_17 vdout1_17ck137 = 0 time = 1380
* CHECK dout1_18 vdout1_18ck137 = 3.3 time = 1380
* CHECK dout1_19 vdout1_19ck137 = 0 time = 1380
* CHECK dout1_20 vdout1_20ck137 = 0 time = 1380
* CHECK dout1_21 vdout1_21ck137 = 3.3 time = 1380
* CHECK dout1_22 vdout1_22ck137 = 3.3 time = 1380
* CHECK dout1_23 vdout1_23ck137 = 0 time = 1380
* CHECK dout1_24 vdout1_24ck137 = 0 time = 1380
* CHECK dout1_25 vdout1_25ck137 = 3.3 time = 1380
* CHECK dout1_26 vdout1_26ck137 = 0 time = 1380
* CHECK dout1_27 vdout1_27ck137 = 3.3 time = 1380
* CHECK dout1_28 vdout1_28ck137 = 0 time = 1380
* CHECK dout1_29 vdout1_29ck137 = 0 time = 1380
* CHECK dout1_30 vdout1_30ck137 = 0 time = 1380
* CHECK dout1_31 vdout1_31ck137 = 0 time = 1380
* CHECK dout1_0 vdout1_0ck139 = 3.3 time = 1400
* CHECK dout1_1 vdout1_1ck139 = 0 time = 1400
* CHECK dout1_2 vdout1_2ck139 = 0 time = 1400
* CHECK dout1_3 vdout1_3ck139 = 0 time = 1400
* CHECK dout1_4 vdout1_4ck139 = 0 time = 1400
* CHECK dout1_5 vdout1_5ck139 = 0 time = 1400
* CHECK dout1_6 vdout1_6ck139 = 3.3 time = 1400
* CHECK dout1_7 vdout1_7ck139 = 3.3 time = 1400
* CHECK dout1_8 vdout1_8ck139 = 0 time = 1400
* CHECK dout1_9 vdout1_9ck139 = 0 time = 1400
* CHECK dout1_10 vdout1_10ck139 = 3.3 time = 1400
* CHECK dout1_11 vdout1_11ck139 = 0 time = 1400
* CHECK dout1_12 vdout1_12ck139 = 3.3 time = 1400
* CHECK dout1_13 vdout1_13ck139 = 3.3 time = 1400
* CHECK dout1_14 vdout1_14ck139 = 0 time = 1400
* CHECK dout1_15 vdout1_15ck139 = 3.3 time = 1400
* CHECK dout1_16 vdout1_16ck139 = 3.3 time = 1400
* CHECK dout1_17 vdout1_17ck139 = 0 time = 1400
* CHECK dout1_18 vdout1_18ck139 = 3.3 time = 1400
* CHECK dout1_19 vdout1_19ck139 = 0 time = 1400
* CHECK dout1_20 vdout1_20ck139 = 0 time = 1400
* CHECK dout1_21 vdout1_21ck139 = 3.3 time = 1400
* CHECK dout1_22 vdout1_22ck139 = 3.3 time = 1400
* CHECK dout1_23 vdout1_23ck139 = 0 time = 1400
* CHECK dout1_24 vdout1_24ck139 = 0 time = 1400
* CHECK dout1_25 vdout1_25ck139 = 3.3 time = 1400
* CHECK dout1_26 vdout1_26ck139 = 0 time = 1400
* CHECK dout1_27 vdout1_27ck139 = 3.3 time = 1400
* CHECK dout1_28 vdout1_28ck139 = 0 time = 1400
* CHECK dout1_29 vdout1_29ck139 = 0 time = 1400
* CHECK dout1_30 vdout1_30ck139 = 0 time = 1400
* CHECK dout1_31 vdout1_31ck139 = 0 time = 1400
* CHECK dout0_0 vdout0_0ck140 = 0 time = 1410
* CHECK dout0_1 vdout0_1ck140 = 3.3 time = 1410
* CHECK dout0_2 vdout0_2ck140 = 0 time = 1410
* CHECK dout0_3 vdout0_3ck140 = 3.3 time = 1410
* CHECK dout0_4 vdout0_4ck140 = 0 time = 1410
* CHECK dout0_5 vdout0_5ck140 = 0 time = 1410
* CHECK dout0_6 vdout0_6ck140 = 3.3 time = 1410
* CHECK dout0_7 vdout0_7ck140 = 3.3 time = 1410
* CHECK dout0_8 vdout0_8ck140 = 3.3 time = 1410
* CHECK dout0_9 vdout0_9ck140 = 0 time = 1410
* CHECK dout0_10 vdout0_10ck140 = 3.3 time = 1410
* CHECK dout0_11 vdout0_11ck140 = 3.3 time = 1410
* CHECK dout0_12 vdout0_12ck140 = 0 time = 1410
* CHECK dout0_13 vdout0_13ck140 = 0 time = 1410
* CHECK dout0_14 vdout0_14ck140 = 0 time = 1410
* CHECK dout0_15 vdout0_15ck140 = 0 time = 1410
* CHECK dout0_16 vdout0_16ck140 = 0 time = 1410
* CHECK dout0_17 vdout0_17ck140 = 3.3 time = 1410
* CHECK dout0_18 vdout0_18ck140 = 0 time = 1410
* CHECK dout0_19 vdout0_19ck140 = 0 time = 1410
* CHECK dout0_20 vdout0_20ck140 = 3.3 time = 1410
* CHECK dout0_21 vdout0_21ck140 = 3.3 time = 1410
* CHECK dout0_22 vdout0_22ck140 = 0 time = 1410
* CHECK dout0_23 vdout0_23ck140 = 3.3 time = 1410
* CHECK dout0_24 vdout0_24ck140 = 0 time = 1410
* CHECK dout0_25 vdout0_25ck140 = 0 time = 1410
* CHECK dout0_26 vdout0_26ck140 = 0 time = 1410
* CHECK dout0_27 vdout0_27ck140 = 0 time = 1410
* CHECK dout0_28 vdout0_28ck140 = 3.3 time = 1410
* CHECK dout0_29 vdout0_29ck140 = 0 time = 1410
* CHECK dout0_30 vdout0_30ck140 = 3.3 time = 1410
* CHECK dout0_31 vdout0_31ck140 = 3.3 time = 1410
* CHECK dout1_0 vdout1_0ck140 = 3.3 time = 1410
* CHECK dout1_1 vdout1_1ck140 = 0 time = 1410
* CHECK dout1_2 vdout1_2ck140 = 0 time = 1410
* CHECK dout1_3 vdout1_3ck140 = 0 time = 1410
* CHECK dout1_4 vdout1_4ck140 = 0 time = 1410
* CHECK dout1_5 vdout1_5ck140 = 0 time = 1410
* CHECK dout1_6 vdout1_6ck140 = 3.3 time = 1410
* CHECK dout1_7 vdout1_7ck140 = 3.3 time = 1410
* CHECK dout1_8 vdout1_8ck140 = 0 time = 1410
* CHECK dout1_9 vdout1_9ck140 = 0 time = 1410
* CHECK dout1_10 vdout1_10ck140 = 3.3 time = 1410
* CHECK dout1_11 vdout1_11ck140 = 0 time = 1410
* CHECK dout1_12 vdout1_12ck140 = 3.3 time = 1410
* CHECK dout1_13 vdout1_13ck140 = 3.3 time = 1410
* CHECK dout1_14 vdout1_14ck140 = 0 time = 1410
* CHECK dout1_15 vdout1_15ck140 = 3.3 time = 1410
* CHECK dout1_16 vdout1_16ck140 = 3.3 time = 1410
* CHECK dout1_17 vdout1_17ck140 = 0 time = 1410
* CHECK dout1_18 vdout1_18ck140 = 3.3 time = 1410
* CHECK dout1_19 vdout1_19ck140 = 0 time = 1410
* CHECK dout1_20 vdout1_20ck140 = 0 time = 1410
* CHECK dout1_21 vdout1_21ck140 = 3.3 time = 1410
* CHECK dout1_22 vdout1_22ck140 = 3.3 time = 1410
* CHECK dout1_23 vdout1_23ck140 = 0 time = 1410
* CHECK dout1_24 vdout1_24ck140 = 0 time = 1410
* CHECK dout1_25 vdout1_25ck140 = 3.3 time = 1410
* CHECK dout1_26 vdout1_26ck140 = 0 time = 1410
* CHECK dout1_27 vdout1_27ck140 = 3.3 time = 1410
* CHECK dout1_28 vdout1_28ck140 = 0 time = 1410
* CHECK dout1_29 vdout1_29ck140 = 0 time = 1410
* CHECK dout1_30 vdout1_30ck140 = 0 time = 1410
* CHECK dout1_31 vdout1_31ck140 = 0 time = 1410
* CHECK dout1_0 vdout1_0ck141 = 0 time = 1420
* CHECK dout1_1 vdout1_1ck141 = 3.3 time = 1420
* CHECK dout1_2 vdout1_2ck141 = 0 time = 1420
* CHECK dout1_3 vdout1_3ck141 = 3.3 time = 1420
* CHECK dout1_4 vdout1_4ck141 = 0 time = 1420
* CHECK dout1_5 vdout1_5ck141 = 0 time = 1420
* CHECK dout1_6 vdout1_6ck141 = 3.3 time = 1420
* CHECK dout1_7 vdout1_7ck141 = 3.3 time = 1420
* CHECK dout1_8 vdout1_8ck141 = 3.3 time = 1420
* CHECK dout1_9 vdout1_9ck141 = 0 time = 1420
* CHECK dout1_10 vdout1_10ck141 = 3.3 time = 1420
* CHECK dout1_11 vdout1_11ck141 = 3.3 time = 1420
* CHECK dout1_12 vdout1_12ck141 = 0 time = 1420
* CHECK dout1_13 vdout1_13ck141 = 0 time = 1420
* CHECK dout1_14 vdout1_14ck141 = 0 time = 1420
* CHECK dout1_15 vdout1_15ck141 = 0 time = 1420
* CHECK dout1_16 vdout1_16ck141 = 0 time = 1420
* CHECK dout1_17 vdout1_17ck141 = 3.3 time = 1420
* CHECK dout1_18 vdout1_18ck141 = 0 time = 1420
* CHECK dout1_19 vdout1_19ck141 = 0 time = 1420
* CHECK dout1_20 vdout1_20ck141 = 3.3 time = 1420
* CHECK dout1_21 vdout1_21ck141 = 3.3 time = 1420
* CHECK dout1_22 vdout1_22ck141 = 0 time = 1420
* CHECK dout1_23 vdout1_23ck141 = 3.3 time = 1420
* CHECK dout1_24 vdout1_24ck141 = 0 time = 1420
* CHECK dout1_25 vdout1_25ck141 = 0 time = 1420
* CHECK dout1_26 vdout1_26ck141 = 0 time = 1420
* CHECK dout1_27 vdout1_27ck141 = 0 time = 1420
* CHECK dout1_28 vdout1_28ck141 = 3.3 time = 1420
* CHECK dout1_29 vdout1_29ck141 = 0 time = 1420
* CHECK dout1_30 vdout1_30ck141 = 3.3 time = 1420
* CHECK dout1_31 vdout1_31ck141 = 3.3 time = 1420
* CHECK dout0_0 vdout0_0ck142 = 3.3 time = 1430
* CHECK dout0_1 vdout0_1ck142 = 0 time = 1430
* CHECK dout0_2 vdout0_2ck142 = 0 time = 1430
* CHECK dout0_3 vdout0_3ck142 = 0 time = 1430
* CHECK dout0_4 vdout0_4ck142 = 0 time = 1430
* CHECK dout0_5 vdout0_5ck142 = 0 time = 1430
* CHECK dout0_6 vdout0_6ck142 = 3.3 time = 1430
* CHECK dout0_7 vdout0_7ck142 = 3.3 time = 1430
* CHECK dout0_8 vdout0_8ck142 = 0 time = 1430
* CHECK dout0_9 vdout0_9ck142 = 0 time = 1430
* CHECK dout0_10 vdout0_10ck142 = 3.3 time = 1430
* CHECK dout0_11 vdout0_11ck142 = 0 time = 1430
* CHECK dout0_12 vdout0_12ck142 = 3.3 time = 1430
* CHECK dout0_13 vdout0_13ck142 = 3.3 time = 1430
* CHECK dout0_14 vdout0_14ck142 = 0 time = 1430
* CHECK dout0_15 vdout0_15ck142 = 3.3 time = 1430
* CHECK dout0_16 vdout0_16ck142 = 3.3 time = 1430
* CHECK dout0_17 vdout0_17ck142 = 0 time = 1430
* CHECK dout0_18 vdout0_18ck142 = 3.3 time = 1430
* CHECK dout0_19 vdout0_19ck142 = 0 time = 1430
* CHECK dout0_20 vdout0_20ck142 = 0 time = 1430
* CHECK dout0_21 vdout0_21ck142 = 3.3 time = 1430
* CHECK dout0_22 vdout0_22ck142 = 3.3 time = 1430
* CHECK dout0_23 vdout0_23ck142 = 0 time = 1430
* CHECK dout0_24 vdout0_24ck142 = 0 time = 1430
* CHECK dout0_25 vdout0_25ck142 = 3.3 time = 1430
* CHECK dout0_26 vdout0_26ck142 = 0 time = 1430
* CHECK dout0_27 vdout0_27ck142 = 3.3 time = 1430
* CHECK dout0_28 vdout0_28ck142 = 0 time = 1430
* CHECK dout0_29 vdout0_29ck142 = 0 time = 1430
* CHECK dout0_30 vdout0_30ck142 = 0 time = 1430
* CHECK dout0_31 vdout0_31ck142 = 0 time = 1430
* CHECK dout1_0 vdout1_0ck142 = 3.3 time = 1430
* CHECK dout1_1 vdout1_1ck142 = 0 time = 1430
* CHECK dout1_2 vdout1_2ck142 = 0 time = 1430
* CHECK dout1_3 vdout1_3ck142 = 0 time = 1430
* CHECK dout1_4 vdout1_4ck142 = 0 time = 1430
* CHECK dout1_5 vdout1_5ck142 = 0 time = 1430
* CHECK dout1_6 vdout1_6ck142 = 3.3 time = 1430
* CHECK dout1_7 vdout1_7ck142 = 3.3 time = 1430
* CHECK dout1_8 vdout1_8ck142 = 0 time = 1430
* CHECK dout1_9 vdout1_9ck142 = 0 time = 1430
* CHECK dout1_10 vdout1_10ck142 = 3.3 time = 1430
* CHECK dout1_11 vdout1_11ck142 = 0 time = 1430
* CHECK dout1_12 vdout1_12ck142 = 3.3 time = 1430
* CHECK dout1_13 vdout1_13ck142 = 3.3 time = 1430
* CHECK dout1_14 vdout1_14ck142 = 0 time = 1430
* CHECK dout1_15 vdout1_15ck142 = 3.3 time = 1430
* CHECK dout1_16 vdout1_16ck142 = 3.3 time = 1430
* CHECK dout1_17 vdout1_17ck142 = 0 time = 1430
* CHECK dout1_18 vdout1_18ck142 = 3.3 time = 1430
* CHECK dout1_19 vdout1_19ck142 = 0 time = 1430
* CHECK dout1_20 vdout1_20ck142 = 0 time = 1430
* CHECK dout1_21 vdout1_21ck142 = 3.3 time = 1430
* CHECK dout1_22 vdout1_22ck142 = 3.3 time = 1430
* CHECK dout1_23 vdout1_23ck142 = 0 time = 1430
* CHECK dout1_24 vdout1_24ck142 = 0 time = 1430
* CHECK dout1_25 vdout1_25ck142 = 3.3 time = 1430
* CHECK dout1_26 vdout1_26ck142 = 0 time = 1430
* CHECK dout1_27 vdout1_27ck142 = 3.3 time = 1430
* CHECK dout1_28 vdout1_28ck142 = 0 time = 1430
* CHECK dout1_29 vdout1_29ck142 = 0 time = 1430
* CHECK dout1_30 vdout1_30ck142 = 0 time = 1430
* CHECK dout1_31 vdout1_31ck142 = 0 time = 1430
* CHECK dout0_0 vdout0_0ck144 = 3.3 time = 1450
* CHECK dout0_1 vdout0_1ck144 = 0 time = 1450
* CHECK dout0_2 vdout0_2ck144 = 0 time = 1450
* CHECK dout0_3 vdout0_3ck144 = 0 time = 1450
* CHECK dout0_4 vdout0_4ck144 = 0 time = 1450
* CHECK dout0_5 vdout0_5ck144 = 0 time = 1450
* CHECK dout0_6 vdout0_6ck144 = 3.3 time = 1450
* CHECK dout0_7 vdout0_7ck144 = 3.3 time = 1450
* CHECK dout0_8 vdout0_8ck144 = 0 time = 1450
* CHECK dout0_9 vdout0_9ck144 = 0 time = 1450
* CHECK dout0_10 vdout0_10ck144 = 3.3 time = 1450
* CHECK dout0_11 vdout0_11ck144 = 0 time = 1450
* CHECK dout0_12 vdout0_12ck144 = 3.3 time = 1450
* CHECK dout0_13 vdout0_13ck144 = 3.3 time = 1450
* CHECK dout0_14 vdout0_14ck144 = 0 time = 1450
* CHECK dout0_15 vdout0_15ck144 = 3.3 time = 1450
* CHECK dout0_16 vdout0_16ck144 = 3.3 time = 1450
* CHECK dout0_17 vdout0_17ck144 = 0 time = 1450
* CHECK dout0_18 vdout0_18ck144 = 3.3 time = 1450
* CHECK dout0_19 vdout0_19ck144 = 0 time = 1450
* CHECK dout0_20 vdout0_20ck144 = 0 time = 1450
* CHECK dout0_21 vdout0_21ck144 = 3.3 time = 1450
* CHECK dout0_22 vdout0_22ck144 = 3.3 time = 1450
* CHECK dout0_23 vdout0_23ck144 = 0 time = 1450
* CHECK dout0_24 vdout0_24ck144 = 0 time = 1450
* CHECK dout0_25 vdout0_25ck144 = 3.3 time = 1450
* CHECK dout0_26 vdout0_26ck144 = 0 time = 1450
* CHECK dout0_27 vdout0_27ck144 = 3.3 time = 1450
* CHECK dout0_28 vdout0_28ck144 = 0 time = 1450
* CHECK dout0_29 vdout0_29ck144 = 0 time = 1450
* CHECK dout0_30 vdout0_30ck144 = 0 time = 1450
* CHECK dout0_31 vdout0_31ck144 = 0 time = 1450
* CHECK dout0_0 vdout0_0ck145 = 0 time = 1460
* CHECK dout0_1 vdout0_1ck145 = 3.3 time = 1460
* CHECK dout0_2 vdout0_2ck145 = 3.3 time = 1460
* CHECK dout0_3 vdout0_3ck145 = 0 time = 1460
* CHECK dout0_4 vdout0_4ck145 = 0 time = 1460
* CHECK dout0_5 vdout0_5ck145 = 0 time = 1460
* CHECK dout0_6 vdout0_6ck145 = 3.3 time = 1460
* CHECK dout0_7 vdout0_7ck145 = 3.3 time = 1460
* CHECK dout0_8 vdout0_8ck145 = 0 time = 1460
* CHECK dout0_9 vdout0_9ck145 = 0 time = 1460
* CHECK dout0_10 vdout0_10ck145 = 0 time = 1460
* CHECK dout0_11 vdout0_11ck145 = 0 time = 1460
* CHECK dout0_12 vdout0_12ck145 = 3.3 time = 1460
* CHECK dout0_13 vdout0_13ck145 = 3.3 time = 1460
* CHECK dout0_14 vdout0_14ck145 = 3.3 time = 1460
* CHECK dout0_15 vdout0_15ck145 = 3.3 time = 1460
* CHECK dout0_16 vdout0_16ck145 = 3.3 time = 1460
* CHECK dout0_17 vdout0_17ck145 = 0 time = 1460
* CHECK dout0_18 vdout0_18ck145 = 3.3 time = 1460
* CHECK dout0_19 vdout0_19ck145 = 3.3 time = 1460
* CHECK dout0_20 vdout0_20ck145 = 0 time = 1460
* CHECK dout0_21 vdout0_21ck145 = 3.3 time = 1460
* CHECK dout0_22 vdout0_22ck145 = 3.3 time = 1460
* CHECK dout0_23 vdout0_23ck145 = 0 time = 1460
* CHECK dout0_24 vdout0_24ck145 = 0 time = 1460
* CHECK dout0_25 vdout0_25ck145 = 0 time = 1460
* CHECK dout0_26 vdout0_26ck145 = 3.3 time = 1460
* CHECK dout0_27 vdout0_27ck145 = 0 time = 1460
* CHECK dout0_28 vdout0_28ck145 = 3.3 time = 1460
* CHECK dout0_29 vdout0_29ck145 = 0 time = 1460
* CHECK dout0_30 vdout0_30ck145 = 0 time = 1460
* CHECK dout0_31 vdout0_31ck145 = 0 time = 1460
* CHECK dout1_0 vdout1_0ck145 = 0 time = 1460
* CHECK dout1_1 vdout1_1ck145 = 3.3 time = 1460
* CHECK dout1_2 vdout1_2ck145 = 3.3 time = 1460
* CHECK dout1_3 vdout1_3ck145 = 0 time = 1460
* CHECK dout1_4 vdout1_4ck145 = 0 time = 1460
* CHECK dout1_5 vdout1_5ck145 = 0 time = 1460
* CHECK dout1_6 vdout1_6ck145 = 3.3 time = 1460
* CHECK dout1_7 vdout1_7ck145 = 3.3 time = 1460
* CHECK dout1_8 vdout1_8ck145 = 0 time = 1460
* CHECK dout1_9 vdout1_9ck145 = 0 time = 1460
* CHECK dout1_10 vdout1_10ck145 = 0 time = 1460
* CHECK dout1_11 vdout1_11ck145 = 0 time = 1460
* CHECK dout1_12 vdout1_12ck145 = 3.3 time = 1460
* CHECK dout1_13 vdout1_13ck145 = 3.3 time = 1460
* CHECK dout1_14 vdout1_14ck145 = 3.3 time = 1460
* CHECK dout1_15 vdout1_15ck145 = 3.3 time = 1460
* CHECK dout1_16 vdout1_16ck145 = 3.3 time = 1460
* CHECK dout1_17 vdout1_17ck145 = 0 time = 1460
* CHECK dout1_18 vdout1_18ck145 = 3.3 time = 1460
* CHECK dout1_19 vdout1_19ck145 = 3.3 time = 1460
* CHECK dout1_20 vdout1_20ck145 = 0 time = 1460
* CHECK dout1_21 vdout1_21ck145 = 3.3 time = 1460
* CHECK dout1_22 vdout1_22ck145 = 3.3 time = 1460
* CHECK dout1_23 vdout1_23ck145 = 0 time = 1460
* CHECK dout1_24 vdout1_24ck145 = 0 time = 1460
* CHECK dout1_25 vdout1_25ck145 = 0 time = 1460
* CHECK dout1_26 vdout1_26ck145 = 3.3 time = 1460
* CHECK dout1_27 vdout1_27ck145 = 0 time = 1460
* CHECK dout1_28 vdout1_28ck145 = 3.3 time = 1460
* CHECK dout1_29 vdout1_29ck145 = 0 time = 1460
* CHECK dout1_30 vdout1_30ck145 = 0 time = 1460
* CHECK dout1_31 vdout1_31ck145 = 0 time = 1460
* CHECK dout0_0 vdout0_0ck147 = 3.3 time = 1480
* CHECK dout0_1 vdout0_1ck147 = 0 time = 1480
* CHECK dout0_2 vdout0_2ck147 = 0 time = 1480
* CHECK dout0_3 vdout0_3ck147 = 0 time = 1480
* CHECK dout0_4 vdout0_4ck147 = 0 time = 1480
* CHECK dout0_5 vdout0_5ck147 = 0 time = 1480
* CHECK dout0_6 vdout0_6ck147 = 3.3 time = 1480
* CHECK dout0_7 vdout0_7ck147 = 3.3 time = 1480
* CHECK dout0_8 vdout0_8ck147 = 0 time = 1480
* CHECK dout0_9 vdout0_9ck147 = 0 time = 1480
* CHECK dout0_10 vdout0_10ck147 = 3.3 time = 1480
* CHECK dout0_11 vdout0_11ck147 = 0 time = 1480
* CHECK dout0_12 vdout0_12ck147 = 3.3 time = 1480
* CHECK dout0_13 vdout0_13ck147 = 3.3 time = 1480
* CHECK dout0_14 vdout0_14ck147 = 0 time = 1480
* CHECK dout0_15 vdout0_15ck147 = 3.3 time = 1480
* CHECK dout0_16 vdout0_16ck147 = 3.3 time = 1480
* CHECK dout0_17 vdout0_17ck147 = 0 time = 1480
* CHECK dout0_18 vdout0_18ck147 = 3.3 time = 1480
* CHECK dout0_19 vdout0_19ck147 = 0 time = 1480
* CHECK dout0_20 vdout0_20ck147 = 0 time = 1480
* CHECK dout0_21 vdout0_21ck147 = 3.3 time = 1480
* CHECK dout0_22 vdout0_22ck147 = 3.3 time = 1480
* CHECK dout0_23 vdout0_23ck147 = 0 time = 1480
* CHECK dout0_24 vdout0_24ck147 = 0 time = 1480
* CHECK dout0_25 vdout0_25ck147 = 3.3 time = 1480
* CHECK dout0_26 vdout0_26ck147 = 0 time = 1480
* CHECK dout0_27 vdout0_27ck147 = 3.3 time = 1480
* CHECK dout0_28 vdout0_28ck147 = 0 time = 1480
* CHECK dout0_29 vdout0_29ck147 = 0 time = 1480
* CHECK dout0_30 vdout0_30ck147 = 0 time = 1480
* CHECK dout0_31 vdout0_31ck147 = 0 time = 1480
* CHECK dout1_0 vdout1_0ck147 = 0 time = 1480
* CHECK dout1_1 vdout1_1ck147 = 0 time = 1480
* CHECK dout1_2 vdout1_2ck147 = 3.3 time = 1480
* CHECK dout1_3 vdout1_3ck147 = 0 time = 1480
* CHECK dout1_4 vdout1_4ck147 = 3.3 time = 1480
* CHECK dout1_5 vdout1_5ck147 = 0 time = 1480
* CHECK dout1_6 vdout1_6ck147 = 0 time = 1480
* CHECK dout1_7 vdout1_7ck147 = 3.3 time = 1480
* CHECK dout1_8 vdout1_8ck147 = 3.3 time = 1480
* CHECK dout1_9 vdout1_9ck147 = 0 time = 1480
* CHECK dout1_10 vdout1_10ck147 = 0 time = 1480
* CHECK dout1_11 vdout1_11ck147 = 0 time = 1480
* CHECK dout1_12 vdout1_12ck147 = 3.3 time = 1480
* CHECK dout1_13 vdout1_13ck147 = 3.3 time = 1480
* CHECK dout1_14 vdout1_14ck147 = 0 time = 1480
* CHECK dout1_15 vdout1_15ck147 = 0 time = 1480
* CHECK dout1_16 vdout1_16ck147 = 0 time = 1480
* CHECK dout1_17 vdout1_17ck147 = 3.3 time = 1480
* CHECK dout1_18 vdout1_18ck147 = 3.3 time = 1480
* CHECK dout1_19 vdout1_19ck147 = 3.3 time = 1480
* CHECK dout1_20 vdout1_20ck147 = 0 time = 1480
* CHECK dout1_21 vdout1_21ck147 = 3.3 time = 1480
* CHECK dout1_22 vdout1_22ck147 = 3.3 time = 1480
* CHECK dout1_23 vdout1_23ck147 = 0 time = 1480
* CHECK dout1_24 vdout1_24ck147 = 3.3 time = 1480
* CHECK dout1_25 vdout1_25ck147 = 0 time = 1480
* CHECK dout1_26 vdout1_26ck147 = 0 time = 1480
* CHECK dout1_27 vdout1_27ck147 = 0 time = 1480
* CHECK dout1_28 vdout1_28ck147 = 0 time = 1480
* CHECK dout1_29 vdout1_29ck147 = 0 time = 1480
* CHECK dout1_30 vdout1_30ck147 = 0 time = 1480
* CHECK dout1_31 vdout1_31ck147 = 3.3 time = 1480
* CHECK dout0_0 vdout0_0ck148 = 3.3 time = 1490
* CHECK dout0_1 vdout0_1ck148 = 0 time = 1490
* CHECK dout0_2 vdout0_2ck148 = 0 time = 1490
* CHECK dout0_3 vdout0_3ck148 = 0 time = 1490
* CHECK dout0_4 vdout0_4ck148 = 0 time = 1490
* CHECK dout0_5 vdout0_5ck148 = 0 time = 1490
* CHECK dout0_6 vdout0_6ck148 = 3.3 time = 1490
* CHECK dout0_7 vdout0_7ck148 = 3.3 time = 1490
* CHECK dout0_8 vdout0_8ck148 = 0 time = 1490
* CHECK dout0_9 vdout0_9ck148 = 0 time = 1490
* CHECK dout0_10 vdout0_10ck148 = 3.3 time = 1490
* CHECK dout0_11 vdout0_11ck148 = 0 time = 1490
* CHECK dout0_12 vdout0_12ck148 = 3.3 time = 1490
* CHECK dout0_13 vdout0_13ck148 = 3.3 time = 1490
* CHECK dout0_14 vdout0_14ck148 = 0 time = 1490
* CHECK dout0_15 vdout0_15ck148 = 3.3 time = 1490
* CHECK dout0_16 vdout0_16ck148 = 3.3 time = 1490
* CHECK dout0_17 vdout0_17ck148 = 0 time = 1490
* CHECK dout0_18 vdout0_18ck148 = 3.3 time = 1490
* CHECK dout0_19 vdout0_19ck148 = 0 time = 1490
* CHECK dout0_20 vdout0_20ck148 = 0 time = 1490
* CHECK dout0_21 vdout0_21ck148 = 3.3 time = 1490
* CHECK dout0_22 vdout0_22ck148 = 3.3 time = 1490
* CHECK dout0_23 vdout0_23ck148 = 0 time = 1490
* CHECK dout0_24 vdout0_24ck148 = 0 time = 1490
* CHECK dout0_25 vdout0_25ck148 = 3.3 time = 1490
* CHECK dout0_26 vdout0_26ck148 = 0 time = 1490
* CHECK dout0_27 vdout0_27ck148 = 3.3 time = 1490
* CHECK dout0_28 vdout0_28ck148 = 0 time = 1490
* CHECK dout0_29 vdout0_29ck148 = 0 time = 1490
* CHECK dout0_30 vdout0_30ck148 = 0 time = 1490
* CHECK dout0_31 vdout0_31ck148 = 0 time = 1490
* CHECK dout1_0 vdout1_0ck148 = 0 time = 1490
* CHECK dout1_1 vdout1_1ck148 = 0 time = 1490
* CHECK dout1_2 vdout1_2ck148 = 3.3 time = 1490
* CHECK dout1_3 vdout1_3ck148 = 0 time = 1490
* CHECK dout1_4 vdout1_4ck148 = 3.3 time = 1490
* CHECK dout1_5 vdout1_5ck148 = 0 time = 1490
* CHECK dout1_6 vdout1_6ck148 = 0 time = 1490
* CHECK dout1_7 vdout1_7ck148 = 3.3 time = 1490
* CHECK dout1_8 vdout1_8ck148 = 3.3 time = 1490
* CHECK dout1_9 vdout1_9ck148 = 0 time = 1490
* CHECK dout1_10 vdout1_10ck148 = 0 time = 1490
* CHECK dout1_11 vdout1_11ck148 = 0 time = 1490
* CHECK dout1_12 vdout1_12ck148 = 3.3 time = 1490
* CHECK dout1_13 vdout1_13ck148 = 3.3 time = 1490
* CHECK dout1_14 vdout1_14ck148 = 0 time = 1490
* CHECK dout1_15 vdout1_15ck148 = 0 time = 1490
* CHECK dout1_16 vdout1_16ck148 = 0 time = 1490
* CHECK dout1_17 vdout1_17ck148 = 3.3 time = 1490
* CHECK dout1_18 vdout1_18ck148 = 3.3 time = 1490
* CHECK dout1_19 vdout1_19ck148 = 3.3 time = 1490
* CHECK dout1_20 vdout1_20ck148 = 0 time = 1490
* CHECK dout1_21 vdout1_21ck148 = 3.3 time = 1490
* CHECK dout1_22 vdout1_22ck148 = 3.3 time = 1490
* CHECK dout1_23 vdout1_23ck148 = 0 time = 1490
* CHECK dout1_24 vdout1_24ck148 = 3.3 time = 1490
* CHECK dout1_25 vdout1_25ck148 = 0 time = 1490
* CHECK dout1_26 vdout1_26ck148 = 0 time = 1490
* CHECK dout1_27 vdout1_27ck148 = 0 time = 1490
* CHECK dout1_28 vdout1_28ck148 = 0 time = 1490
* CHECK dout1_29 vdout1_29ck148 = 0 time = 1490
* CHECK dout1_30 vdout1_30ck148 = 0 time = 1490
* CHECK dout1_31 vdout1_31ck148 = 3.3 time = 1490
* CHECK dout0_0 vdout0_0ck149 = 3.3 time = 1500
* CHECK dout0_1 vdout0_1ck149 = 0 time = 1500
* CHECK dout0_2 vdout0_2ck149 = 0 time = 1500
* CHECK dout0_3 vdout0_3ck149 = 0 time = 1500
* CHECK dout0_4 vdout0_4ck149 = 0 time = 1500
* CHECK dout0_5 vdout0_5ck149 = 0 time = 1500
* CHECK dout0_6 vdout0_6ck149 = 3.3 time = 1500
* CHECK dout0_7 vdout0_7ck149 = 3.3 time = 1500
* CHECK dout0_8 vdout0_8ck149 = 0 time = 1500
* CHECK dout0_9 vdout0_9ck149 = 0 time = 1500
* CHECK dout0_10 vdout0_10ck149 = 3.3 time = 1500
* CHECK dout0_11 vdout0_11ck149 = 0 time = 1500
* CHECK dout0_12 vdout0_12ck149 = 3.3 time = 1500
* CHECK dout0_13 vdout0_13ck149 = 3.3 time = 1500
* CHECK dout0_14 vdout0_14ck149 = 0 time = 1500
* CHECK dout0_15 vdout0_15ck149 = 3.3 time = 1500
* CHECK dout0_16 vdout0_16ck149 = 3.3 time = 1500
* CHECK dout0_17 vdout0_17ck149 = 0 time = 1500
* CHECK dout0_18 vdout0_18ck149 = 3.3 time = 1500
* CHECK dout0_19 vdout0_19ck149 = 0 time = 1500
* CHECK dout0_20 vdout0_20ck149 = 0 time = 1500
* CHECK dout0_21 vdout0_21ck149 = 3.3 time = 1500
* CHECK dout0_22 vdout0_22ck149 = 3.3 time = 1500
* CHECK dout0_23 vdout0_23ck149 = 0 time = 1500
* CHECK dout0_24 vdout0_24ck149 = 0 time = 1500
* CHECK dout0_25 vdout0_25ck149 = 3.3 time = 1500
* CHECK dout0_26 vdout0_26ck149 = 0 time = 1500
* CHECK dout0_27 vdout0_27ck149 = 3.3 time = 1500
* CHECK dout0_28 vdout0_28ck149 = 0 time = 1500
* CHECK dout0_29 vdout0_29ck149 = 0 time = 1500
* CHECK dout0_30 vdout0_30ck149 = 0 time = 1500
* CHECK dout0_31 vdout0_31ck149 = 0 time = 1500
* CHECK dout0_0 vdout0_0ck151 = 0 time = 1520
* CHECK dout0_1 vdout0_1ck151 = 0 time = 1520
* CHECK dout0_2 vdout0_2ck151 = 3.3 time = 1520
* CHECK dout0_3 vdout0_3ck151 = 0 time = 1520
* CHECK dout0_4 vdout0_4ck151 = 0 time = 1520
* CHECK dout0_5 vdout0_5ck151 = 0 time = 1520
* CHECK dout0_6 vdout0_6ck151 = 0 time = 1520
* CHECK dout0_7 vdout0_7ck151 = 3.3 time = 1520
* CHECK dout0_8 vdout0_8ck151 = 3.3 time = 1520
* CHECK dout0_9 vdout0_9ck151 = 3.3 time = 1520
* CHECK dout0_10 vdout0_10ck151 = 3.3 time = 1520
* CHECK dout0_11 vdout0_11ck151 = 3.3 time = 1520
* CHECK dout0_12 vdout0_12ck151 = 0 time = 1520
* CHECK dout0_13 vdout0_13ck151 = 0 time = 1520
* CHECK dout0_14 vdout0_14ck151 = 3.3 time = 1520
* CHECK dout0_15 vdout0_15ck151 = 0 time = 1520
* CHECK dout0_16 vdout0_16ck151 = 0 time = 1520
* CHECK dout0_17 vdout0_17ck151 = 3.3 time = 1520
* CHECK dout0_18 vdout0_18ck151 = 0 time = 1520
* CHECK dout0_19 vdout0_19ck151 = 0 time = 1520
* CHECK dout0_20 vdout0_20ck151 = 0 time = 1520
* CHECK dout0_21 vdout0_21ck151 = 0 time = 1520
* CHECK dout0_22 vdout0_22ck151 = 0 time = 1520
* CHECK dout0_23 vdout0_23ck151 = 3.3 time = 1520
* CHECK dout0_24 vdout0_24ck151 = 0 time = 1520
* CHECK dout0_25 vdout0_25ck151 = 3.3 time = 1520
* CHECK dout0_26 vdout0_26ck151 = 0 time = 1520
* CHECK dout0_27 vdout0_27ck151 = 3.3 time = 1520
* CHECK dout0_28 vdout0_28ck151 = 0 time = 1520
* CHECK dout0_29 vdout0_29ck151 = 0 time = 1520
* CHECK dout0_30 vdout0_30ck151 = 0 time = 1520
* CHECK dout0_31 vdout0_31ck151 = 0 time = 1520
* CHECK dout0_0 vdout0_0ck152 = 0 time = 1530
* CHECK dout0_1 vdout0_1ck152 = 0 time = 1530
* CHECK dout0_2 vdout0_2ck152 = 3.3 time = 1530
* CHECK dout0_3 vdout0_3ck152 = 0 time = 1530
* CHECK dout0_4 vdout0_4ck152 = 0 time = 1530
* CHECK dout0_5 vdout0_5ck152 = 0 time = 1530
* CHECK dout0_6 vdout0_6ck152 = 0 time = 1530
* CHECK dout0_7 vdout0_7ck152 = 3.3 time = 1530
* CHECK dout0_8 vdout0_8ck152 = 3.3 time = 1530
* CHECK dout0_9 vdout0_9ck152 = 3.3 time = 1530
* CHECK dout0_10 vdout0_10ck152 = 3.3 time = 1530
* CHECK dout0_11 vdout0_11ck152 = 3.3 time = 1530
* CHECK dout0_12 vdout0_12ck152 = 0 time = 1530
* CHECK dout0_13 vdout0_13ck152 = 0 time = 1530
* CHECK dout0_14 vdout0_14ck152 = 3.3 time = 1530
* CHECK dout0_15 vdout0_15ck152 = 0 time = 1530
* CHECK dout0_16 vdout0_16ck152 = 0 time = 1530
* CHECK dout0_17 vdout0_17ck152 = 3.3 time = 1530
* CHECK dout0_18 vdout0_18ck152 = 0 time = 1530
* CHECK dout0_19 vdout0_19ck152 = 0 time = 1530
* CHECK dout0_20 vdout0_20ck152 = 0 time = 1530
* CHECK dout0_21 vdout0_21ck152 = 0 time = 1530
* CHECK dout0_22 vdout0_22ck152 = 0 time = 1530
* CHECK dout0_23 vdout0_23ck152 = 3.3 time = 1530
* CHECK dout0_24 vdout0_24ck152 = 0 time = 1530
* CHECK dout0_25 vdout0_25ck152 = 3.3 time = 1530
* CHECK dout0_26 vdout0_26ck152 = 0 time = 1530
* CHECK dout0_27 vdout0_27ck152 = 3.3 time = 1530
* CHECK dout0_28 vdout0_28ck152 = 0 time = 1530
* CHECK dout0_29 vdout0_29ck152 = 0 time = 1530
* CHECK dout0_30 vdout0_30ck152 = 0 time = 1530
* CHECK dout0_31 vdout0_31ck152 = 0 time = 1530
* CHECK dout0_0 vdout0_0ck154 = 0 time = 1550
* CHECK dout0_1 vdout0_1ck154 = 0 time = 1550
* CHECK dout0_2 vdout0_2ck154 = 3.3 time = 1550
* CHECK dout0_3 vdout0_3ck154 = 0 time = 1550
* CHECK dout0_4 vdout0_4ck154 = 3.3 time = 1550
* CHECK dout0_5 vdout0_5ck154 = 0 time = 1550
* CHECK dout0_6 vdout0_6ck154 = 0 time = 1550
* CHECK dout0_7 vdout0_7ck154 = 3.3 time = 1550
* CHECK dout0_8 vdout0_8ck154 = 3.3 time = 1550
* CHECK dout0_9 vdout0_9ck154 = 0 time = 1550
* CHECK dout0_10 vdout0_10ck154 = 0 time = 1550
* CHECK dout0_11 vdout0_11ck154 = 0 time = 1550
* CHECK dout0_12 vdout0_12ck154 = 3.3 time = 1550
* CHECK dout0_13 vdout0_13ck154 = 3.3 time = 1550
* CHECK dout0_14 vdout0_14ck154 = 0 time = 1550
* CHECK dout0_15 vdout0_15ck154 = 0 time = 1550
* CHECK dout0_16 vdout0_16ck154 = 0 time = 1550
* CHECK dout0_17 vdout0_17ck154 = 3.3 time = 1550
* CHECK dout0_18 vdout0_18ck154 = 3.3 time = 1550
* CHECK dout0_19 vdout0_19ck154 = 3.3 time = 1550
* CHECK dout0_20 vdout0_20ck154 = 0 time = 1550
* CHECK dout0_21 vdout0_21ck154 = 3.3 time = 1550
* CHECK dout0_22 vdout0_22ck154 = 3.3 time = 1550
* CHECK dout0_23 vdout0_23ck154 = 0 time = 1550
* CHECK dout0_24 vdout0_24ck154 = 3.3 time = 1550
* CHECK dout0_25 vdout0_25ck154 = 0 time = 1550
* CHECK dout0_26 vdout0_26ck154 = 0 time = 1550
* CHECK dout0_27 vdout0_27ck154 = 0 time = 1550
* CHECK dout0_28 vdout0_28ck154 = 0 time = 1550
* CHECK dout0_29 vdout0_29ck154 = 0 time = 1550
* CHECK dout0_30 vdout0_30ck154 = 0 time = 1550
* CHECK dout0_31 vdout0_31ck154 = 3.3 time = 1550
* CHECK dout1_0 vdout1_0ck154 = 0 time = 1550
* CHECK dout1_1 vdout1_1ck154 = 0 time = 1550
* CHECK dout1_2 vdout1_2ck154 = 3.3 time = 1550
* CHECK dout1_3 vdout1_3ck154 = 0 time = 1550
* CHECK dout1_4 vdout1_4ck154 = 3.3 time = 1550
* CHECK dout1_5 vdout1_5ck154 = 0 time = 1550
* CHECK dout1_6 vdout1_6ck154 = 0 time = 1550
* CHECK dout1_7 vdout1_7ck154 = 3.3 time = 1550
* CHECK dout1_8 vdout1_8ck154 = 3.3 time = 1550
* CHECK dout1_9 vdout1_9ck154 = 0 time = 1550
* CHECK dout1_10 vdout1_10ck154 = 0 time = 1550
* CHECK dout1_11 vdout1_11ck154 = 0 time = 1550
* CHECK dout1_12 vdout1_12ck154 = 3.3 time = 1550
* CHECK dout1_13 vdout1_13ck154 = 3.3 time = 1550
* CHECK dout1_14 vdout1_14ck154 = 0 time = 1550
* CHECK dout1_15 vdout1_15ck154 = 0 time = 1550
* CHECK dout1_16 vdout1_16ck154 = 0 time = 1550
* CHECK dout1_17 vdout1_17ck154 = 3.3 time = 1550
* CHECK dout1_18 vdout1_18ck154 = 3.3 time = 1550
* CHECK dout1_19 vdout1_19ck154 = 3.3 time = 1550
* CHECK dout1_20 vdout1_20ck154 = 0 time = 1550
* CHECK dout1_21 vdout1_21ck154 = 3.3 time = 1550
* CHECK dout1_22 vdout1_22ck154 = 3.3 time = 1550
* CHECK dout1_23 vdout1_23ck154 = 0 time = 1550
* CHECK dout1_24 vdout1_24ck154 = 3.3 time = 1550
* CHECK dout1_25 vdout1_25ck154 = 0 time = 1550
* CHECK dout1_26 vdout1_26ck154 = 0 time = 1550
* CHECK dout1_27 vdout1_27ck154 = 0 time = 1550
* CHECK dout1_28 vdout1_28ck154 = 0 time = 1550
* CHECK dout1_29 vdout1_29ck154 = 0 time = 1550
* CHECK dout1_30 vdout1_30ck154 = 0 time = 1550
* CHECK dout1_31 vdout1_31ck154 = 3.3 time = 1550
* CHECK dout0_0 vdout0_0ck155 = 0 time = 1560
* CHECK dout0_1 vdout0_1ck155 = 0 time = 1560
* CHECK dout0_2 vdout0_2ck155 = 0 time = 1560
* CHECK dout0_3 vdout0_3ck155 = 3.3 time = 1560
* CHECK dout0_4 vdout0_4ck155 = 3.3 time = 1560
* CHECK dout0_5 vdout0_5ck155 = 0 time = 1560
* CHECK dout0_6 vdout0_6ck155 = 0 time = 1560
* CHECK dout0_7 vdout0_7ck155 = 3.3 time = 1560
* CHECK dout0_8 vdout0_8ck155 = 3.3 time = 1560
* CHECK dout0_9 vdout0_9ck155 = 3.3 time = 1560
* CHECK dout0_10 vdout0_10ck155 = 3.3 time = 1560
* CHECK dout0_11 vdout0_11ck155 = 0 time = 1560
* CHECK dout0_12 vdout0_12ck155 = 3.3 time = 1560
* CHECK dout0_13 vdout0_13ck155 = 3.3 time = 1560
* CHECK dout0_14 vdout0_14ck155 = 3.3 time = 1560
* CHECK dout0_15 vdout0_15ck155 = 3.3 time = 1560
* CHECK dout0_16 vdout0_16ck155 = 0 time = 1560
* CHECK dout0_17 vdout0_17ck155 = 0 time = 1560
* CHECK dout0_18 vdout0_18ck155 = 3.3 time = 1560
* CHECK dout0_19 vdout0_19ck155 = 0 time = 1560
* CHECK dout0_20 vdout0_20ck155 = 0 time = 1560
* CHECK dout0_21 vdout0_21ck155 = 0 time = 1560
* CHECK dout0_22 vdout0_22ck155 = 0 time = 1560
* CHECK dout0_23 vdout0_23ck155 = 0 time = 1560
* CHECK dout0_24 vdout0_24ck155 = 3.3 time = 1560
* CHECK dout0_25 vdout0_25ck155 = 3.3 time = 1560
* CHECK dout0_26 vdout0_26ck155 = 3.3 time = 1560
* CHECK dout0_27 vdout0_27ck155 = 3.3 time = 1560
* CHECK dout0_28 vdout0_28ck155 = 3.3 time = 1560
* CHECK dout0_29 vdout0_29ck155 = 0 time = 1560
* CHECK dout0_30 vdout0_30ck155 = 0 time = 1560
* CHECK dout0_31 vdout0_31ck155 = 0 time = 1560
* CHECK dout0_0 vdout0_0ck156 = 0 time = 1570
* CHECK dout0_1 vdout0_1ck156 = 0 time = 1570
* CHECK dout0_2 vdout0_2ck156 = 3.3 time = 1570
* CHECK dout0_3 vdout0_3ck156 = 0 time = 1570
* CHECK dout0_4 vdout0_4ck156 = 3.3 time = 1570
* CHECK dout0_5 vdout0_5ck156 = 0 time = 1570
* CHECK dout0_6 vdout0_6ck156 = 0 time = 1570
* CHECK dout0_7 vdout0_7ck156 = 3.3 time = 1570
* CHECK dout0_8 vdout0_8ck156 = 3.3 time = 1570
* CHECK dout0_9 vdout0_9ck156 = 0 time = 1570
* CHECK dout0_10 vdout0_10ck156 = 0 time = 1570
* CHECK dout0_11 vdout0_11ck156 = 0 time = 1570
* CHECK dout0_12 vdout0_12ck156 = 3.3 time = 1570
* CHECK dout0_13 vdout0_13ck156 = 3.3 time = 1570
* CHECK dout0_14 vdout0_14ck156 = 0 time = 1570
* CHECK dout0_15 vdout0_15ck156 = 0 time = 1570
* CHECK dout0_16 vdout0_16ck156 = 0 time = 1570
* CHECK dout0_17 vdout0_17ck156 = 3.3 time = 1570
* CHECK dout0_18 vdout0_18ck156 = 3.3 time = 1570
* CHECK dout0_19 vdout0_19ck156 = 3.3 time = 1570
* CHECK dout0_20 vdout0_20ck156 = 0 time = 1570
* CHECK dout0_21 vdout0_21ck156 = 3.3 time = 1570
* CHECK dout0_22 vdout0_22ck156 = 3.3 time = 1570
* CHECK dout0_23 vdout0_23ck156 = 0 time = 1570
* CHECK dout0_24 vdout0_24ck156 = 3.3 time = 1570
* CHECK dout0_25 vdout0_25ck156 = 0 time = 1570
* CHECK dout0_26 vdout0_26ck156 = 0 time = 1570
* CHECK dout0_27 vdout0_27ck156 = 0 time = 1570
* CHECK dout0_28 vdout0_28ck156 = 0 time = 1570
* CHECK dout0_29 vdout0_29ck156 = 0 time = 1570
* CHECK dout0_30 vdout0_30ck156 = 0 time = 1570
* CHECK dout0_31 vdout0_31ck156 = 3.3 time = 1570
* CHECK dout0_0 vdout0_0ck158 = 3.3 time = 1590
* CHECK dout0_1 vdout0_1ck158 = 0 time = 1590
* CHECK dout0_2 vdout0_2ck158 = 0 time = 1590
* CHECK dout0_3 vdout0_3ck158 = 0 time = 1590
* CHECK dout0_4 vdout0_4ck158 = 3.3 time = 1590
* CHECK dout0_5 vdout0_5ck158 = 3.3 time = 1590
* CHECK dout0_6 vdout0_6ck158 = 0 time = 1590
* CHECK dout0_7 vdout0_7ck158 = 0 time = 1590
* CHECK dout0_8 vdout0_8ck158 = 3.3 time = 1590
* CHECK dout0_9 vdout0_9ck158 = 0 time = 1590
* CHECK dout0_10 vdout0_10ck158 = 3.3 time = 1590
* CHECK dout0_11 vdout0_11ck158 = 3.3 time = 1590
* CHECK dout0_12 vdout0_12ck158 = 0 time = 1590
* CHECK dout0_13 vdout0_13ck158 = 0 time = 1590
* CHECK dout0_14 vdout0_14ck158 = 3.3 time = 1590
* CHECK dout0_15 vdout0_15ck158 = 0 time = 1590
* CHECK dout0_16 vdout0_16ck158 = 3.3 time = 1590
* CHECK dout0_17 vdout0_17ck158 = 0 time = 1590
* CHECK dout0_18 vdout0_18ck158 = 0 time = 1590
* CHECK dout0_19 vdout0_19ck158 = 3.3 time = 1590
* CHECK dout0_20 vdout0_20ck158 = 0 time = 1590
* CHECK dout0_21 vdout0_21ck158 = 0 time = 1590
* CHECK dout0_22 vdout0_22ck158 = 3.3 time = 1590
* CHECK dout0_23 vdout0_23ck158 = 0 time = 1590
* CHECK dout0_24 vdout0_24ck158 = 3.3 time = 1590
* CHECK dout0_25 vdout0_25ck158 = 0 time = 1590
* CHECK dout0_26 vdout0_26ck158 = 0 time = 1590
* CHECK dout0_27 vdout0_27ck158 = 0 time = 1590
* CHECK dout0_28 vdout0_28ck158 = 0 time = 1590
* CHECK dout0_29 vdout0_29ck158 = 0 time = 1590
* CHECK dout0_30 vdout0_30ck158 = 0 time = 1590
* CHECK dout0_31 vdout0_31ck158 = 0 time = 1590
* CHECK dout1_0 vdout1_0ck158 = 3.3 time = 1590
* CHECK dout1_1 vdout1_1ck158 = 0 time = 1590
* CHECK dout1_2 vdout1_2ck158 = 0 time = 1590
* CHECK dout1_3 vdout1_3ck158 = 3.3 time = 1590
* CHECK dout1_4 vdout1_4ck158 = 0 time = 1590
* CHECK dout1_5 vdout1_5ck158 = 0 time = 1590
* CHECK dout1_6 vdout1_6ck158 = 3.3 time = 1590
* CHECK dout1_7 vdout1_7ck158 = 3.3 time = 1590
* CHECK dout1_8 vdout1_8ck158 = 0 time = 1590
* CHECK dout1_9 vdout1_9ck158 = 0 time = 1590
* CHECK dout1_10 vdout1_10ck158 = 0 time = 1590
* CHECK dout1_11 vdout1_11ck158 = 0 time = 1590
* CHECK dout1_12 vdout1_12ck158 = 3.3 time = 1590
* CHECK dout1_13 vdout1_13ck158 = 3.3 time = 1590
* CHECK dout1_14 vdout1_14ck158 = 0 time = 1590
* CHECK dout1_15 vdout1_15ck158 = 3.3 time = 1590
* CHECK dout1_16 vdout1_16ck158 = 3.3 time = 1590
* CHECK dout1_17 vdout1_17ck158 = 3.3 time = 1590
* CHECK dout1_18 vdout1_18ck158 = 0 time = 1590
* CHECK dout1_19 vdout1_19ck158 = 0 time = 1590
* CHECK dout1_20 vdout1_20ck158 = 0 time = 1590
* CHECK dout1_21 vdout1_21ck158 = 3.3 time = 1590
* CHECK dout1_22 vdout1_22ck158 = 3.3 time = 1590
* CHECK dout1_23 vdout1_23ck158 = 3.3 time = 1590
* CHECK dout1_24 vdout1_24ck158 = 0 time = 1590
* CHECK dout1_25 vdout1_25ck158 = 0 time = 1590
* CHECK dout1_26 vdout1_26ck158 = 0 time = 1590
* CHECK dout1_27 vdout1_27ck158 = 0 time = 1590
* CHECK dout1_28 vdout1_28ck158 = 0 time = 1590
* CHECK dout1_29 vdout1_29ck158 = 3.3 time = 1590
* CHECK dout1_30 vdout1_30ck158 = 0 time = 1590
* CHECK dout1_31 vdout1_31ck158 = 0 time = 1590
* CHECK dout0_0 vdout0_0ck159 = 3.3 time = 1600
* CHECK dout0_1 vdout0_1ck159 = 0 time = 1600
* CHECK dout0_2 vdout0_2ck159 = 0 time = 1600
* CHECK dout0_3 vdout0_3ck159 = 0 time = 1600
* CHECK dout0_4 vdout0_4ck159 = 3.3 time = 1600
* CHECK dout0_5 vdout0_5ck159 = 3.3 time = 1600
* CHECK dout0_6 vdout0_6ck159 = 0 time = 1600
* CHECK dout0_7 vdout0_7ck159 = 0 time = 1600
* CHECK dout0_8 vdout0_8ck159 = 3.3 time = 1600
* CHECK dout0_9 vdout0_9ck159 = 0 time = 1600
* CHECK dout0_10 vdout0_10ck159 = 3.3 time = 1600
* CHECK dout0_11 vdout0_11ck159 = 3.3 time = 1600
* CHECK dout0_12 vdout0_12ck159 = 0 time = 1600
* CHECK dout0_13 vdout0_13ck159 = 0 time = 1600
* CHECK dout0_14 vdout0_14ck159 = 3.3 time = 1600
* CHECK dout0_15 vdout0_15ck159 = 0 time = 1600
* CHECK dout0_16 vdout0_16ck159 = 3.3 time = 1600
* CHECK dout0_17 vdout0_17ck159 = 0 time = 1600
* CHECK dout0_18 vdout0_18ck159 = 0 time = 1600
* CHECK dout0_19 vdout0_19ck159 = 3.3 time = 1600
* CHECK dout0_20 vdout0_20ck159 = 0 time = 1600
* CHECK dout0_21 vdout0_21ck159 = 0 time = 1600
* CHECK dout0_22 vdout0_22ck159 = 3.3 time = 1600
* CHECK dout0_23 vdout0_23ck159 = 0 time = 1600
* CHECK dout0_24 vdout0_24ck159 = 3.3 time = 1600
* CHECK dout0_25 vdout0_25ck159 = 0 time = 1600
* CHECK dout0_26 vdout0_26ck159 = 0 time = 1600
* CHECK dout0_27 vdout0_27ck159 = 0 time = 1600
* CHECK dout0_28 vdout0_28ck159 = 0 time = 1600
* CHECK dout0_29 vdout0_29ck159 = 0 time = 1600
* CHECK dout0_30 vdout0_30ck159 = 0 time = 1600
* CHECK dout0_31 vdout0_31ck159 = 0 time = 1600
* CHECK dout1_0 vdout1_0ck159 = 3.3 time = 1600
* CHECK dout1_1 vdout1_1ck159 = 0 time = 1600
* CHECK dout1_2 vdout1_2ck159 = 0 time = 1600
* CHECK dout1_3 vdout1_3ck159 = 0 time = 1600
* CHECK dout1_4 vdout1_4ck159 = 3.3 time = 1600
* CHECK dout1_5 vdout1_5ck159 = 3.3 time = 1600
* CHECK dout1_6 vdout1_6ck159 = 0 time = 1600
* CHECK dout1_7 vdout1_7ck159 = 0 time = 1600
* CHECK dout1_8 vdout1_8ck159 = 3.3 time = 1600
* CHECK dout1_9 vdout1_9ck159 = 0 time = 1600
* CHECK dout1_10 vdout1_10ck159 = 3.3 time = 1600
* CHECK dout1_11 vdout1_11ck159 = 3.3 time = 1600
* CHECK dout1_12 vdout1_12ck159 = 0 time = 1600
* CHECK dout1_13 vdout1_13ck159 = 0 time = 1600
* CHECK dout1_14 vdout1_14ck159 = 3.3 time = 1600
* CHECK dout1_15 vdout1_15ck159 = 0 time = 1600
* CHECK dout1_16 vdout1_16ck159 = 3.3 time = 1600
* CHECK dout1_17 vdout1_17ck159 = 0 time = 1600
* CHECK dout1_18 vdout1_18ck159 = 0 time = 1600
* CHECK dout1_19 vdout1_19ck159 = 3.3 time = 1600
* CHECK dout1_20 vdout1_20ck159 = 0 time = 1600
* CHECK dout1_21 vdout1_21ck159 = 0 time = 1600
* CHECK dout1_22 vdout1_22ck159 = 3.3 time = 1600
* CHECK dout1_23 vdout1_23ck159 = 0 time = 1600
* CHECK dout1_24 vdout1_24ck159 = 3.3 time = 1600
* CHECK dout1_25 vdout1_25ck159 = 0 time = 1600
* CHECK dout1_26 vdout1_26ck159 = 0 time = 1600
* CHECK dout1_27 vdout1_27ck159 = 0 time = 1600
* CHECK dout1_28 vdout1_28ck159 = 0 time = 1600
* CHECK dout1_29 vdout1_29ck159 = 0 time = 1600
* CHECK dout1_30 vdout1_30ck159 = 0 time = 1600
* CHECK dout1_31 vdout1_31ck159 = 0 time = 1600
* CHECK dout0_0 vdout0_0ck160 = 3.3 time = 1610
* CHECK dout0_1 vdout0_1ck160 = 0 time = 1610
* CHECK dout0_2 vdout0_2ck160 = 0 time = 1610
* CHECK dout0_3 vdout0_3ck160 = 3.3 time = 1610
* CHECK dout0_4 vdout0_4ck160 = 0 time = 1610
* CHECK dout0_5 vdout0_5ck160 = 0 time = 1610
* CHECK dout0_6 vdout0_6ck160 = 3.3 time = 1610
* CHECK dout0_7 vdout0_7ck160 = 3.3 time = 1610
* CHECK dout0_8 vdout0_8ck160 = 0 time = 1610
* CHECK dout0_9 vdout0_9ck160 = 0 time = 1610
* CHECK dout0_10 vdout0_10ck160 = 0 time = 1610
* CHECK dout0_11 vdout0_11ck160 = 0 time = 1610
* CHECK dout0_12 vdout0_12ck160 = 3.3 time = 1610
* CHECK dout0_13 vdout0_13ck160 = 3.3 time = 1610
* CHECK dout0_14 vdout0_14ck160 = 0 time = 1610
* CHECK dout0_15 vdout0_15ck160 = 3.3 time = 1610
* CHECK dout0_16 vdout0_16ck160 = 3.3 time = 1610
* CHECK dout0_17 vdout0_17ck160 = 3.3 time = 1610
* CHECK dout0_18 vdout0_18ck160 = 0 time = 1610
* CHECK dout0_19 vdout0_19ck160 = 0 time = 1610
* CHECK dout0_20 vdout0_20ck160 = 0 time = 1610
* CHECK dout0_21 vdout0_21ck160 = 3.3 time = 1610
* CHECK dout0_22 vdout0_22ck160 = 3.3 time = 1610
* CHECK dout0_23 vdout0_23ck160 = 3.3 time = 1610
* CHECK dout0_24 vdout0_24ck160 = 0 time = 1610
* CHECK dout0_25 vdout0_25ck160 = 0 time = 1610
* CHECK dout0_26 vdout0_26ck160 = 0 time = 1610
* CHECK dout0_27 vdout0_27ck160 = 0 time = 1610
* CHECK dout0_28 vdout0_28ck160 = 0 time = 1610
* CHECK dout0_29 vdout0_29ck160 = 3.3 time = 1610
* CHECK dout0_30 vdout0_30ck160 = 0 time = 1610
* CHECK dout0_31 vdout0_31ck160 = 0 time = 1610
* CHECK dout0_0 vdout0_0ck161 = 3.3 time = 1620
* CHECK dout0_1 vdout0_1ck161 = 0 time = 1620
* CHECK dout0_2 vdout0_2ck161 = 0 time = 1620
* CHECK dout0_3 vdout0_3ck161 = 0 time = 1620
* CHECK dout0_4 vdout0_4ck161 = 3.3 time = 1620
* CHECK dout0_5 vdout0_5ck161 = 3.3 time = 1620
* CHECK dout0_6 vdout0_6ck161 = 0 time = 1620
* CHECK dout0_7 vdout0_7ck161 = 0 time = 1620
* CHECK dout0_8 vdout0_8ck161 = 3.3 time = 1620
* CHECK dout0_9 vdout0_9ck161 = 0 time = 1620
* CHECK dout0_10 vdout0_10ck161 = 3.3 time = 1620
* CHECK dout0_11 vdout0_11ck161 = 3.3 time = 1620
* CHECK dout0_12 vdout0_12ck161 = 0 time = 1620
* CHECK dout0_13 vdout0_13ck161 = 0 time = 1620
* CHECK dout0_14 vdout0_14ck161 = 3.3 time = 1620
* CHECK dout0_15 vdout0_15ck161 = 0 time = 1620
* CHECK dout0_16 vdout0_16ck161 = 3.3 time = 1620
* CHECK dout0_17 vdout0_17ck161 = 0 time = 1620
* CHECK dout0_18 vdout0_18ck161 = 0 time = 1620
* CHECK dout0_19 vdout0_19ck161 = 3.3 time = 1620
* CHECK dout0_20 vdout0_20ck161 = 0 time = 1620
* CHECK dout0_21 vdout0_21ck161 = 0 time = 1620
* CHECK dout0_22 vdout0_22ck161 = 3.3 time = 1620
* CHECK dout0_23 vdout0_23ck161 = 0 time = 1620
* CHECK dout0_24 vdout0_24ck161 = 3.3 time = 1620
* CHECK dout0_25 vdout0_25ck161 = 0 time = 1620
* CHECK dout0_26 vdout0_26ck161 = 0 time = 1620
* CHECK dout0_27 vdout0_27ck161 = 0 time = 1620
* CHECK dout0_28 vdout0_28ck161 = 0 time = 1620
* CHECK dout0_29 vdout0_29ck161 = 0 time = 1620
* CHECK dout0_30 vdout0_30ck161 = 0 time = 1620
* CHECK dout0_31 vdout0_31ck161 = 0 time = 1620
* CHECK dout1_0 vdout1_0ck161 = 3.3 time = 1620
* CHECK dout1_1 vdout1_1ck161 = 3.3 time = 1620
* CHECK dout1_2 vdout1_2ck161 = 0 time = 1620
* CHECK dout1_3 vdout1_3ck161 = 0 time = 1620
* CHECK dout1_4 vdout1_4ck161 = 3.3 time = 1620
* CHECK dout1_5 vdout1_5ck161 = 3.3 time = 1620
* CHECK dout1_6 vdout1_6ck161 = 3.3 time = 1620
* CHECK dout1_7 vdout1_7ck161 = 3.3 time = 1620
* CHECK dout1_8 vdout1_8ck161 = 3.3 time = 1620
* CHECK dout1_9 vdout1_9ck161 = 3.3 time = 1620
* CHECK dout1_10 vdout1_10ck161 = 0 time = 1620
* CHECK dout1_11 vdout1_11ck161 = 0 time = 1620
* CHECK dout1_12 vdout1_12ck161 = 0 time = 1620
* CHECK dout1_13 vdout1_13ck161 = 3.3 time = 1620
* CHECK dout1_14 vdout1_14ck161 = 0 time = 1620
* CHECK dout1_15 vdout1_15ck161 = 3.3 time = 1620
* CHECK dout1_16 vdout1_16ck161 = 0 time = 1620
* CHECK dout1_17 vdout1_17ck161 = 0 time = 1620
* CHECK dout1_18 vdout1_18ck161 = 0 time = 1620
* CHECK dout1_19 vdout1_19ck161 = 0 time = 1620
* CHECK dout1_20 vdout1_20ck161 = 0 time = 1620
* CHECK dout1_21 vdout1_21ck161 = 0 time = 1620
* CHECK dout1_22 vdout1_22ck161 = 3.3 time = 1620
* CHECK dout1_23 vdout1_23ck161 = 0 time = 1620
* CHECK dout1_24 vdout1_24ck161 = 0 time = 1620
* CHECK dout1_25 vdout1_25ck161 = 0 time = 1620
* CHECK dout1_26 vdout1_26ck161 = 0 time = 1620
* CHECK dout1_27 vdout1_27ck161 = 3.3 time = 1620
* CHECK dout1_28 vdout1_28ck161 = 0 time = 1620
* CHECK dout1_29 vdout1_29ck161 = 0 time = 1620
* CHECK dout1_30 vdout1_30ck161 = 3.3 time = 1620
* CHECK dout1_31 vdout1_31ck161 = 3.3 time = 1620
* CHECK dout0_0 vdout0_0ck162 = 3.3 time = 1630
* CHECK dout0_1 vdout0_1ck162 = 0 time = 1630
* CHECK dout0_2 vdout0_2ck162 = 0 time = 1630
* CHECK dout0_3 vdout0_3ck162 = 0 time = 1630
* CHECK dout0_4 vdout0_4ck162 = 3.3 time = 1630
* CHECK dout0_5 vdout0_5ck162 = 3.3 time = 1630
* CHECK dout0_6 vdout0_6ck162 = 0 time = 1630
* CHECK dout0_7 vdout0_7ck162 = 0 time = 1630
* CHECK dout0_8 vdout0_8ck162 = 3.3 time = 1630
* CHECK dout0_9 vdout0_9ck162 = 0 time = 1630
* CHECK dout0_10 vdout0_10ck162 = 3.3 time = 1630
* CHECK dout0_11 vdout0_11ck162 = 3.3 time = 1630
* CHECK dout0_12 vdout0_12ck162 = 0 time = 1630
* CHECK dout0_13 vdout0_13ck162 = 0 time = 1630
* CHECK dout0_14 vdout0_14ck162 = 3.3 time = 1630
* CHECK dout0_15 vdout0_15ck162 = 0 time = 1630
* CHECK dout0_16 vdout0_16ck162 = 3.3 time = 1630
* CHECK dout0_17 vdout0_17ck162 = 0 time = 1630
* CHECK dout0_18 vdout0_18ck162 = 0 time = 1630
* CHECK dout0_19 vdout0_19ck162 = 3.3 time = 1630
* CHECK dout0_20 vdout0_20ck162 = 0 time = 1630
* CHECK dout0_21 vdout0_21ck162 = 0 time = 1630
* CHECK dout0_22 vdout0_22ck162 = 3.3 time = 1630
* CHECK dout0_23 vdout0_23ck162 = 0 time = 1630
* CHECK dout0_24 vdout0_24ck162 = 3.3 time = 1630
* CHECK dout0_25 vdout0_25ck162 = 0 time = 1630
* CHECK dout0_26 vdout0_26ck162 = 0 time = 1630
* CHECK dout0_27 vdout0_27ck162 = 0 time = 1630
* CHECK dout0_28 vdout0_28ck162 = 0 time = 1630
* CHECK dout0_29 vdout0_29ck162 = 0 time = 1630
* CHECK dout0_30 vdout0_30ck162 = 0 time = 1630
* CHECK dout0_31 vdout0_31ck162 = 0 time = 1630
* CHECK dout0_0 vdout0_0ck163 = 3.3 time = 1640
* CHECK dout0_1 vdout0_1ck163 = 3.3 time = 1640
* CHECK dout0_2 vdout0_2ck163 = 0 time = 1640
* CHECK dout0_3 vdout0_3ck163 = 0 time = 1640
* CHECK dout0_4 vdout0_4ck163 = 3.3 time = 1640
* CHECK dout0_5 vdout0_5ck163 = 3.3 time = 1640
* CHECK dout0_6 vdout0_6ck163 = 3.3 time = 1640
* CHECK dout0_7 vdout0_7ck163 = 3.3 time = 1640
* CHECK dout0_8 vdout0_8ck163 = 3.3 time = 1640
* CHECK dout0_9 vdout0_9ck163 = 3.3 time = 1640
* CHECK dout0_10 vdout0_10ck163 = 0 time = 1640
* CHECK dout0_11 vdout0_11ck163 = 0 time = 1640
* CHECK dout0_12 vdout0_12ck163 = 0 time = 1640
* CHECK dout0_13 vdout0_13ck163 = 3.3 time = 1640
* CHECK dout0_14 vdout0_14ck163 = 0 time = 1640
* CHECK dout0_15 vdout0_15ck163 = 3.3 time = 1640
* CHECK dout0_16 vdout0_16ck163 = 0 time = 1640
* CHECK dout0_17 vdout0_17ck163 = 0 time = 1640
* CHECK dout0_18 vdout0_18ck163 = 0 time = 1640
* CHECK dout0_19 vdout0_19ck163 = 0 time = 1640
* CHECK dout0_20 vdout0_20ck163 = 0 time = 1640
* CHECK dout0_21 vdout0_21ck163 = 0 time = 1640
* CHECK dout0_22 vdout0_22ck163 = 3.3 time = 1640
* CHECK dout0_23 vdout0_23ck163 = 0 time = 1640
* CHECK dout0_24 vdout0_24ck163 = 0 time = 1640
* CHECK dout0_25 vdout0_25ck163 = 0 time = 1640
* CHECK dout0_26 vdout0_26ck163 = 0 time = 1640
* CHECK dout0_27 vdout0_27ck163 = 3.3 time = 1640
* CHECK dout0_28 vdout0_28ck163 = 0 time = 1640
* CHECK dout0_29 vdout0_29ck163 = 0 time = 1640
* CHECK dout0_30 vdout0_30ck163 = 3.3 time = 1640
* CHECK dout0_31 vdout0_31ck163 = 3.3 time = 1640
* CHECK dout1_0 vdout1_0ck163 = 3.3 time = 1640
* CHECK dout1_1 vdout1_1ck163 = 0 time = 1640
* CHECK dout1_2 vdout1_2ck163 = 0 time = 1640
* CHECK dout1_3 vdout1_3ck163 = 0 time = 1640
* CHECK dout1_4 vdout1_4ck163 = 3.3 time = 1640
* CHECK dout1_5 vdout1_5ck163 = 3.3 time = 1640
* CHECK dout1_6 vdout1_6ck163 = 0 time = 1640
* CHECK dout1_7 vdout1_7ck163 = 0 time = 1640
* CHECK dout1_8 vdout1_8ck163 = 3.3 time = 1640
* CHECK dout1_9 vdout1_9ck163 = 0 time = 1640
* CHECK dout1_10 vdout1_10ck163 = 3.3 time = 1640
* CHECK dout1_11 vdout1_11ck163 = 3.3 time = 1640
* CHECK dout1_12 vdout1_12ck163 = 0 time = 1640
* CHECK dout1_13 vdout1_13ck163 = 0 time = 1640
* CHECK dout1_14 vdout1_14ck163 = 3.3 time = 1640
* CHECK dout1_15 vdout1_15ck163 = 0 time = 1640
* CHECK dout1_16 vdout1_16ck163 = 3.3 time = 1640
* CHECK dout1_17 vdout1_17ck163 = 0 time = 1640
* CHECK dout1_18 vdout1_18ck163 = 0 time = 1640
* CHECK dout1_19 vdout1_19ck163 = 3.3 time = 1640
* CHECK dout1_20 vdout1_20ck163 = 0 time = 1640
* CHECK dout1_21 vdout1_21ck163 = 0 time = 1640
* CHECK dout1_22 vdout1_22ck163 = 3.3 time = 1640
* CHECK dout1_23 vdout1_23ck163 = 0 time = 1640
* CHECK dout1_24 vdout1_24ck163 = 3.3 time = 1640
* CHECK dout1_25 vdout1_25ck163 = 0 time = 1640
* CHECK dout1_26 vdout1_26ck163 = 0 time = 1640
* CHECK dout1_27 vdout1_27ck163 = 0 time = 1640
* CHECK dout1_28 vdout1_28ck163 = 0 time = 1640
* CHECK dout1_29 vdout1_29ck163 = 0 time = 1640
* CHECK dout1_30 vdout1_30ck163 = 0 time = 1640
* CHECK dout1_31 vdout1_31ck163 = 0 time = 1640
* CHECK dout0_0 vdout0_0ck164 = 3.3 time = 1650
* CHECK dout0_1 vdout0_1ck164 = 3.3 time = 1650
* CHECK dout0_2 vdout0_2ck164 = 0 time = 1650
* CHECK dout0_3 vdout0_3ck164 = 0 time = 1650
* CHECK dout0_4 vdout0_4ck164 = 3.3 time = 1650
* CHECK dout0_5 vdout0_5ck164 = 3.3 time = 1650
* CHECK dout0_6 vdout0_6ck164 = 3.3 time = 1650
* CHECK dout0_7 vdout0_7ck164 = 3.3 time = 1650
* CHECK dout0_8 vdout0_8ck164 = 3.3 time = 1650
* CHECK dout0_9 vdout0_9ck164 = 3.3 time = 1650
* CHECK dout0_10 vdout0_10ck164 = 0 time = 1650
* CHECK dout0_11 vdout0_11ck164 = 0 time = 1650
* CHECK dout0_12 vdout0_12ck164 = 0 time = 1650
* CHECK dout0_13 vdout0_13ck164 = 3.3 time = 1650
* CHECK dout0_14 vdout0_14ck164 = 0 time = 1650
* CHECK dout0_15 vdout0_15ck164 = 3.3 time = 1650
* CHECK dout0_16 vdout0_16ck164 = 0 time = 1650
* CHECK dout0_17 vdout0_17ck164 = 0 time = 1650
* CHECK dout0_18 vdout0_18ck164 = 0 time = 1650
* CHECK dout0_19 vdout0_19ck164 = 0 time = 1650
* CHECK dout0_20 vdout0_20ck164 = 0 time = 1650
* CHECK dout0_21 vdout0_21ck164 = 0 time = 1650
* CHECK dout0_22 vdout0_22ck164 = 3.3 time = 1650
* CHECK dout0_23 vdout0_23ck164 = 0 time = 1650
* CHECK dout0_24 vdout0_24ck164 = 0 time = 1650
* CHECK dout0_25 vdout0_25ck164 = 0 time = 1650
* CHECK dout0_26 vdout0_26ck164 = 0 time = 1650
* CHECK dout0_27 vdout0_27ck164 = 3.3 time = 1650
* CHECK dout0_28 vdout0_28ck164 = 0 time = 1650
* CHECK dout0_29 vdout0_29ck164 = 0 time = 1650
* CHECK dout0_30 vdout0_30ck164 = 3.3 time = 1650
* CHECK dout0_31 vdout0_31ck164 = 3.3 time = 1650
* CHECK dout1_0 vdout1_0ck164 = 3.3 time = 1650
* CHECK dout1_1 vdout1_1ck164 = 0 time = 1650
* CHECK dout1_2 vdout1_2ck164 = 0 time = 1650
* CHECK dout1_3 vdout1_3ck164 = 0 time = 1650
* CHECK dout1_4 vdout1_4ck164 = 3.3 time = 1650
* CHECK dout1_5 vdout1_5ck164 = 3.3 time = 1650
* CHECK dout1_6 vdout1_6ck164 = 0 time = 1650
* CHECK dout1_7 vdout1_7ck164 = 0 time = 1650
* CHECK dout1_8 vdout1_8ck164 = 3.3 time = 1650
* CHECK dout1_9 vdout1_9ck164 = 0 time = 1650
* CHECK dout1_10 vdout1_10ck164 = 3.3 time = 1650
* CHECK dout1_11 vdout1_11ck164 = 3.3 time = 1650
* CHECK dout1_12 vdout1_12ck164 = 0 time = 1650
* CHECK dout1_13 vdout1_13ck164 = 0 time = 1650
* CHECK dout1_14 vdout1_14ck164 = 3.3 time = 1650
* CHECK dout1_15 vdout1_15ck164 = 0 time = 1650
* CHECK dout1_16 vdout1_16ck164 = 3.3 time = 1650
* CHECK dout1_17 vdout1_17ck164 = 0 time = 1650
* CHECK dout1_18 vdout1_18ck164 = 0 time = 1650
* CHECK dout1_19 vdout1_19ck164 = 3.3 time = 1650
* CHECK dout1_20 vdout1_20ck164 = 0 time = 1650
* CHECK dout1_21 vdout1_21ck164 = 0 time = 1650
* CHECK dout1_22 vdout1_22ck164 = 3.3 time = 1650
* CHECK dout1_23 vdout1_23ck164 = 0 time = 1650
* CHECK dout1_24 vdout1_24ck164 = 3.3 time = 1650
* CHECK dout1_25 vdout1_25ck164 = 0 time = 1650
* CHECK dout1_26 vdout1_26ck164 = 0 time = 1650
* CHECK dout1_27 vdout1_27ck164 = 0 time = 1650
* CHECK dout1_28 vdout1_28ck164 = 0 time = 1650
* CHECK dout1_29 vdout1_29ck164 = 0 time = 1650
* CHECK dout1_30 vdout1_30ck164 = 0 time = 1650
* CHECK dout1_31 vdout1_31ck164 = 0 time = 1650
* CHECK dout1_0 vdout1_0ck165 = 3.3 time = 1660
* CHECK dout1_1 vdout1_1ck165 = 0 time = 1660
* CHECK dout1_2 vdout1_2ck165 = 0 time = 1660
* CHECK dout1_3 vdout1_3ck165 = 0 time = 1660
* CHECK dout1_4 vdout1_4ck165 = 3.3 time = 1660
* CHECK dout1_5 vdout1_5ck165 = 3.3 time = 1660
* CHECK dout1_6 vdout1_6ck165 = 0 time = 1660
* CHECK dout1_7 vdout1_7ck165 = 0 time = 1660
* CHECK dout1_8 vdout1_8ck165 = 3.3 time = 1660
* CHECK dout1_9 vdout1_9ck165 = 0 time = 1660
* CHECK dout1_10 vdout1_10ck165 = 3.3 time = 1660
* CHECK dout1_11 vdout1_11ck165 = 3.3 time = 1660
* CHECK dout1_12 vdout1_12ck165 = 0 time = 1660
* CHECK dout1_13 vdout1_13ck165 = 0 time = 1660
* CHECK dout1_14 vdout1_14ck165 = 3.3 time = 1660
* CHECK dout1_15 vdout1_15ck165 = 0 time = 1660
* CHECK dout1_16 vdout1_16ck165 = 3.3 time = 1660
* CHECK dout1_17 vdout1_17ck165 = 0 time = 1660
* CHECK dout1_18 vdout1_18ck165 = 0 time = 1660
* CHECK dout1_19 vdout1_19ck165 = 3.3 time = 1660
* CHECK dout1_20 vdout1_20ck165 = 0 time = 1660
* CHECK dout1_21 vdout1_21ck165 = 0 time = 1660
* CHECK dout1_22 vdout1_22ck165 = 3.3 time = 1660
* CHECK dout1_23 vdout1_23ck165 = 0 time = 1660
* CHECK dout1_24 vdout1_24ck165 = 3.3 time = 1660
* CHECK dout1_25 vdout1_25ck165 = 0 time = 1660
* CHECK dout1_26 vdout1_26ck165 = 0 time = 1660
* CHECK dout1_27 vdout1_27ck165 = 0 time = 1660
* CHECK dout1_28 vdout1_28ck165 = 0 time = 1660
* CHECK dout1_29 vdout1_29ck165 = 0 time = 1660
* CHECK dout1_30 vdout1_30ck165 = 0 time = 1660
* CHECK dout1_31 vdout1_31ck165 = 0 time = 1660
* CHECK dout0_0 vdout0_0ck167 = 3.3 time = 1680
* CHECK dout0_1 vdout0_1ck167 = 0 time = 1680
* CHECK dout0_2 vdout0_2ck167 = 3.3 time = 1680
* CHECK dout0_3 vdout0_3ck167 = 3.3 time = 1680
* CHECK dout0_4 vdout0_4ck167 = 0 time = 1680
* CHECK dout0_5 vdout0_5ck167 = 3.3 time = 1680
* CHECK dout0_6 vdout0_6ck167 = 3.3 time = 1680
* CHECK dout0_7 vdout0_7ck167 = 0 time = 1680
* CHECK dout0_8 vdout0_8ck167 = 0 time = 1680
* CHECK dout0_9 vdout0_9ck167 = 3.3 time = 1680
* CHECK dout0_10 vdout0_10ck167 = 0 time = 1680
* CHECK dout0_11 vdout0_11ck167 = 3.3 time = 1680
* CHECK dout0_12 vdout0_12ck167 = 0 time = 1680
* CHECK dout0_13 vdout0_13ck167 = 3.3 time = 1680
* CHECK dout0_14 vdout0_14ck167 = 0 time = 1680
* CHECK dout0_15 vdout0_15ck167 = 3.3 time = 1680
* CHECK dout0_16 vdout0_16ck167 = 3.3 time = 1680
* CHECK dout0_17 vdout0_17ck167 = 3.3 time = 1680
* CHECK dout0_18 vdout0_18ck167 = 3.3 time = 1680
* CHECK dout0_19 vdout0_19ck167 = 0 time = 1680
* CHECK dout0_20 vdout0_20ck167 = 3.3 time = 1680
* CHECK dout0_21 vdout0_21ck167 = 3.3 time = 1680
* CHECK dout0_22 vdout0_22ck167 = 0 time = 1680
* CHECK dout0_23 vdout0_23ck167 = 3.3 time = 1680
* CHECK dout0_24 vdout0_24ck167 = 3.3 time = 1680
* CHECK dout0_25 vdout0_25ck167 = 0 time = 1680
* CHECK dout0_26 vdout0_26ck167 = 0 time = 1680
* CHECK dout0_27 vdout0_27ck167 = 3.3 time = 1680
* CHECK dout0_28 vdout0_28ck167 = 3.3 time = 1680
* CHECK dout0_29 vdout0_29ck167 = 0 time = 1680
* CHECK dout0_30 vdout0_30ck167 = 3.3 time = 1680
* CHECK dout0_31 vdout0_31ck167 = 0 time = 1680
* CHECK dout1_0 vdout1_0ck167 = 3.3 time = 1680
* CHECK dout1_1 vdout1_1ck167 = 3.3 time = 1680
* CHECK dout1_2 vdout1_2ck167 = 0 time = 1680
* CHECK dout1_3 vdout1_3ck167 = 0 time = 1680
* CHECK dout1_4 vdout1_4ck167 = 3.3 time = 1680
* CHECK dout1_5 vdout1_5ck167 = 3.3 time = 1680
* CHECK dout1_6 vdout1_6ck167 = 3.3 time = 1680
* CHECK dout1_7 vdout1_7ck167 = 3.3 time = 1680
* CHECK dout1_8 vdout1_8ck167 = 3.3 time = 1680
* CHECK dout1_9 vdout1_9ck167 = 3.3 time = 1680
* CHECK dout1_10 vdout1_10ck167 = 0 time = 1680
* CHECK dout1_11 vdout1_11ck167 = 0 time = 1680
* CHECK dout1_12 vdout1_12ck167 = 0 time = 1680
* CHECK dout1_13 vdout1_13ck167 = 3.3 time = 1680
* CHECK dout1_14 vdout1_14ck167 = 0 time = 1680
* CHECK dout1_15 vdout1_15ck167 = 3.3 time = 1680
* CHECK dout1_16 vdout1_16ck167 = 0 time = 1680
* CHECK dout1_17 vdout1_17ck167 = 0 time = 1680
* CHECK dout1_18 vdout1_18ck167 = 0 time = 1680
* CHECK dout1_19 vdout1_19ck167 = 0 time = 1680
* CHECK dout1_20 vdout1_20ck167 = 0 time = 1680
* CHECK dout1_21 vdout1_21ck167 = 0 time = 1680
* CHECK dout1_22 vdout1_22ck167 = 3.3 time = 1680
* CHECK dout1_23 vdout1_23ck167 = 0 time = 1680
* CHECK dout1_24 vdout1_24ck167 = 0 time = 1680
* CHECK dout1_25 vdout1_25ck167 = 0 time = 1680
* CHECK dout1_26 vdout1_26ck167 = 0 time = 1680
* CHECK dout1_27 vdout1_27ck167 = 3.3 time = 1680
* CHECK dout1_28 vdout1_28ck167 = 0 time = 1680
* CHECK dout1_29 vdout1_29ck167 = 0 time = 1680
* CHECK dout1_30 vdout1_30ck167 = 3.3 time = 1680
* CHECK dout1_31 vdout1_31ck167 = 3.3 time = 1680
* CHECK dout0_0 vdout0_0ck168 = 3.3 time = 1690
* CHECK dout0_1 vdout0_1ck168 = 3.3 time = 1690
* CHECK dout0_2 vdout0_2ck168 = 0 time = 1690
* CHECK dout0_3 vdout0_3ck168 = 0 time = 1690
* CHECK dout0_4 vdout0_4ck168 = 3.3 time = 1690
* CHECK dout0_5 vdout0_5ck168 = 3.3 time = 1690
* CHECK dout0_6 vdout0_6ck168 = 3.3 time = 1690
* CHECK dout0_7 vdout0_7ck168 = 3.3 time = 1690
* CHECK dout0_8 vdout0_8ck168 = 3.3 time = 1690
* CHECK dout0_9 vdout0_9ck168 = 3.3 time = 1690
* CHECK dout0_10 vdout0_10ck168 = 0 time = 1690
* CHECK dout0_11 vdout0_11ck168 = 0 time = 1690
* CHECK dout0_12 vdout0_12ck168 = 0 time = 1690
* CHECK dout0_13 vdout0_13ck168 = 3.3 time = 1690
* CHECK dout0_14 vdout0_14ck168 = 0 time = 1690
* CHECK dout0_15 vdout0_15ck168 = 3.3 time = 1690
* CHECK dout0_16 vdout0_16ck168 = 0 time = 1690
* CHECK dout0_17 vdout0_17ck168 = 0 time = 1690
* CHECK dout0_18 vdout0_18ck168 = 0 time = 1690
* CHECK dout0_19 vdout0_19ck168 = 0 time = 1690
* CHECK dout0_20 vdout0_20ck168 = 0 time = 1690
* CHECK dout0_21 vdout0_21ck168 = 0 time = 1690
* CHECK dout0_22 vdout0_22ck168 = 3.3 time = 1690
* CHECK dout0_23 vdout0_23ck168 = 0 time = 1690
* CHECK dout0_24 vdout0_24ck168 = 0 time = 1690
* CHECK dout0_25 vdout0_25ck168 = 0 time = 1690
* CHECK dout0_26 vdout0_26ck168 = 0 time = 1690
* CHECK dout0_27 vdout0_27ck168 = 3.3 time = 1690
* CHECK dout0_28 vdout0_28ck168 = 0 time = 1690
* CHECK dout0_29 vdout0_29ck168 = 0 time = 1690
* CHECK dout0_30 vdout0_30ck168 = 3.3 time = 1690
* CHECK dout0_31 vdout0_31ck168 = 3.3 time = 1690
* CHECK dout1_0 vdout1_0ck168 = 3.3 time = 1690
* CHECK dout1_1 vdout1_1ck168 = 3.3 time = 1690
* CHECK dout1_2 vdout1_2ck168 = 0 time = 1690
* CHECK dout1_3 vdout1_3ck168 = 0 time = 1690
* CHECK dout1_4 vdout1_4ck168 = 3.3 time = 1690
* CHECK dout1_5 vdout1_5ck168 = 3.3 time = 1690
* CHECK dout1_6 vdout1_6ck168 = 3.3 time = 1690
* CHECK dout1_7 vdout1_7ck168 = 3.3 time = 1690
* CHECK dout1_8 vdout1_8ck168 = 3.3 time = 1690
* CHECK dout1_9 vdout1_9ck168 = 3.3 time = 1690
* CHECK dout1_10 vdout1_10ck168 = 0 time = 1690
* CHECK dout1_11 vdout1_11ck168 = 0 time = 1690
* CHECK dout1_12 vdout1_12ck168 = 0 time = 1690
* CHECK dout1_13 vdout1_13ck168 = 3.3 time = 1690
* CHECK dout1_14 vdout1_14ck168 = 0 time = 1690
* CHECK dout1_15 vdout1_15ck168 = 3.3 time = 1690
* CHECK dout1_16 vdout1_16ck168 = 0 time = 1690
* CHECK dout1_17 vdout1_17ck168 = 0 time = 1690
* CHECK dout1_18 vdout1_18ck168 = 0 time = 1690
* CHECK dout1_19 vdout1_19ck168 = 0 time = 1690
* CHECK dout1_20 vdout1_20ck168 = 0 time = 1690
* CHECK dout1_21 vdout1_21ck168 = 0 time = 1690
* CHECK dout1_22 vdout1_22ck168 = 3.3 time = 1690
* CHECK dout1_23 vdout1_23ck168 = 0 time = 1690
* CHECK dout1_24 vdout1_24ck168 = 0 time = 1690
* CHECK dout1_25 vdout1_25ck168 = 0 time = 1690
* CHECK dout1_26 vdout1_26ck168 = 0 time = 1690
* CHECK dout1_27 vdout1_27ck168 = 3.3 time = 1690
* CHECK dout1_28 vdout1_28ck168 = 0 time = 1690
* CHECK dout1_29 vdout1_29ck168 = 0 time = 1690
* CHECK dout1_30 vdout1_30ck168 = 3.3 time = 1690
* CHECK dout1_31 vdout1_31ck168 = 3.3 time = 1690
* CHECK dout0_0 vdout0_0ck169 = 3.3 time = 1700
* CHECK dout0_1 vdout0_1ck169 = 3.3 time = 1700
* CHECK dout0_2 vdout0_2ck169 = 0 time = 1700
* CHECK dout0_3 vdout0_3ck169 = 0 time = 1700
* CHECK dout0_4 vdout0_4ck169 = 3.3 time = 1700
* CHECK dout0_5 vdout0_5ck169 = 3.3 time = 1700
* CHECK dout0_6 vdout0_6ck169 = 3.3 time = 1700
* CHECK dout0_7 vdout0_7ck169 = 3.3 time = 1700
* CHECK dout0_8 vdout0_8ck169 = 3.3 time = 1700
* CHECK dout0_9 vdout0_9ck169 = 3.3 time = 1700
* CHECK dout0_10 vdout0_10ck169 = 0 time = 1700
* CHECK dout0_11 vdout0_11ck169 = 0 time = 1700
* CHECK dout0_12 vdout0_12ck169 = 0 time = 1700
* CHECK dout0_13 vdout0_13ck169 = 3.3 time = 1700
* CHECK dout0_14 vdout0_14ck169 = 0 time = 1700
* CHECK dout0_15 vdout0_15ck169 = 3.3 time = 1700
* CHECK dout0_16 vdout0_16ck169 = 0 time = 1700
* CHECK dout0_17 vdout0_17ck169 = 0 time = 1700
* CHECK dout0_18 vdout0_18ck169 = 0 time = 1700
* CHECK dout0_19 vdout0_19ck169 = 0 time = 1700
* CHECK dout0_20 vdout0_20ck169 = 0 time = 1700
* CHECK dout0_21 vdout0_21ck169 = 0 time = 1700
* CHECK dout0_22 vdout0_22ck169 = 3.3 time = 1700
* CHECK dout0_23 vdout0_23ck169 = 0 time = 1700
* CHECK dout0_24 vdout0_24ck169 = 0 time = 1700
* CHECK dout0_25 vdout0_25ck169 = 0 time = 1700
* CHECK dout0_26 vdout0_26ck169 = 0 time = 1700
* CHECK dout0_27 vdout0_27ck169 = 3.3 time = 1700
* CHECK dout0_28 vdout0_28ck169 = 0 time = 1700
* CHECK dout0_29 vdout0_29ck169 = 0 time = 1700
* CHECK dout0_30 vdout0_30ck169 = 3.3 time = 1700
* CHECK dout0_31 vdout0_31ck169 = 3.3 time = 1700
* CHECK dout0_0 vdout0_0ck170 = 3.3 time = 1710
* CHECK dout0_1 vdout0_1ck170 = 3.3 time = 1710
* CHECK dout0_2 vdout0_2ck170 = 0 time = 1710
* CHECK dout0_3 vdout0_3ck170 = 0 time = 1710
* CHECK dout0_4 vdout0_4ck170 = 3.3 time = 1710
* CHECK dout0_5 vdout0_5ck170 = 3.3 time = 1710
* CHECK dout0_6 vdout0_6ck170 = 3.3 time = 1710
* CHECK dout0_7 vdout0_7ck170 = 3.3 time = 1710
* CHECK dout0_8 vdout0_8ck170 = 3.3 time = 1710
* CHECK dout0_9 vdout0_9ck170 = 3.3 time = 1710
* CHECK dout0_10 vdout0_10ck170 = 0 time = 1710
* CHECK dout0_11 vdout0_11ck170 = 0 time = 1710
* CHECK dout0_12 vdout0_12ck170 = 0 time = 1710
* CHECK dout0_13 vdout0_13ck170 = 3.3 time = 1710
* CHECK dout0_14 vdout0_14ck170 = 0 time = 1710
* CHECK dout0_15 vdout0_15ck170 = 3.3 time = 1710
* CHECK dout0_16 vdout0_16ck170 = 0 time = 1710
* CHECK dout0_17 vdout0_17ck170 = 0 time = 1710
* CHECK dout0_18 vdout0_18ck170 = 0 time = 1710
* CHECK dout0_19 vdout0_19ck170 = 0 time = 1710
* CHECK dout0_20 vdout0_20ck170 = 0 time = 1710
* CHECK dout0_21 vdout0_21ck170 = 0 time = 1710
* CHECK dout0_22 vdout0_22ck170 = 3.3 time = 1710
* CHECK dout0_23 vdout0_23ck170 = 0 time = 1710
* CHECK dout0_24 vdout0_24ck170 = 0 time = 1710
* CHECK dout0_25 vdout0_25ck170 = 0 time = 1710
* CHECK dout0_26 vdout0_26ck170 = 0 time = 1710
* CHECK dout0_27 vdout0_27ck170 = 3.3 time = 1710
* CHECK dout0_28 vdout0_28ck170 = 0 time = 1710
* CHECK dout0_29 vdout0_29ck170 = 0 time = 1710
* CHECK dout0_30 vdout0_30ck170 = 3.3 time = 1710
* CHECK dout0_31 vdout0_31ck170 = 3.3 time = 1710
* CHECK dout0_0 vdout0_0ck172 = 0 time = 1730
* CHECK dout0_1 vdout0_1ck172 = 0 time = 1730
* CHECK dout0_2 vdout0_2ck172 = 0 time = 1730
* CHECK dout0_3 vdout0_3ck172 = 3.3 time = 1730
* CHECK dout0_4 vdout0_4ck172 = 3.3 time = 1730
* CHECK dout0_5 vdout0_5ck172 = 3.3 time = 1730
* CHECK dout0_6 vdout0_6ck172 = 3.3 time = 1730
* CHECK dout0_7 vdout0_7ck172 = 0 time = 1730
* CHECK dout0_8 vdout0_8ck172 = 0 time = 1730
* CHECK dout0_9 vdout0_9ck172 = 0 time = 1730
* CHECK dout0_10 vdout0_10ck172 = 3.3 time = 1730
* CHECK dout0_11 vdout0_11ck172 = 3.3 time = 1730
* CHECK dout0_12 vdout0_12ck172 = 3.3 time = 1730
* CHECK dout0_13 vdout0_13ck172 = 0 time = 1730
* CHECK dout0_14 vdout0_14ck172 = 3.3 time = 1730
* CHECK dout0_15 vdout0_15ck172 = 0 time = 1730
* CHECK dout0_16 vdout0_16ck172 = 0 time = 1730
* CHECK dout0_17 vdout0_17ck172 = 3.3 time = 1730
* CHECK dout0_18 vdout0_18ck172 = 3.3 time = 1730
* CHECK dout0_19 vdout0_19ck172 = 0 time = 1730
* CHECK dout0_20 vdout0_20ck172 = 0 time = 1730
* CHECK dout0_21 vdout0_21ck172 = 3.3 time = 1730
* CHECK dout0_22 vdout0_22ck172 = 0 time = 1730
* CHECK dout0_23 vdout0_23ck172 = 0 time = 1730
* CHECK dout0_24 vdout0_24ck172 = 3.3 time = 1730
* CHECK dout0_25 vdout0_25ck172 = 3.3 time = 1730
* CHECK dout0_26 vdout0_26ck172 = 3.3 time = 1730
* CHECK dout0_27 vdout0_27ck172 = 0 time = 1730
* CHECK dout0_28 vdout0_28ck172 = 0 time = 1730
* CHECK dout0_29 vdout0_29ck172 = 3.3 time = 1730
* CHECK dout0_30 vdout0_30ck172 = 0 time = 1730
* CHECK dout0_31 vdout0_31ck172 = 3.3 time = 1730
* CHECK dout1_0 vdout1_0ck172 = 3.3 time = 1730
* CHECK dout1_1 vdout1_1ck172 = 0 time = 1730
* CHECK dout1_2 vdout1_2ck172 = 3.3 time = 1730
* CHECK dout1_3 vdout1_3ck172 = 3.3 time = 1730
* CHECK dout1_4 vdout1_4ck172 = 0 time = 1730
* CHECK dout1_5 vdout1_5ck172 = 3.3 time = 1730
* CHECK dout1_6 vdout1_6ck172 = 3.3 time = 1730
* CHECK dout1_7 vdout1_7ck172 = 0 time = 1730
* CHECK dout1_8 vdout1_8ck172 = 0 time = 1730
* CHECK dout1_9 vdout1_9ck172 = 3.3 time = 1730
* CHECK dout1_10 vdout1_10ck172 = 0 time = 1730
* CHECK dout1_11 vdout1_11ck172 = 3.3 time = 1730
* CHECK dout1_12 vdout1_12ck172 = 0 time = 1730
* CHECK dout1_13 vdout1_13ck172 = 3.3 time = 1730
* CHECK dout1_14 vdout1_14ck172 = 0 time = 1730
* CHECK dout1_15 vdout1_15ck172 = 3.3 time = 1730
* CHECK dout1_16 vdout1_16ck172 = 3.3 time = 1730
* CHECK dout1_17 vdout1_17ck172 = 3.3 time = 1730
* CHECK dout1_18 vdout1_18ck172 = 3.3 time = 1730
* CHECK dout1_19 vdout1_19ck172 = 0 time = 1730
* CHECK dout1_20 vdout1_20ck172 = 3.3 time = 1730
* CHECK dout1_21 vdout1_21ck172 = 3.3 time = 1730
* CHECK dout1_22 vdout1_22ck172 = 0 time = 1730
* CHECK dout1_23 vdout1_23ck172 = 3.3 time = 1730
* CHECK dout1_24 vdout1_24ck172 = 3.3 time = 1730
* CHECK dout1_25 vdout1_25ck172 = 0 time = 1730
* CHECK dout1_26 vdout1_26ck172 = 0 time = 1730
* CHECK dout1_27 vdout1_27ck172 = 3.3 time = 1730
* CHECK dout1_28 vdout1_28ck172 = 3.3 time = 1730
* CHECK dout1_29 vdout1_29ck172 = 0 time = 1730
* CHECK dout1_30 vdout1_30ck172 = 3.3 time = 1730
* CHECK dout1_31 vdout1_31ck172 = 0 time = 1730
* CHECK dout0_0 vdout0_0ck173 = 0 time = 1740
* CHECK dout0_1 vdout0_1ck173 = 0 time = 1740
* CHECK dout0_2 vdout0_2ck173 = 0 time = 1740
* CHECK dout0_3 vdout0_3ck173 = 3.3 time = 1740
* CHECK dout0_4 vdout0_4ck173 = 3.3 time = 1740
* CHECK dout0_5 vdout0_5ck173 = 3.3 time = 1740
* CHECK dout0_6 vdout0_6ck173 = 3.3 time = 1740
* CHECK dout0_7 vdout0_7ck173 = 0 time = 1740
* CHECK dout0_8 vdout0_8ck173 = 0 time = 1740
* CHECK dout0_9 vdout0_9ck173 = 0 time = 1740
* CHECK dout0_10 vdout0_10ck173 = 3.3 time = 1740
* CHECK dout0_11 vdout0_11ck173 = 3.3 time = 1740
* CHECK dout0_12 vdout0_12ck173 = 3.3 time = 1740
* CHECK dout0_13 vdout0_13ck173 = 0 time = 1740
* CHECK dout0_14 vdout0_14ck173 = 3.3 time = 1740
* CHECK dout0_15 vdout0_15ck173 = 0 time = 1740
* CHECK dout0_16 vdout0_16ck173 = 0 time = 1740
* CHECK dout0_17 vdout0_17ck173 = 3.3 time = 1740
* CHECK dout0_18 vdout0_18ck173 = 3.3 time = 1740
* CHECK dout0_19 vdout0_19ck173 = 0 time = 1740
* CHECK dout0_20 vdout0_20ck173 = 0 time = 1740
* CHECK dout0_21 vdout0_21ck173 = 3.3 time = 1740
* CHECK dout0_22 vdout0_22ck173 = 0 time = 1740
* CHECK dout0_23 vdout0_23ck173 = 0 time = 1740
* CHECK dout0_24 vdout0_24ck173 = 3.3 time = 1740
* CHECK dout0_25 vdout0_25ck173 = 3.3 time = 1740
* CHECK dout0_26 vdout0_26ck173 = 3.3 time = 1740
* CHECK dout0_27 vdout0_27ck173 = 0 time = 1740
* CHECK dout0_28 vdout0_28ck173 = 0 time = 1740
* CHECK dout0_29 vdout0_29ck173 = 3.3 time = 1740
* CHECK dout0_30 vdout0_30ck173 = 0 time = 1740
* CHECK dout0_31 vdout0_31ck173 = 3.3 time = 1740
* CHECK dout0_0 vdout0_0ck174 = 3.3 time = 1750
* CHECK dout0_1 vdout0_1ck174 = 3.3 time = 1750
* CHECK dout0_2 vdout0_2ck174 = 3.3 time = 1750
* CHECK dout0_3 vdout0_3ck174 = 3.3 time = 1750
* CHECK dout0_4 vdout0_4ck174 = 0 time = 1750
* CHECK dout0_5 vdout0_5ck174 = 3.3 time = 1750
* CHECK dout0_6 vdout0_6ck174 = 0 time = 1750
* CHECK dout0_7 vdout0_7ck174 = 3.3 time = 1750
* CHECK dout0_8 vdout0_8ck174 = 3.3 time = 1750
* CHECK dout0_9 vdout0_9ck174 = 0 time = 1750
* CHECK dout0_10 vdout0_10ck174 = 3.3 time = 1750
* CHECK dout0_11 vdout0_11ck174 = 3.3 time = 1750
* CHECK dout0_12 vdout0_12ck174 = 3.3 time = 1750
* CHECK dout0_13 vdout0_13ck174 = 3.3 time = 1750
* CHECK dout0_14 vdout0_14ck174 = 3.3 time = 1750
* CHECK dout0_15 vdout0_15ck174 = 0 time = 1750
* CHECK dout0_16 vdout0_16ck174 = 0 time = 1750
* CHECK dout0_17 vdout0_17ck174 = 3.3 time = 1750
* CHECK dout0_18 vdout0_18ck174 = 3.3 time = 1750
* CHECK dout0_19 vdout0_19ck174 = 3.3 time = 1750
* CHECK dout0_20 vdout0_20ck174 = 0 time = 1750
* CHECK dout0_21 vdout0_21ck174 = 3.3 time = 1750
* CHECK dout0_22 vdout0_22ck174 = 0 time = 1750
* CHECK dout0_23 vdout0_23ck174 = 0 time = 1750
* CHECK dout0_24 vdout0_24ck174 = 0 time = 1750
* CHECK dout0_25 vdout0_25ck174 = 0 time = 1750
* CHECK dout0_26 vdout0_26ck174 = 0 time = 1750
* CHECK dout0_27 vdout0_27ck174 = 0 time = 1750
* CHECK dout0_28 vdout0_28ck174 = 0 time = 1750
* CHECK dout0_29 vdout0_29ck174 = 3.3 time = 1750
* CHECK dout0_30 vdout0_30ck174 = 0 time = 1750
* CHECK dout0_31 vdout0_31ck174 = 3.3 time = 1750
* CHECK dout1_0 vdout1_0ck174 = 3.3 time = 1750
* CHECK dout1_1 vdout1_1ck174 = 3.3 time = 1750
* CHECK dout1_2 vdout1_2ck174 = 3.3 time = 1750
* CHECK dout1_3 vdout1_3ck174 = 3.3 time = 1750
* CHECK dout1_4 vdout1_4ck174 = 0 time = 1750
* CHECK dout1_5 vdout1_5ck174 = 3.3 time = 1750
* CHECK dout1_6 vdout1_6ck174 = 0 time = 1750
* CHECK dout1_7 vdout1_7ck174 = 3.3 time = 1750
* CHECK dout1_8 vdout1_8ck174 = 3.3 time = 1750
* CHECK dout1_9 vdout1_9ck174 = 0 time = 1750
* CHECK dout1_10 vdout1_10ck174 = 3.3 time = 1750
* CHECK dout1_11 vdout1_11ck174 = 3.3 time = 1750
* CHECK dout1_12 vdout1_12ck174 = 3.3 time = 1750
* CHECK dout1_13 vdout1_13ck174 = 3.3 time = 1750
* CHECK dout1_14 vdout1_14ck174 = 3.3 time = 1750
* CHECK dout1_15 vdout1_15ck174 = 0 time = 1750
* CHECK dout1_16 vdout1_16ck174 = 0 time = 1750
* CHECK dout1_17 vdout1_17ck174 = 3.3 time = 1750
* CHECK dout1_18 vdout1_18ck174 = 3.3 time = 1750
* CHECK dout1_19 vdout1_19ck174 = 3.3 time = 1750
* CHECK dout1_20 vdout1_20ck174 = 0 time = 1750
* CHECK dout1_21 vdout1_21ck174 = 3.3 time = 1750
* CHECK dout1_22 vdout1_22ck174 = 0 time = 1750
* CHECK dout1_23 vdout1_23ck174 = 0 time = 1750
* CHECK dout1_24 vdout1_24ck174 = 0 time = 1750
* CHECK dout1_25 vdout1_25ck174 = 0 time = 1750
* CHECK dout1_26 vdout1_26ck174 = 0 time = 1750
* CHECK dout1_27 vdout1_27ck174 = 0 time = 1750
* CHECK dout1_28 vdout1_28ck174 = 0 time = 1750
* CHECK dout1_29 vdout1_29ck174 = 3.3 time = 1750
* CHECK dout1_30 vdout1_30ck174 = 0 time = 1750
* CHECK dout1_31 vdout1_31ck174 = 3.3 time = 1750
* CHECK dout0_0 vdout0_0ck175 = 3.3 time = 1760
* CHECK dout0_1 vdout0_1ck175 = 3.3 time = 1760
* CHECK dout0_2 vdout0_2ck175 = 3.3 time = 1760
* CHECK dout0_3 vdout0_3ck175 = 3.3 time = 1760
* CHECK dout0_4 vdout0_4ck175 = 0 time = 1760
* CHECK dout0_5 vdout0_5ck175 = 3.3 time = 1760
* CHECK dout0_6 vdout0_6ck175 = 0 time = 1760
* CHECK dout0_7 vdout0_7ck175 = 3.3 time = 1760
* CHECK dout0_8 vdout0_8ck175 = 3.3 time = 1760
* CHECK dout0_9 vdout0_9ck175 = 0 time = 1760
* CHECK dout0_10 vdout0_10ck175 = 3.3 time = 1760
* CHECK dout0_11 vdout0_11ck175 = 3.3 time = 1760
* CHECK dout0_12 vdout0_12ck175 = 3.3 time = 1760
* CHECK dout0_13 vdout0_13ck175 = 3.3 time = 1760
* CHECK dout0_14 vdout0_14ck175 = 3.3 time = 1760
* CHECK dout0_15 vdout0_15ck175 = 0 time = 1760
* CHECK dout0_16 vdout0_16ck175 = 0 time = 1760
* CHECK dout0_17 vdout0_17ck175 = 3.3 time = 1760
* CHECK dout0_18 vdout0_18ck175 = 3.3 time = 1760
* CHECK dout0_19 vdout0_19ck175 = 3.3 time = 1760
* CHECK dout0_20 vdout0_20ck175 = 0 time = 1760
* CHECK dout0_21 vdout0_21ck175 = 3.3 time = 1760
* CHECK dout0_22 vdout0_22ck175 = 0 time = 1760
* CHECK dout0_23 vdout0_23ck175 = 0 time = 1760
* CHECK dout0_24 vdout0_24ck175 = 0 time = 1760
* CHECK dout0_25 vdout0_25ck175 = 0 time = 1760
* CHECK dout0_26 vdout0_26ck175 = 0 time = 1760
* CHECK dout0_27 vdout0_27ck175 = 0 time = 1760
* CHECK dout0_28 vdout0_28ck175 = 0 time = 1760
* CHECK dout0_29 vdout0_29ck175 = 3.3 time = 1760
* CHECK dout0_30 vdout0_30ck175 = 0 time = 1760
* CHECK dout0_31 vdout0_31ck175 = 3.3 time = 1760
* CHECK dout0_0 vdout0_0ck176 = 3.3 time = 1770
* CHECK dout0_1 vdout0_1ck176 = 3.3 time = 1770
* CHECK dout0_2 vdout0_2ck176 = 3.3 time = 1770
* CHECK dout0_3 vdout0_3ck176 = 3.3 time = 1770
* CHECK dout0_4 vdout0_4ck176 = 0 time = 1770
* CHECK dout0_5 vdout0_5ck176 = 3.3 time = 1770
* CHECK dout0_6 vdout0_6ck176 = 0 time = 1770
* CHECK dout0_7 vdout0_7ck176 = 3.3 time = 1770
* CHECK dout0_8 vdout0_8ck176 = 3.3 time = 1770
* CHECK dout0_9 vdout0_9ck176 = 0 time = 1770
* CHECK dout0_10 vdout0_10ck176 = 3.3 time = 1770
* CHECK dout0_11 vdout0_11ck176 = 3.3 time = 1770
* CHECK dout0_12 vdout0_12ck176 = 3.3 time = 1770
* CHECK dout0_13 vdout0_13ck176 = 3.3 time = 1770
* CHECK dout0_14 vdout0_14ck176 = 3.3 time = 1770
* CHECK dout0_15 vdout0_15ck176 = 0 time = 1770
* CHECK dout0_16 vdout0_16ck176 = 0 time = 1770
* CHECK dout0_17 vdout0_17ck176 = 3.3 time = 1770
* CHECK dout0_18 vdout0_18ck176 = 3.3 time = 1770
* CHECK dout0_19 vdout0_19ck176 = 3.3 time = 1770
* CHECK dout0_20 vdout0_20ck176 = 0 time = 1770
* CHECK dout0_21 vdout0_21ck176 = 3.3 time = 1770
* CHECK dout0_22 vdout0_22ck176 = 0 time = 1770
* CHECK dout0_23 vdout0_23ck176 = 0 time = 1770
* CHECK dout0_24 vdout0_24ck176 = 0 time = 1770
* CHECK dout0_25 vdout0_25ck176 = 0 time = 1770
* CHECK dout0_26 vdout0_26ck176 = 0 time = 1770
* CHECK dout0_27 vdout0_27ck176 = 0 time = 1770
* CHECK dout0_28 vdout0_28ck176 = 0 time = 1770
* CHECK dout0_29 vdout0_29ck176 = 3.3 time = 1770
* CHECK dout0_30 vdout0_30ck176 = 0 time = 1770
* CHECK dout0_31 vdout0_31ck176 = 3.3 time = 1770
* CHECK dout1_0 vdout1_0ck176 = 3.3 time = 1770
* CHECK dout1_1 vdout1_1ck176 = 3.3 time = 1770
* CHECK dout1_2 vdout1_2ck176 = 3.3 time = 1770
* CHECK dout1_3 vdout1_3ck176 = 3.3 time = 1770
* CHECK dout1_4 vdout1_4ck176 = 0 time = 1770
* CHECK dout1_5 vdout1_5ck176 = 3.3 time = 1770
* CHECK dout1_6 vdout1_6ck176 = 0 time = 1770
* CHECK dout1_7 vdout1_7ck176 = 3.3 time = 1770
* CHECK dout1_8 vdout1_8ck176 = 3.3 time = 1770
* CHECK dout1_9 vdout1_9ck176 = 0 time = 1770
* CHECK dout1_10 vdout1_10ck176 = 3.3 time = 1770
* CHECK dout1_11 vdout1_11ck176 = 3.3 time = 1770
* CHECK dout1_12 vdout1_12ck176 = 3.3 time = 1770
* CHECK dout1_13 vdout1_13ck176 = 3.3 time = 1770
* CHECK dout1_14 vdout1_14ck176 = 3.3 time = 1770
* CHECK dout1_15 vdout1_15ck176 = 0 time = 1770
* CHECK dout1_16 vdout1_16ck176 = 0 time = 1770
* CHECK dout1_17 vdout1_17ck176 = 3.3 time = 1770
* CHECK dout1_18 vdout1_18ck176 = 3.3 time = 1770
* CHECK dout1_19 vdout1_19ck176 = 3.3 time = 1770
* CHECK dout1_20 vdout1_20ck176 = 0 time = 1770
* CHECK dout1_21 vdout1_21ck176 = 3.3 time = 1770
* CHECK dout1_22 vdout1_22ck176 = 0 time = 1770
* CHECK dout1_23 vdout1_23ck176 = 0 time = 1770
* CHECK dout1_24 vdout1_24ck176 = 0 time = 1770
* CHECK dout1_25 vdout1_25ck176 = 0 time = 1770
* CHECK dout1_26 vdout1_26ck176 = 0 time = 1770
* CHECK dout1_27 vdout1_27ck176 = 0 time = 1770
* CHECK dout1_28 vdout1_28ck176 = 0 time = 1770
* CHECK dout1_29 vdout1_29ck176 = 3.3 time = 1770
* CHECK dout1_30 vdout1_30ck176 = 0 time = 1770
* CHECK dout1_31 vdout1_31ck176 = 3.3 time = 1770
* CHECK dout0_0 vdout0_0ck180 = 0 time = 1810
* CHECK dout0_1 vdout0_1ck180 = 0 time = 1810
* CHECK dout0_2 vdout0_2ck180 = 0 time = 1810
* CHECK dout0_3 vdout0_3ck180 = 3.3 time = 1810
* CHECK dout0_4 vdout0_4ck180 = 3.3 time = 1810
* CHECK dout0_5 vdout0_5ck180 = 3.3 time = 1810
* CHECK dout0_6 vdout0_6ck180 = 3.3 time = 1810
* CHECK dout0_7 vdout0_7ck180 = 0 time = 1810
* CHECK dout0_8 vdout0_8ck180 = 0 time = 1810
* CHECK dout0_9 vdout0_9ck180 = 0 time = 1810
* CHECK dout0_10 vdout0_10ck180 = 0 time = 1810
* CHECK dout0_11 vdout0_11ck180 = 3.3 time = 1810
* CHECK dout0_12 vdout0_12ck180 = 0 time = 1810
* CHECK dout0_13 vdout0_13ck180 = 0 time = 1810
* CHECK dout0_14 vdout0_14ck180 = 0 time = 1810
* CHECK dout0_15 vdout0_15ck180 = 3.3 time = 1810
* CHECK dout0_16 vdout0_16ck180 = 0 time = 1810
* CHECK dout0_17 vdout0_17ck180 = 3.3 time = 1810
* CHECK dout0_18 vdout0_18ck180 = 0 time = 1810
* CHECK dout0_19 vdout0_19ck180 = 3.3 time = 1810
* CHECK dout0_20 vdout0_20ck180 = 0 time = 1810
* CHECK dout0_21 vdout0_21ck180 = 0 time = 1810
* CHECK dout0_22 vdout0_22ck180 = 3.3 time = 1810
* CHECK dout0_23 vdout0_23ck180 = 0 time = 1810
* CHECK dout0_24 vdout0_24ck180 = 3.3 time = 1810
* CHECK dout0_25 vdout0_25ck180 = 3.3 time = 1810
* CHECK dout0_26 vdout0_26ck180 = 3.3 time = 1810
* CHECK dout0_27 vdout0_27ck180 = 3.3 time = 1810
* CHECK dout0_28 vdout0_28ck180 = 0 time = 1810
* CHECK dout0_29 vdout0_29ck180 = 3.3 time = 1810
* CHECK dout0_30 vdout0_30ck180 = 3.3 time = 1810
* CHECK dout0_31 vdout0_31ck180 = 0 time = 1810
* CHECK dout1_0 vdout1_0ck180 = 3.3 time = 1810
* CHECK dout1_1 vdout1_1ck180 = 3.3 time = 1810
* CHECK dout1_2 vdout1_2ck180 = 3.3 time = 1810
* CHECK dout1_3 vdout1_3ck180 = 3.3 time = 1810
* CHECK dout1_4 vdout1_4ck180 = 3.3 time = 1810
* CHECK dout1_5 vdout1_5ck180 = 3.3 time = 1810
* CHECK dout1_6 vdout1_6ck180 = 0 time = 1810
* CHECK dout1_7 vdout1_7ck180 = 3.3 time = 1810
* CHECK dout1_8 vdout1_8ck180 = 0 time = 1810
* CHECK dout1_9 vdout1_9ck180 = 3.3 time = 1810
* CHECK dout1_10 vdout1_10ck180 = 0 time = 1810
* CHECK dout1_11 vdout1_11ck180 = 0 time = 1810
* CHECK dout1_12 vdout1_12ck180 = 0 time = 1810
* CHECK dout1_13 vdout1_13ck180 = 0 time = 1810
* CHECK dout1_14 vdout1_14ck180 = 0 time = 1810
* CHECK dout1_15 vdout1_15ck180 = 0 time = 1810
* CHECK dout1_16 vdout1_16ck180 = 3.3 time = 1810
* CHECK dout1_17 vdout1_17ck180 = 3.3 time = 1810
* CHECK dout1_18 vdout1_18ck180 = 0 time = 1810
* CHECK dout1_19 vdout1_19ck180 = 0 time = 1810
* CHECK dout1_20 vdout1_20ck180 = 0 time = 1810
* CHECK dout1_21 vdout1_21ck180 = 3.3 time = 1810
* CHECK dout1_22 vdout1_22ck180 = 0 time = 1810
* CHECK dout1_23 vdout1_23ck180 = 0 time = 1810
* CHECK dout1_24 vdout1_24ck180 = 0 time = 1810
* CHECK dout1_25 vdout1_25ck180 = 0 time = 1810
* CHECK dout1_26 vdout1_26ck180 = 0 time = 1810
* CHECK dout1_27 vdout1_27ck180 = 0 time = 1810
* CHECK dout1_28 vdout1_28ck180 = 3.3 time = 1810
* CHECK dout1_29 vdout1_29ck180 = 0 time = 1810
* CHECK dout1_30 vdout1_30ck180 = 3.3 time = 1810
* CHECK dout1_31 vdout1_31ck180 = 0 time = 1810
* CHECK dout0_0 vdout0_0ck181 = 0 time = 1820
* CHECK dout0_1 vdout0_1ck181 = 0 time = 1820
* CHECK dout0_2 vdout0_2ck181 = 0 time = 1820
* CHECK dout0_3 vdout0_3ck181 = 3.3 time = 1820
* CHECK dout0_4 vdout0_4ck181 = 3.3 time = 1820
* CHECK dout0_5 vdout0_5ck181 = 3.3 time = 1820
* CHECK dout0_6 vdout0_6ck181 = 3.3 time = 1820
* CHECK dout0_7 vdout0_7ck181 = 0 time = 1820
* CHECK dout0_8 vdout0_8ck181 = 0 time = 1820
* CHECK dout0_9 vdout0_9ck181 = 0 time = 1820
* CHECK dout0_10 vdout0_10ck181 = 0 time = 1820
* CHECK dout0_11 vdout0_11ck181 = 3.3 time = 1820
* CHECK dout0_12 vdout0_12ck181 = 0 time = 1820
* CHECK dout0_13 vdout0_13ck181 = 0 time = 1820
* CHECK dout0_14 vdout0_14ck181 = 0 time = 1820
* CHECK dout0_15 vdout0_15ck181 = 3.3 time = 1820
* CHECK dout0_16 vdout0_16ck181 = 0 time = 1820
* CHECK dout0_17 vdout0_17ck181 = 3.3 time = 1820
* CHECK dout0_18 vdout0_18ck181 = 0 time = 1820
* CHECK dout0_19 vdout0_19ck181 = 3.3 time = 1820
* CHECK dout0_20 vdout0_20ck181 = 0 time = 1820
* CHECK dout0_21 vdout0_21ck181 = 0 time = 1820
* CHECK dout0_22 vdout0_22ck181 = 3.3 time = 1820
* CHECK dout0_23 vdout0_23ck181 = 0 time = 1820
* CHECK dout0_24 vdout0_24ck181 = 3.3 time = 1820
* CHECK dout0_25 vdout0_25ck181 = 3.3 time = 1820
* CHECK dout0_26 vdout0_26ck181 = 3.3 time = 1820
* CHECK dout0_27 vdout0_27ck181 = 3.3 time = 1820
* CHECK dout0_28 vdout0_28ck181 = 0 time = 1820
* CHECK dout0_29 vdout0_29ck181 = 3.3 time = 1820
* CHECK dout0_30 vdout0_30ck181 = 3.3 time = 1820
* CHECK dout0_31 vdout0_31ck181 = 0 time = 1820
* CHECK dout1_0 vdout1_0ck181 = 3.3 time = 1820
* CHECK dout1_1 vdout1_1ck181 = 3.3 time = 1820
* CHECK dout1_2 vdout1_2ck181 = 3.3 time = 1820
* CHECK dout1_3 vdout1_3ck181 = 3.3 time = 1820
* CHECK dout1_4 vdout1_4ck181 = 3.3 time = 1820
* CHECK dout1_5 vdout1_5ck181 = 3.3 time = 1820
* CHECK dout1_6 vdout1_6ck181 = 0 time = 1820
* CHECK dout1_7 vdout1_7ck181 = 3.3 time = 1820
* CHECK dout1_8 vdout1_8ck181 = 0 time = 1820
* CHECK dout1_9 vdout1_9ck181 = 3.3 time = 1820
* CHECK dout1_10 vdout1_10ck181 = 0 time = 1820
* CHECK dout1_11 vdout1_11ck181 = 0 time = 1820
* CHECK dout1_12 vdout1_12ck181 = 0 time = 1820
* CHECK dout1_13 vdout1_13ck181 = 0 time = 1820
* CHECK dout1_14 vdout1_14ck181 = 0 time = 1820
* CHECK dout1_15 vdout1_15ck181 = 0 time = 1820
* CHECK dout1_16 vdout1_16ck181 = 3.3 time = 1820
* CHECK dout1_17 vdout1_17ck181 = 3.3 time = 1820
* CHECK dout1_18 vdout1_18ck181 = 0 time = 1820
* CHECK dout1_19 vdout1_19ck181 = 0 time = 1820
* CHECK dout1_20 vdout1_20ck181 = 0 time = 1820
* CHECK dout1_21 vdout1_21ck181 = 3.3 time = 1820
* CHECK dout1_22 vdout1_22ck181 = 0 time = 1820
* CHECK dout1_23 vdout1_23ck181 = 0 time = 1820
* CHECK dout1_24 vdout1_24ck181 = 0 time = 1820
* CHECK dout1_25 vdout1_25ck181 = 0 time = 1820
* CHECK dout1_26 vdout1_26ck181 = 0 time = 1820
* CHECK dout1_27 vdout1_27ck181 = 0 time = 1820
* CHECK dout1_28 vdout1_28ck181 = 3.3 time = 1820
* CHECK dout1_29 vdout1_29ck181 = 0 time = 1820
* CHECK dout1_30 vdout1_30ck181 = 3.3 time = 1820
* CHECK dout1_31 vdout1_31ck181 = 0 time = 1820
* CHECK dout0_0 vdout0_0ck183 = 0 time = 1840
* CHECK dout0_1 vdout0_1ck183 = 3.3 time = 1840
* CHECK dout0_2 vdout0_2ck183 = 0 time = 1840
* CHECK dout0_3 vdout0_3ck183 = 0 time = 1840
* CHECK dout0_4 vdout0_4ck183 = 3.3 time = 1840
* CHECK dout0_5 vdout0_5ck183 = 0 time = 1840
* CHECK dout0_6 vdout0_6ck183 = 3.3 time = 1840
* CHECK dout0_7 vdout0_7ck183 = 0 time = 1840
* CHECK dout0_8 vdout0_8ck183 = 3.3 time = 1840
* CHECK dout0_9 vdout0_9ck183 = 0 time = 1840
* CHECK dout0_10 vdout0_10ck183 = 0 time = 1840
* CHECK dout0_11 vdout0_11ck183 = 3.3 time = 1840
* CHECK dout0_12 vdout0_12ck183 = 0 time = 1840
* CHECK dout0_13 vdout0_13ck183 = 0 time = 1840
* CHECK dout0_14 vdout0_14ck183 = 0 time = 1840
* CHECK dout0_15 vdout0_15ck183 = 0 time = 1840
* CHECK dout0_16 vdout0_16ck183 = 3.3 time = 1840
* CHECK dout0_17 vdout0_17ck183 = 3.3 time = 1840
* CHECK dout0_18 vdout0_18ck183 = 0 time = 1840
* CHECK dout0_19 vdout0_19ck183 = 0 time = 1840
* CHECK dout0_20 vdout0_20ck183 = 3.3 time = 1840
* CHECK dout0_21 vdout0_21ck183 = 0 time = 1840
* CHECK dout0_22 vdout0_22ck183 = 0 time = 1840
* CHECK dout0_23 vdout0_23ck183 = 0 time = 1840
* CHECK dout0_24 vdout0_24ck183 = 0 time = 1840
* CHECK dout0_25 vdout0_25ck183 = 3.3 time = 1840
* CHECK dout0_26 vdout0_26ck183 = 3.3 time = 1840
* CHECK dout0_27 vdout0_27ck183 = 0 time = 1840
* CHECK dout0_28 vdout0_28ck183 = 3.3 time = 1840
* CHECK dout0_29 vdout0_29ck183 = 0 time = 1840
* CHECK dout0_30 vdout0_30ck183 = 0 time = 1840
* CHECK dout0_31 vdout0_31ck183 = 3.3 time = 1840
* CHECK dout0_0 vdout0_0ck184 = 0 time = 1850
* CHECK dout0_1 vdout0_1ck184 = 3.3 time = 1850
* CHECK dout0_2 vdout0_2ck184 = 0 time = 1850
* CHECK dout0_3 vdout0_3ck184 = 0 time = 1850
* CHECK dout0_4 vdout0_4ck184 = 3.3 time = 1850
* CHECK dout0_5 vdout0_5ck184 = 0 time = 1850
* CHECK dout0_6 vdout0_6ck184 = 3.3 time = 1850
* CHECK dout0_7 vdout0_7ck184 = 0 time = 1850
* CHECK dout0_8 vdout0_8ck184 = 3.3 time = 1850
* CHECK dout0_9 vdout0_9ck184 = 0 time = 1850
* CHECK dout0_10 vdout0_10ck184 = 0 time = 1850
* CHECK dout0_11 vdout0_11ck184 = 3.3 time = 1850
* CHECK dout0_12 vdout0_12ck184 = 0 time = 1850
* CHECK dout0_13 vdout0_13ck184 = 0 time = 1850
* CHECK dout0_14 vdout0_14ck184 = 0 time = 1850
* CHECK dout0_15 vdout0_15ck184 = 0 time = 1850
* CHECK dout0_16 vdout0_16ck184 = 3.3 time = 1850
* CHECK dout0_17 vdout0_17ck184 = 3.3 time = 1850
* CHECK dout0_18 vdout0_18ck184 = 0 time = 1850
* CHECK dout0_19 vdout0_19ck184 = 0 time = 1850
* CHECK dout0_20 vdout0_20ck184 = 3.3 time = 1850
* CHECK dout0_21 vdout0_21ck184 = 0 time = 1850
* CHECK dout0_22 vdout0_22ck184 = 0 time = 1850
* CHECK dout0_23 vdout0_23ck184 = 0 time = 1850
* CHECK dout0_24 vdout0_24ck184 = 0 time = 1850
* CHECK dout0_25 vdout0_25ck184 = 3.3 time = 1850
* CHECK dout0_26 vdout0_26ck184 = 3.3 time = 1850
* CHECK dout0_27 vdout0_27ck184 = 0 time = 1850
* CHECK dout0_28 vdout0_28ck184 = 3.3 time = 1850
* CHECK dout0_29 vdout0_29ck184 = 0 time = 1850
* CHECK dout0_30 vdout0_30ck184 = 0 time = 1850
* CHECK dout0_31 vdout0_31ck184 = 3.3 time = 1850
* CHECK dout1_0 vdout1_0ck184 = 0 time = 1850
* CHECK dout1_1 vdout1_1ck184 = 3.3 time = 1850
* CHECK dout1_2 vdout1_2ck184 = 3.3 time = 1850
* CHECK dout1_3 vdout1_3ck184 = 0 time = 1850
* CHECK dout1_4 vdout1_4ck184 = 0 time = 1850
* CHECK dout1_5 vdout1_5ck184 = 0 time = 1850
* CHECK dout1_6 vdout1_6ck184 = 3.3 time = 1850
* CHECK dout1_7 vdout1_7ck184 = 3.3 time = 1850
* CHECK dout1_8 vdout1_8ck184 = 0 time = 1850
* CHECK dout1_9 vdout1_9ck184 = 0 time = 1850
* CHECK dout1_10 vdout1_10ck184 = 0 time = 1850
* CHECK dout1_11 vdout1_11ck184 = 0 time = 1850
* CHECK dout1_12 vdout1_12ck184 = 3.3 time = 1850
* CHECK dout1_13 vdout1_13ck184 = 3.3 time = 1850
* CHECK dout1_14 vdout1_14ck184 = 3.3 time = 1850
* CHECK dout1_15 vdout1_15ck184 = 3.3 time = 1850
* CHECK dout1_16 vdout1_16ck184 = 0 time = 1850
* CHECK dout1_17 vdout1_17ck184 = 3.3 time = 1850
* CHECK dout1_18 vdout1_18ck184 = 0 time = 1850
* CHECK dout1_19 vdout1_19ck184 = 0 time = 1850
* CHECK dout1_20 vdout1_20ck184 = 3.3 time = 1850
* CHECK dout1_21 vdout1_21ck184 = 3.3 time = 1850
* CHECK dout1_22 vdout1_22ck184 = 0 time = 1850
* CHECK dout1_23 vdout1_23ck184 = 0 time = 1850
* CHECK dout1_24 vdout1_24ck184 = 3.3 time = 1850
* CHECK dout1_25 vdout1_25ck184 = 3.3 time = 1850
* CHECK dout1_26 vdout1_26ck184 = 3.3 time = 1850
* CHECK dout1_27 vdout1_27ck184 = 3.3 time = 1850
* CHECK dout1_28 vdout1_28ck184 = 3.3 time = 1850
* CHECK dout1_29 vdout1_29ck184 = 0 time = 1850
* CHECK dout1_30 vdout1_30ck184 = 0 time = 1850
* CHECK dout1_31 vdout1_31ck184 = 3.3 time = 1850
* CHECK dout0_0 vdout0_0ck186 = 0 time = 1870
* CHECK dout0_1 vdout0_1ck186 = 3.3 time = 1870
* CHECK dout0_2 vdout0_2ck186 = 3.3 time = 1870
* CHECK dout0_3 vdout0_3ck186 = 0 time = 1870
* CHECK dout0_4 vdout0_4ck186 = 0 time = 1870
* CHECK dout0_5 vdout0_5ck186 = 0 time = 1870
* CHECK dout0_6 vdout0_6ck186 = 3.3 time = 1870
* CHECK dout0_7 vdout0_7ck186 = 3.3 time = 1870
* CHECK dout0_8 vdout0_8ck186 = 0 time = 1870
* CHECK dout0_9 vdout0_9ck186 = 0 time = 1870
* CHECK dout0_10 vdout0_10ck186 = 0 time = 1870
* CHECK dout0_11 vdout0_11ck186 = 0 time = 1870
* CHECK dout0_12 vdout0_12ck186 = 3.3 time = 1870
* CHECK dout0_13 vdout0_13ck186 = 3.3 time = 1870
* CHECK dout0_14 vdout0_14ck186 = 3.3 time = 1870
* CHECK dout0_15 vdout0_15ck186 = 3.3 time = 1870
* CHECK dout0_16 vdout0_16ck186 = 0 time = 1870
* CHECK dout0_17 vdout0_17ck186 = 3.3 time = 1870
* CHECK dout0_18 vdout0_18ck186 = 0 time = 1870
* CHECK dout0_19 vdout0_19ck186 = 0 time = 1870
* CHECK dout0_20 vdout0_20ck186 = 3.3 time = 1870
* CHECK dout0_21 vdout0_21ck186 = 3.3 time = 1870
* CHECK dout0_22 vdout0_22ck186 = 0 time = 1870
* CHECK dout0_23 vdout0_23ck186 = 0 time = 1870
* CHECK dout0_24 vdout0_24ck186 = 3.3 time = 1870
* CHECK dout0_25 vdout0_25ck186 = 3.3 time = 1870
* CHECK dout0_26 vdout0_26ck186 = 3.3 time = 1870
* CHECK dout0_27 vdout0_27ck186 = 3.3 time = 1870
* CHECK dout0_28 vdout0_28ck186 = 3.3 time = 1870
* CHECK dout0_29 vdout0_29ck186 = 0 time = 1870
* CHECK dout0_30 vdout0_30ck186 = 0 time = 1870
* CHECK dout0_31 vdout0_31ck186 = 3.3 time = 1870
* CHECK dout0_0 vdout0_0ck187 = 3.3 time = 1880
* CHECK dout0_1 vdout0_1ck187 = 0 time = 1880
* CHECK dout0_2 vdout0_2ck187 = 0 time = 1880
* CHECK dout0_3 vdout0_3ck187 = 3.3 time = 1880
* CHECK dout0_4 vdout0_4ck187 = 3.3 time = 1880
* CHECK dout0_5 vdout0_5ck187 = 3.3 time = 1880
* CHECK dout0_6 vdout0_6ck187 = 0 time = 1880
* CHECK dout0_7 vdout0_7ck187 = 0 time = 1880
* CHECK dout0_8 vdout0_8ck187 = 0 time = 1880
* CHECK dout0_9 vdout0_9ck187 = 3.3 time = 1880
* CHECK dout0_10 vdout0_10ck187 = 3.3 time = 1880
* CHECK dout0_11 vdout0_11ck187 = 0 time = 1880
* CHECK dout0_12 vdout0_12ck187 = 0 time = 1880
* CHECK dout0_13 vdout0_13ck187 = 0 time = 1880
* CHECK dout0_14 vdout0_14ck187 = 3.3 time = 1880
* CHECK dout0_15 vdout0_15ck187 = 0 time = 1880
* CHECK dout0_16 vdout0_16ck187 = 3.3 time = 1880
* CHECK dout0_17 vdout0_17ck187 = 0 time = 1880
* CHECK dout0_18 vdout0_18ck187 = 3.3 time = 1880
* CHECK dout0_19 vdout0_19ck187 = 0 time = 1880
* CHECK dout0_20 vdout0_20ck187 = 3.3 time = 1880
* CHECK dout0_21 vdout0_21ck187 = 3.3 time = 1880
* CHECK dout0_22 vdout0_22ck187 = 0 time = 1880
* CHECK dout0_23 vdout0_23ck187 = 3.3 time = 1880
* CHECK dout0_24 vdout0_24ck187 = 0 time = 1880
* CHECK dout0_25 vdout0_25ck187 = 0 time = 1880
* CHECK dout0_26 vdout0_26ck187 = 3.3 time = 1880
* CHECK dout0_27 vdout0_27ck187 = 3.3 time = 1880
* CHECK dout0_28 vdout0_28ck187 = 3.3 time = 1880
* CHECK dout0_29 vdout0_29ck187 = 0 time = 1880
* CHECK dout0_30 vdout0_30ck187 = 3.3 time = 1880
* CHECK dout0_31 vdout0_31ck187 = 0 time = 1880
* CHECK dout1_0 vdout1_0ck187 = 3.3 time = 1880
* CHECK dout1_1 vdout1_1ck187 = 3.3 time = 1880
* CHECK dout1_2 vdout1_2ck187 = 0 time = 1880
* CHECK dout1_3 vdout1_3ck187 = 0 time = 1880
* CHECK dout1_4 vdout1_4ck187 = 0 time = 1880
* CHECK dout1_5 vdout1_5ck187 = 0 time = 1880
* CHECK dout1_6 vdout1_6ck187 = 0 time = 1880
* CHECK dout1_7 vdout1_7ck187 = 0 time = 1880
* CHECK dout1_8 vdout1_8ck187 = 0 time = 1880
* CHECK dout1_9 vdout1_9ck187 = 0 time = 1880
* CHECK dout1_10 vdout1_10ck187 = 3.3 time = 1880
* CHECK dout1_11 vdout1_11ck187 = 0 time = 1880
* CHECK dout1_12 vdout1_12ck187 = 0 time = 1880
* CHECK dout1_13 vdout1_13ck187 = 0 time = 1880
* CHECK dout1_14 vdout1_14ck187 = 0 time = 1880
* CHECK dout1_15 vdout1_15ck187 = 3.3 time = 1880
* CHECK dout1_16 vdout1_16ck187 = 0 time = 1880
* CHECK dout1_17 vdout1_17ck187 = 3.3 time = 1880
* CHECK dout1_18 vdout1_18ck187 = 3.3 time = 1880
* CHECK dout1_19 vdout1_19ck187 = 3.3 time = 1880
* CHECK dout1_20 vdout1_20ck187 = 3.3 time = 1880
* CHECK dout1_21 vdout1_21ck187 = 0 time = 1880
* CHECK dout1_22 vdout1_22ck187 = 0 time = 1880
* CHECK dout1_23 vdout1_23ck187 = 3.3 time = 1880
* CHECK dout1_24 vdout1_24ck187 = 0 time = 1880
* CHECK dout1_25 vdout1_25ck187 = 0 time = 1880
* CHECK dout1_26 vdout1_26ck187 = 3.3 time = 1880
* CHECK dout1_27 vdout1_27ck187 = 0 time = 1880
* CHECK dout1_28 vdout1_28ck187 = 3.3 time = 1880
* CHECK dout1_29 vdout1_29ck187 = 3.3 time = 1880
* CHECK dout1_30 vdout1_30ck187 = 3.3 time = 1880
* CHECK dout1_31 vdout1_31ck187 = 3.3 time = 1880
* CHECK dout1_0 vdout1_0ck189 = 3.3 time = 1900
* CHECK dout1_1 vdout1_1ck189 = 3.3 time = 1900
* CHECK dout1_2 vdout1_2ck189 = 3.3 time = 1900
* CHECK dout1_3 vdout1_3ck189 = 3.3 time = 1900
* CHECK dout1_4 vdout1_4ck189 = 0 time = 1900
* CHECK dout1_5 vdout1_5ck189 = 0 time = 1900
* CHECK dout1_6 vdout1_6ck189 = 3.3 time = 1900
* CHECK dout1_7 vdout1_7ck189 = 0 time = 1900
* CHECK dout1_8 vdout1_8ck189 = 3.3 time = 1900
* CHECK dout1_9 vdout1_9ck189 = 0 time = 1900
* CHECK dout1_10 vdout1_10ck189 = 3.3 time = 1900
* CHECK dout1_11 vdout1_11ck189 = 3.3 time = 1900
* CHECK dout1_12 vdout1_12ck189 = 3.3 time = 1900
* CHECK dout1_13 vdout1_13ck189 = 3.3 time = 1900
* CHECK dout1_14 vdout1_14ck189 = 3.3 time = 1900
* CHECK dout1_15 vdout1_15ck189 = 3.3 time = 1900
* CHECK dout1_16 vdout1_16ck189 = 3.3 time = 1900
* CHECK dout1_17 vdout1_17ck189 = 0 time = 1900
* CHECK dout1_18 vdout1_18ck189 = 0 time = 1900
* CHECK dout1_19 vdout1_19ck189 = 0 time = 1900
* CHECK dout1_20 vdout1_20ck189 = 3.3 time = 1900
* CHECK dout1_21 vdout1_21ck189 = 0 time = 1900
* CHECK dout1_22 vdout1_22ck189 = 3.3 time = 1900
* CHECK dout1_23 vdout1_23ck189 = 3.3 time = 1900
* CHECK dout1_24 vdout1_24ck189 = 0 time = 1900
* CHECK dout1_25 vdout1_25ck189 = 3.3 time = 1900
* CHECK dout1_26 vdout1_26ck189 = 0 time = 1900
* CHECK dout1_27 vdout1_27ck189 = 0 time = 1900
* CHECK dout1_28 vdout1_28ck189 = 3.3 time = 1900
* CHECK dout1_29 vdout1_29ck189 = 0 time = 1900
* CHECK dout1_30 vdout1_30ck189 = 0 time = 1900
* CHECK dout1_31 vdout1_31ck189 = 3.3 time = 1900
* CHECK dout1_0 vdout1_0ck190 = 3.3 time = 1910
* CHECK dout1_1 vdout1_1ck190 = 3.3 time = 1910
* CHECK dout1_2 vdout1_2ck190 = 3.3 time = 1910
* CHECK dout1_3 vdout1_3ck190 = 3.3 time = 1910
* CHECK dout1_4 vdout1_4ck190 = 0 time = 1910
* CHECK dout1_5 vdout1_5ck190 = 0 time = 1910
* CHECK dout1_6 vdout1_6ck190 = 3.3 time = 1910
* CHECK dout1_7 vdout1_7ck190 = 0 time = 1910
* CHECK dout1_8 vdout1_8ck190 = 3.3 time = 1910
* CHECK dout1_9 vdout1_9ck190 = 0 time = 1910
* CHECK dout1_10 vdout1_10ck190 = 3.3 time = 1910
* CHECK dout1_11 vdout1_11ck190 = 3.3 time = 1910
* CHECK dout1_12 vdout1_12ck190 = 3.3 time = 1910
* CHECK dout1_13 vdout1_13ck190 = 3.3 time = 1910
* CHECK dout1_14 vdout1_14ck190 = 3.3 time = 1910
* CHECK dout1_15 vdout1_15ck190 = 3.3 time = 1910
* CHECK dout1_16 vdout1_16ck190 = 3.3 time = 1910
* CHECK dout1_17 vdout1_17ck190 = 0 time = 1910
* CHECK dout1_18 vdout1_18ck190 = 0 time = 1910
* CHECK dout1_19 vdout1_19ck190 = 0 time = 1910
* CHECK dout1_20 vdout1_20ck190 = 3.3 time = 1910
* CHECK dout1_21 vdout1_21ck190 = 0 time = 1910
* CHECK dout1_22 vdout1_22ck190 = 3.3 time = 1910
* CHECK dout1_23 vdout1_23ck190 = 3.3 time = 1910
* CHECK dout1_24 vdout1_24ck190 = 0 time = 1910
* CHECK dout1_25 vdout1_25ck190 = 3.3 time = 1910
* CHECK dout1_26 vdout1_26ck190 = 0 time = 1910
* CHECK dout1_27 vdout1_27ck190 = 0 time = 1910
* CHECK dout1_28 vdout1_28ck190 = 3.3 time = 1910
* CHECK dout1_29 vdout1_29ck190 = 0 time = 1910
* CHECK dout1_30 vdout1_30ck190 = 0 time = 1910
* CHECK dout1_31 vdout1_31ck190 = 3.3 time = 1910
* CHECK dout0_0 vdout0_0ck191 = 0 time = 1920
* CHECK dout0_1 vdout0_1ck191 = 0 time = 1920
* CHECK dout0_2 vdout0_2ck191 = 3.3 time = 1920
* CHECK dout0_3 vdout0_3ck191 = 0 time = 1920
* CHECK dout0_4 vdout0_4ck191 = 0 time = 1920
* CHECK dout0_5 vdout0_5ck191 = 3.3 time = 1920
* CHECK dout0_6 vdout0_6ck191 = 0 time = 1920
* CHECK dout0_7 vdout0_7ck191 = 0 time = 1920
* CHECK dout0_8 vdout0_8ck191 = 0 time = 1920
* CHECK dout0_9 vdout0_9ck191 = 0 time = 1920
* CHECK dout0_10 vdout0_10ck191 = 3.3 time = 1920
* CHECK dout0_11 vdout0_11ck191 = 3.3 time = 1920
* CHECK dout0_12 vdout0_12ck191 = 3.3 time = 1920
* CHECK dout0_13 vdout0_13ck191 = 0 time = 1920
* CHECK dout0_14 vdout0_14ck191 = 0 time = 1920
* CHECK dout0_15 vdout0_15ck191 = 3.3 time = 1920
* CHECK dout0_16 vdout0_16ck191 = 3.3 time = 1920
* CHECK dout0_17 vdout0_17ck191 = 0 time = 1920
* CHECK dout0_18 vdout0_18ck191 = 0 time = 1920
* CHECK dout0_19 vdout0_19ck191 = 3.3 time = 1920
* CHECK dout0_20 vdout0_20ck191 = 3.3 time = 1920
* CHECK dout0_21 vdout0_21ck191 = 3.3 time = 1920
* CHECK dout0_22 vdout0_22ck191 = 0 time = 1920
* CHECK dout0_23 vdout0_23ck191 = 3.3 time = 1920
* CHECK dout0_24 vdout0_24ck191 = 3.3 time = 1920
* CHECK dout0_25 vdout0_25ck191 = 3.3 time = 1920
* CHECK dout0_26 vdout0_26ck191 = 3.3 time = 1920
* CHECK dout0_27 vdout0_27ck191 = 3.3 time = 1920
* CHECK dout0_28 vdout0_28ck191 = 3.3 time = 1920
* CHECK dout0_29 vdout0_29ck191 = 0 time = 1920
* CHECK dout0_30 vdout0_30ck191 = 0 time = 1920
* CHECK dout0_31 vdout0_31ck191 = 3.3 time = 1920
* CHECK dout0_0 vdout0_0ck192 = 3.3 time = 1930
* CHECK dout0_1 vdout0_1ck192 = 0 time = 1930
* CHECK dout0_2 vdout0_2ck192 = 3.3 time = 1930
* CHECK dout0_3 vdout0_3ck192 = 3.3 time = 1930
* CHECK dout0_4 vdout0_4ck192 = 0 time = 1930
* CHECK dout0_5 vdout0_5ck192 = 3.3 time = 1930
* CHECK dout0_6 vdout0_6ck192 = 0 time = 1930
* CHECK dout0_7 vdout0_7ck192 = 3.3 time = 1930
* CHECK dout0_8 vdout0_8ck192 = 0 time = 1930
* CHECK dout0_9 vdout0_9ck192 = 3.3 time = 1930
* CHECK dout0_10 vdout0_10ck192 = 3.3 time = 1930
* CHECK dout0_11 vdout0_11ck192 = 0 time = 1930
* CHECK dout0_12 vdout0_12ck192 = 0 time = 1930
* CHECK dout0_13 vdout0_13ck192 = 3.3 time = 1930
* CHECK dout0_14 vdout0_14ck192 = 0 time = 1930
* CHECK dout0_15 vdout0_15ck192 = 0 time = 1930
* CHECK dout0_16 vdout0_16ck192 = 3.3 time = 1930
* CHECK dout0_17 vdout0_17ck192 = 3.3 time = 1930
* CHECK dout0_18 vdout0_18ck192 = 0 time = 1930
* CHECK dout0_19 vdout0_19ck192 = 0 time = 1930
* CHECK dout0_20 vdout0_20ck192 = 0 time = 1930
* CHECK dout0_21 vdout0_21ck192 = 3.3 time = 1930
* CHECK dout0_22 vdout0_22ck192 = 3.3 time = 1930
* CHECK dout0_23 vdout0_23ck192 = 3.3 time = 1930
* CHECK dout0_24 vdout0_24ck192 = 3.3 time = 1930
* CHECK dout0_25 vdout0_25ck192 = 0 time = 1930
* CHECK dout0_26 vdout0_26ck192 = 0 time = 1930
* CHECK dout0_27 vdout0_27ck192 = 0 time = 1930
* CHECK dout0_28 vdout0_28ck192 = 0 time = 1930
* CHECK dout0_29 vdout0_29ck192 = 3.3 time = 1930
* CHECK dout0_30 vdout0_30ck192 = 0 time = 1930
* CHECK dout0_31 vdout0_31ck192 = 3.3 time = 1930
* CHECK dout0_0 vdout0_0ck193 = 3.3 time = 1940
* CHECK dout0_1 vdout0_1ck193 = 0 time = 1940
* CHECK dout0_2 vdout0_2ck193 = 3.3 time = 1940
* CHECK dout0_3 vdout0_3ck193 = 3.3 time = 1940
* CHECK dout0_4 vdout0_4ck193 = 0 time = 1940
* CHECK dout0_5 vdout0_5ck193 = 3.3 time = 1940
* CHECK dout0_6 vdout0_6ck193 = 0 time = 1940
* CHECK dout0_7 vdout0_7ck193 = 3.3 time = 1940
* CHECK dout0_8 vdout0_8ck193 = 0 time = 1940
* CHECK dout0_9 vdout0_9ck193 = 3.3 time = 1940
* CHECK dout0_10 vdout0_10ck193 = 3.3 time = 1940
* CHECK dout0_11 vdout0_11ck193 = 0 time = 1940
* CHECK dout0_12 vdout0_12ck193 = 0 time = 1940
* CHECK dout0_13 vdout0_13ck193 = 3.3 time = 1940
* CHECK dout0_14 vdout0_14ck193 = 0 time = 1940
* CHECK dout0_15 vdout0_15ck193 = 0 time = 1940
* CHECK dout0_16 vdout0_16ck193 = 3.3 time = 1940
* CHECK dout0_17 vdout0_17ck193 = 3.3 time = 1940
* CHECK dout0_18 vdout0_18ck193 = 0 time = 1940
* CHECK dout0_19 vdout0_19ck193 = 0 time = 1940
* CHECK dout0_20 vdout0_20ck193 = 0 time = 1940
* CHECK dout0_21 vdout0_21ck193 = 3.3 time = 1940
* CHECK dout0_22 vdout0_22ck193 = 3.3 time = 1940
* CHECK dout0_23 vdout0_23ck193 = 3.3 time = 1940
* CHECK dout0_24 vdout0_24ck193 = 3.3 time = 1940
* CHECK dout0_25 vdout0_25ck193 = 0 time = 1940
* CHECK dout0_26 vdout0_26ck193 = 0 time = 1940
* CHECK dout0_27 vdout0_27ck193 = 0 time = 1940
* CHECK dout0_28 vdout0_28ck193 = 0 time = 1940
* CHECK dout0_29 vdout0_29ck193 = 3.3 time = 1940
* CHECK dout0_30 vdout0_30ck193 = 0 time = 1940
* CHECK dout0_31 vdout0_31ck193 = 3.3 time = 1940
* CHECK dout0_0 vdout0_0ck194 = 3.3 time = 1950
* CHECK dout0_1 vdout0_1ck194 = 0 time = 1950
* CHECK dout0_2 vdout0_2ck194 = 3.3 time = 1950
* CHECK dout0_3 vdout0_3ck194 = 3.3 time = 1950
* CHECK dout0_4 vdout0_4ck194 = 0 time = 1950
* CHECK dout0_5 vdout0_5ck194 = 3.3 time = 1950
* CHECK dout0_6 vdout0_6ck194 = 0 time = 1950
* CHECK dout0_7 vdout0_7ck194 = 3.3 time = 1950
* CHECK dout0_8 vdout0_8ck194 = 0 time = 1950
* CHECK dout0_9 vdout0_9ck194 = 3.3 time = 1950
* CHECK dout0_10 vdout0_10ck194 = 3.3 time = 1950
* CHECK dout0_11 vdout0_11ck194 = 0 time = 1950
* CHECK dout0_12 vdout0_12ck194 = 0 time = 1950
* CHECK dout0_13 vdout0_13ck194 = 3.3 time = 1950
* CHECK dout0_14 vdout0_14ck194 = 0 time = 1950
* CHECK dout0_15 vdout0_15ck194 = 0 time = 1950
* CHECK dout0_16 vdout0_16ck194 = 3.3 time = 1950
* CHECK dout0_17 vdout0_17ck194 = 3.3 time = 1950
* CHECK dout0_18 vdout0_18ck194 = 0 time = 1950
* CHECK dout0_19 vdout0_19ck194 = 0 time = 1950
* CHECK dout0_20 vdout0_20ck194 = 0 time = 1950
* CHECK dout0_21 vdout0_21ck194 = 3.3 time = 1950
* CHECK dout0_22 vdout0_22ck194 = 3.3 time = 1950
* CHECK dout0_23 vdout0_23ck194 = 3.3 time = 1950
* CHECK dout0_24 vdout0_24ck194 = 3.3 time = 1950
* CHECK dout0_25 vdout0_25ck194 = 0 time = 1950
* CHECK dout0_26 vdout0_26ck194 = 0 time = 1950
* CHECK dout0_27 vdout0_27ck194 = 0 time = 1950
* CHECK dout0_28 vdout0_28ck194 = 0 time = 1950
* CHECK dout0_29 vdout0_29ck194 = 3.3 time = 1950
* CHECK dout0_30 vdout0_30ck194 = 0 time = 1950
* CHECK dout0_31 vdout0_31ck194 = 3.3 time = 1950
* CHECK dout0_0 vdout0_0ck195 = 3.3 time = 1960
* CHECK dout0_1 vdout0_1ck195 = 0 time = 1960
* CHECK dout0_2 vdout0_2ck195 = 3.3 time = 1960
* CHECK dout0_3 vdout0_3ck195 = 3.3 time = 1960
* CHECK dout0_4 vdout0_4ck195 = 0 time = 1960
* CHECK dout0_5 vdout0_5ck195 = 3.3 time = 1960
* CHECK dout0_6 vdout0_6ck195 = 0 time = 1960
* CHECK dout0_7 vdout0_7ck195 = 3.3 time = 1960
* CHECK dout0_8 vdout0_8ck195 = 0 time = 1960
* CHECK dout0_9 vdout0_9ck195 = 3.3 time = 1960
* CHECK dout0_10 vdout0_10ck195 = 3.3 time = 1960
* CHECK dout0_11 vdout0_11ck195 = 0 time = 1960
* CHECK dout0_12 vdout0_12ck195 = 0 time = 1960
* CHECK dout0_13 vdout0_13ck195 = 3.3 time = 1960
* CHECK dout0_14 vdout0_14ck195 = 0 time = 1960
* CHECK dout0_15 vdout0_15ck195 = 0 time = 1960
* CHECK dout0_16 vdout0_16ck195 = 3.3 time = 1960
* CHECK dout0_17 vdout0_17ck195 = 3.3 time = 1960
* CHECK dout0_18 vdout0_18ck195 = 0 time = 1960
* CHECK dout0_19 vdout0_19ck195 = 0 time = 1960
* CHECK dout0_20 vdout0_20ck195 = 0 time = 1960
* CHECK dout0_21 vdout0_21ck195 = 3.3 time = 1960
* CHECK dout0_22 vdout0_22ck195 = 3.3 time = 1960
* CHECK dout0_23 vdout0_23ck195 = 3.3 time = 1960
* CHECK dout0_24 vdout0_24ck195 = 3.3 time = 1960
* CHECK dout0_25 vdout0_25ck195 = 0 time = 1960
* CHECK dout0_26 vdout0_26ck195 = 0 time = 1960
* CHECK dout0_27 vdout0_27ck195 = 0 time = 1960
* CHECK dout0_28 vdout0_28ck195 = 0 time = 1960
* CHECK dout0_29 vdout0_29ck195 = 3.3 time = 1960
* CHECK dout0_30 vdout0_30ck195 = 0 time = 1960
* CHECK dout0_31 vdout0_31ck195 = 3.3 time = 1960
* CHECK dout1_0 vdout1_0ck195 = 0 time = 1960
* CHECK dout1_1 vdout1_1ck195 = 0 time = 1960
* CHECK dout1_2 vdout1_2ck195 = 0 time = 1960
* CHECK dout1_3 vdout1_3ck195 = 3.3 time = 1960
* CHECK dout1_4 vdout1_4ck195 = 3.3 time = 1960
* CHECK dout1_5 vdout1_5ck195 = 3.3 time = 1960
* CHECK dout1_6 vdout1_6ck195 = 0 time = 1960
* CHECK dout1_7 vdout1_7ck195 = 3.3 time = 1960
* CHECK dout1_8 vdout1_8ck195 = 3.3 time = 1960
* CHECK dout1_9 vdout1_9ck195 = 0 time = 1960
* CHECK dout1_10 vdout1_10ck195 = 0 time = 1960
* CHECK dout1_11 vdout1_11ck195 = 3.3 time = 1960
* CHECK dout1_12 vdout1_12ck195 = 0 time = 1960
* CHECK dout1_13 vdout1_13ck195 = 3.3 time = 1960
* CHECK dout1_14 vdout1_14ck195 = 0 time = 1960
* CHECK dout1_15 vdout1_15ck195 = 3.3 time = 1960
* CHECK dout1_16 vdout1_16ck195 = 0 time = 1960
* CHECK dout1_17 vdout1_17ck195 = 3.3 time = 1960
* CHECK dout1_18 vdout1_18ck195 = 0 time = 1960
* CHECK dout1_19 vdout1_19ck195 = 3.3 time = 1960
* CHECK dout1_20 vdout1_20ck195 = 3.3 time = 1960
* CHECK dout1_21 vdout1_21ck195 = 3.3 time = 1960
* CHECK dout1_22 vdout1_22ck195 = 3.3 time = 1960
* CHECK dout1_23 vdout1_23ck195 = 3.3 time = 1960
* CHECK dout1_24 vdout1_24ck195 = 0 time = 1960
* CHECK dout1_25 vdout1_25ck195 = 3.3 time = 1960
* CHECK dout1_26 vdout1_26ck195 = 0 time = 1960
* CHECK dout1_27 vdout1_27ck195 = 0 time = 1960
* CHECK dout1_28 vdout1_28ck195 = 0 time = 1960
* CHECK dout1_29 vdout1_29ck195 = 0 time = 1960
* CHECK dout1_30 vdout1_30ck195 = 3.3 time = 1960
* CHECK dout1_31 vdout1_31ck195 = 3.3 time = 1960
* CHECK dout1_0 vdout1_0ck197 = 3.3 time = 1980
* CHECK dout1_1 vdout1_1ck197 = 3.3 time = 1980
* CHECK dout1_2 vdout1_2ck197 = 0 time = 1980
* CHECK dout1_3 vdout1_3ck197 = 0 time = 1980
* CHECK dout1_4 vdout1_4ck197 = 3.3 time = 1980
* CHECK dout1_5 vdout1_5ck197 = 3.3 time = 1980
* CHECK dout1_6 vdout1_6ck197 = 3.3 time = 1980
* CHECK dout1_7 vdout1_7ck197 = 3.3 time = 1980
* CHECK dout1_8 vdout1_8ck197 = 3.3 time = 1980
* CHECK dout1_9 vdout1_9ck197 = 3.3 time = 1980
* CHECK dout1_10 vdout1_10ck197 = 0 time = 1980
* CHECK dout1_11 vdout1_11ck197 = 0 time = 1980
* CHECK dout1_12 vdout1_12ck197 = 0 time = 1980
* CHECK dout1_13 vdout1_13ck197 = 3.3 time = 1980
* CHECK dout1_14 vdout1_14ck197 = 0 time = 1980
* CHECK dout1_15 vdout1_15ck197 = 3.3 time = 1980
* CHECK dout1_16 vdout1_16ck197 = 3.3 time = 1980
* CHECK dout1_17 vdout1_17ck197 = 0 time = 1980
* CHECK dout1_18 vdout1_18ck197 = 0 time = 1980
* CHECK dout1_19 vdout1_19ck197 = 0 time = 1980
* CHECK dout1_20 vdout1_20ck197 = 0 time = 1980
* CHECK dout1_21 vdout1_21ck197 = 0 time = 1980
* CHECK dout1_22 vdout1_22ck197 = 3.3 time = 1980
* CHECK dout1_23 vdout1_23ck197 = 0 time = 1980
* CHECK dout1_24 vdout1_24ck197 = 0 time = 1980
* CHECK dout1_25 vdout1_25ck197 = 3.3 time = 1980
* CHECK dout1_26 vdout1_26ck197 = 3.3 time = 1980
* CHECK dout1_27 vdout1_27ck197 = 3.3 time = 1980
* CHECK dout1_28 vdout1_28ck197 = 0 time = 1980
* CHECK dout1_29 vdout1_29ck197 = 3.3 time = 1980
* CHECK dout1_30 vdout1_30ck197 = 0 time = 1980
* CHECK dout1_31 vdout1_31ck197 = 0 time = 1980
* CHECK dout0_0 vdout0_0ck198 = 0 time = 1990
* CHECK dout0_1 vdout0_1ck198 = 0 time = 1990
* CHECK dout0_2 vdout0_2ck198 = 0 time = 1990
* CHECK dout0_3 vdout0_3ck198 = 3.3 time = 1990
* CHECK dout0_4 vdout0_4ck198 = 3.3 time = 1990
* CHECK dout0_5 vdout0_5ck198 = 3.3 time = 1990
* CHECK dout0_6 vdout0_6ck198 = 0 time = 1990
* CHECK dout0_7 vdout0_7ck198 = 3.3 time = 1990
* CHECK dout0_8 vdout0_8ck198 = 3.3 time = 1990
* CHECK dout0_9 vdout0_9ck198 = 0 time = 1990
* CHECK dout0_10 vdout0_10ck198 = 0 time = 1990
* CHECK dout0_11 vdout0_11ck198 = 3.3 time = 1990
* CHECK dout0_12 vdout0_12ck198 = 0 time = 1990
* CHECK dout0_13 vdout0_13ck198 = 3.3 time = 1990
* CHECK dout0_14 vdout0_14ck198 = 0 time = 1990
* CHECK dout0_15 vdout0_15ck198 = 3.3 time = 1990
* CHECK dout0_16 vdout0_16ck198 = 0 time = 1990
* CHECK dout0_17 vdout0_17ck198 = 3.3 time = 1990
* CHECK dout0_18 vdout0_18ck198 = 0 time = 1990
* CHECK dout0_19 vdout0_19ck198 = 3.3 time = 1990
* CHECK dout0_20 vdout0_20ck198 = 3.3 time = 1990
* CHECK dout0_21 vdout0_21ck198 = 3.3 time = 1990
* CHECK dout0_22 vdout0_22ck198 = 3.3 time = 1990
* CHECK dout0_23 vdout0_23ck198 = 3.3 time = 1990
* CHECK dout0_24 vdout0_24ck198 = 0 time = 1990
* CHECK dout0_25 vdout0_25ck198 = 3.3 time = 1990
* CHECK dout0_26 vdout0_26ck198 = 0 time = 1990
* CHECK dout0_27 vdout0_27ck198 = 0 time = 1990
* CHECK dout0_28 vdout0_28ck198 = 0 time = 1990
* CHECK dout0_29 vdout0_29ck198 = 0 time = 1990
* CHECK dout0_30 vdout0_30ck198 = 3.3 time = 1990
* CHECK dout0_31 vdout0_31ck198 = 3.3 time = 1990
* CHECK dout0_0 vdout0_0ck201 = 3.3 time = 2020
* CHECK dout0_1 vdout0_1ck201 = 0 time = 2020
* CHECK dout0_2 vdout0_2ck201 = 0 time = 2020
* CHECK dout0_3 vdout0_3ck201 = 0 time = 2020
* CHECK dout0_4 vdout0_4ck201 = 0 time = 2020
* CHECK dout0_5 vdout0_5ck201 = 0 time = 2020
* CHECK dout0_6 vdout0_6ck201 = 3.3 time = 2020
* CHECK dout0_7 vdout0_7ck201 = 3.3 time = 2020
* CHECK dout0_8 vdout0_8ck201 = 0 time = 2020
* CHECK dout0_9 vdout0_9ck201 = 3.3 time = 2020
* CHECK dout0_10 vdout0_10ck201 = 3.3 time = 2020
* CHECK dout0_11 vdout0_11ck201 = 3.3 time = 2020
* CHECK dout0_12 vdout0_12ck201 = 0 time = 2020
* CHECK dout0_13 vdout0_13ck201 = 0 time = 2020
* CHECK dout0_14 vdout0_14ck201 = 0 time = 2020
* CHECK dout0_15 vdout0_15ck201 = 3.3 time = 2020
* CHECK dout0_16 vdout0_16ck201 = 0 time = 2020
* CHECK dout0_17 vdout0_17ck201 = 3.3 time = 2020
* CHECK dout0_18 vdout0_18ck201 = 0 time = 2020
* CHECK dout0_19 vdout0_19ck201 = 3.3 time = 2020
* CHECK dout0_20 vdout0_20ck201 = 0 time = 2020
* CHECK dout0_21 vdout0_21ck201 = 0 time = 2020
* CHECK dout0_22 vdout0_22ck201 = 3.3 time = 2020
* CHECK dout0_23 vdout0_23ck201 = 0 time = 2020
* CHECK dout0_24 vdout0_24ck201 = 0 time = 2020
* CHECK dout0_25 vdout0_25ck201 = 3.3 time = 2020
* CHECK dout0_26 vdout0_26ck201 = 3.3 time = 2020
* CHECK dout0_27 vdout0_27ck201 = 0 time = 2020
* CHECK dout0_28 vdout0_28ck201 = 3.3 time = 2020
* CHECK dout0_29 vdout0_29ck201 = 3.3 time = 2020
* CHECK dout0_30 vdout0_30ck201 = 3.3 time = 2020
* CHECK dout0_31 vdout0_31ck201 = 0 time = 2020
* CHECK dout0_0 vdout0_0ck202 = 3.3 time = 2030
* CHECK dout0_1 vdout0_1ck202 = 3.3 time = 2030
* CHECK dout0_2 vdout0_2ck202 = 3.3 time = 2030
* CHECK dout0_3 vdout0_3ck202 = 0 time = 2030
* CHECK dout0_4 vdout0_4ck202 = 0 time = 2030
* CHECK dout0_5 vdout0_5ck202 = 0 time = 2030
* CHECK dout0_6 vdout0_6ck202 = 3.3 time = 2030
* CHECK dout0_7 vdout0_7ck202 = 0 time = 2030
* CHECK dout0_8 vdout0_8ck202 = 0 time = 2030
* CHECK dout0_9 vdout0_9ck202 = 0 time = 2030
* CHECK dout0_10 vdout0_10ck202 = 0 time = 2030
* CHECK dout0_11 vdout0_11ck202 = 0 time = 2030
* CHECK dout0_12 vdout0_12ck202 = 3.3 time = 2030
* CHECK dout0_13 vdout0_13ck202 = 3.3 time = 2030
* CHECK dout0_14 vdout0_14ck202 = 3.3 time = 2030
* CHECK dout0_15 vdout0_15ck202 = 0 time = 2030
* CHECK dout0_16 vdout0_16ck202 = 3.3 time = 2030
* CHECK dout0_17 vdout0_17ck202 = 0 time = 2030
* CHECK dout0_18 vdout0_18ck202 = 0 time = 2030
* CHECK dout0_19 vdout0_19ck202 = 0 time = 2030
* CHECK dout0_20 vdout0_20ck202 = 0 time = 2030
* CHECK dout0_21 vdout0_21ck202 = 3.3 time = 2030
* CHECK dout0_22 vdout0_22ck202 = 3.3 time = 2030
* CHECK dout0_23 vdout0_23ck202 = 0 time = 2030
* CHECK dout0_24 vdout0_24ck202 = 3.3 time = 2030
* CHECK dout0_25 vdout0_25ck202 = 3.3 time = 2030
* CHECK dout0_26 vdout0_26ck202 = 3.3 time = 2030
* CHECK dout0_27 vdout0_27ck202 = 3.3 time = 2030
* CHECK dout0_28 vdout0_28ck202 = 3.3 time = 2030
* CHECK dout0_29 vdout0_29ck202 = 3.3 time = 2030
* CHECK dout0_30 vdout0_30ck202 = 0 time = 2030
* CHECK dout0_31 vdout0_31ck202 = 3.3 time = 2030
* CHECK dout0_0 vdout0_0ck203 = 0 time = 2040
* CHECK dout0_1 vdout0_1ck203 = 0 time = 2040
* CHECK dout0_2 vdout0_2ck203 = 3.3 time = 2040
* CHECK dout0_3 vdout0_3ck203 = 3.3 time = 2040
* CHECK dout0_4 vdout0_4ck203 = 3.3 time = 2040
* CHECK dout0_5 vdout0_5ck203 = 0 time = 2040
* CHECK dout0_6 vdout0_6ck203 = 0 time = 2040
* CHECK dout0_7 vdout0_7ck203 = 3.3 time = 2040
* CHECK dout0_8 vdout0_8ck203 = 0 time = 2040
* CHECK dout0_9 vdout0_9ck203 = 0 time = 2040
* CHECK dout0_10 vdout0_10ck203 = 3.3 time = 2040
* CHECK dout0_11 vdout0_11ck203 = 0 time = 2040
* CHECK dout0_12 vdout0_12ck203 = 3.3 time = 2040
* CHECK dout0_13 vdout0_13ck203 = 0 time = 2040
* CHECK dout0_14 vdout0_14ck203 = 3.3 time = 2040
* CHECK dout0_15 vdout0_15ck203 = 0 time = 2040
* CHECK dout0_16 vdout0_16ck203 = 3.3 time = 2040
* CHECK dout0_17 vdout0_17ck203 = 0 time = 2040
* CHECK dout0_18 vdout0_18ck203 = 0 time = 2040
* CHECK dout0_19 vdout0_19ck203 = 0 time = 2040
* CHECK dout0_20 vdout0_20ck203 = 3.3 time = 2040
* CHECK dout0_21 vdout0_21ck203 = 3.3 time = 2040
* CHECK dout0_22 vdout0_22ck203 = 3.3 time = 2040
* CHECK dout0_23 vdout0_23ck203 = 0 time = 2040
* CHECK dout0_24 vdout0_24ck203 = 0 time = 2040
* CHECK dout0_25 vdout0_25ck203 = 0 time = 2040
* CHECK dout0_26 vdout0_26ck203 = 3.3 time = 2040
* CHECK dout0_27 vdout0_27ck203 = 0 time = 2040
* CHECK dout0_28 vdout0_28ck203 = 0 time = 2040
* CHECK dout0_29 vdout0_29ck203 = 0 time = 2040
* CHECK dout0_30 vdout0_30ck203 = 3.3 time = 2040
* CHECK dout0_31 vdout0_31ck203 = 0 time = 2040
* CHECK dout0_0 vdout0_0ck204 = 3.3 time = 2050
* CHECK dout0_1 vdout0_1ck204 = 3.3 time = 2050
* CHECK dout0_2 vdout0_2ck204 = 3.3 time = 2050
* CHECK dout0_3 vdout0_3ck204 = 0 time = 2050
* CHECK dout0_4 vdout0_4ck204 = 0 time = 2050
* CHECK dout0_5 vdout0_5ck204 = 0 time = 2050
* CHECK dout0_6 vdout0_6ck204 = 3.3 time = 2050
* CHECK dout0_7 vdout0_7ck204 = 0 time = 2050
* CHECK dout0_8 vdout0_8ck204 = 0 time = 2050
* CHECK dout0_9 vdout0_9ck204 = 0 time = 2050
* CHECK dout0_10 vdout0_10ck204 = 0 time = 2050
* CHECK dout0_11 vdout0_11ck204 = 0 time = 2050
* CHECK dout0_12 vdout0_12ck204 = 3.3 time = 2050
* CHECK dout0_13 vdout0_13ck204 = 3.3 time = 2050
* CHECK dout0_14 vdout0_14ck204 = 3.3 time = 2050
* CHECK dout0_15 vdout0_15ck204 = 0 time = 2050
* CHECK dout0_16 vdout0_16ck204 = 3.3 time = 2050
* CHECK dout0_17 vdout0_17ck204 = 0 time = 2050
* CHECK dout0_18 vdout0_18ck204 = 0 time = 2050
* CHECK dout0_19 vdout0_19ck204 = 0 time = 2050
* CHECK dout0_20 vdout0_20ck204 = 0 time = 2050
* CHECK dout0_21 vdout0_21ck204 = 3.3 time = 2050
* CHECK dout0_22 vdout0_22ck204 = 3.3 time = 2050
* CHECK dout0_23 vdout0_23ck204 = 0 time = 2050
* CHECK dout0_24 vdout0_24ck204 = 3.3 time = 2050
* CHECK dout0_25 vdout0_25ck204 = 3.3 time = 2050
* CHECK dout0_26 vdout0_26ck204 = 3.3 time = 2050
* CHECK dout0_27 vdout0_27ck204 = 3.3 time = 2050
* CHECK dout0_28 vdout0_28ck204 = 3.3 time = 2050
* CHECK dout0_29 vdout0_29ck204 = 3.3 time = 2050
* CHECK dout0_30 vdout0_30ck204 = 0 time = 2050
* CHECK dout0_31 vdout0_31ck204 = 3.3 time = 2050
.include /lscratch/fanals/asic-data-operation/OpenRAM/temp2/functional_meas.sp
.OPTIONS DEVICE TEMP=25
.OPTIONS MEASURE MEASFAIL=1
.OPTIONS LINSOL type=klu
.OPTIONS TIMEINT RELTOL=1e-3 ABSTOL=1e-6 method=gear minorder=2
.TRAN 10p 2060n 0n 10p
* probe is used for hspice/xa, while plot is used in ngspice
*.probe V(*)
*.plot V(*)
.end
