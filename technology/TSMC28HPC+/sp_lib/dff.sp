** Generated for: hspiceD
** Generated on: Apr 23 13:42:05 2025
** Design library name: OpenRAM_cells
** Design cell name: ADO_DFCND1_HK
** Design view name: schematic

.TEMP 25
.OPTION
+    ARTIST=2
+    INGOLD=2
+    PARHIER=LOCAL
+    PSF=2
+    HIER_DELIM=0
.LIB "/lscratch/TSMC28HPC+/TSMC28nm/models/hspice/toplevel.l" TOP_TT

** Library name: tcbn28hpcplusbwp35p140
** Cell name: DFCND1BWP35P140
** View name: schematic
.subckt DFCND1BWP35P140 d cp cdn q qn vdd vss
xmm73 net172 qf_x vss vss nch_mac l=35e-9 w=280e-9 multi=1 nf=1 sd=100e-9 ad=21e-15 as=21e-15 pd=710e-9 ps=710e-9 nrd=1.382006 nrs=1.382006 sa=75e-9 sb=75e-9 sa1=75e-9 sa2=75e-9 sa3=75e-9 sa4=75e-9 sb1=75e-9 sb2=75e-9 sb3=75e-9 spa=100e-9 spa1=100e-9 spa2=100e-9 spa3=100e-9 sap=91.9776e-9 sapb=114.444e-9 spba=115.996e-9 spba1=117.547e-9 dfm_flag=0 spmt=1.11111e15 spomt=0 spomt1=1.11111e60 spmb=1.11111e15 spomb=0 spomb1=1.11111e60
xmsltn1 qf clkbb mq vss nch_mac l=35e-9 w=250e-9 multi=1 nf=1 sd=100e-9 ad=18.75e-15 as=18.75e-15 pd=650e-9 ps=650e-9 nrd=1.338763 nrs=1.338763 sa=75e-9 sb=75e-9 sa1=75e-9 sa2=75e-9 sa3=75e-9 sa4=75e-9 sb1=75e-9 sb2=75e-9 sb3=75e-9 spa=100e-9 spa1=100e-9 spa2=100e-9 spa3=100e-9 sap=91.9776e-9 sapb=114.444e-9 spba=115.996e-9 spba1=117.547e-9 dfm_flag=0 spmt=1.11111e15 spomt=0 spomt1=1.11111e60 spmb=1.11111e15 spomb=0 spomb1=1.11111e60
xmm67 net172 clkb qf vss nch_mac l=35e-9 w=250e-9 multi=1 nf=1 sd=100e-9 ad=18.75e-15 as=18.75e-15 pd=650e-9 ps=650e-9 nrd=1.338763 nrs=1.338763 sa=75e-9 sb=75e-9 sa1=75e-9 sa2=75e-9 sa3=75e-9 sa4=75e-9 sb1=75e-9 sb2=75e-9 sb3=75e-9 spa=100e-9 spa1=100e-9 spa2=100e-9 spa3=100e-9 sap=91.9776e-9 sapb=114.444e-9 spba=115.996e-9 spba1=117.547e-9 dfm_flag=0 spmt=1.11111e15 spomt=0 spomt1=1.11111e60 spmb=1.11111e15 spomb=0 spomb1=1.11111e60
xmm69 qn net172 vss vss nch_mac l=35e-9 w=280e-9 multi=1 nf=1 sd=100e-9 ad=21e-15 as=21e-15 pd=710e-9 ps=710e-9 nrd=1.382006 nrs=1.382006 sa=75e-9 sb=75e-9 sa1=75e-9 sa2=75e-9 sa3=75e-9 sa4=75e-9 sb1=75e-9 sb2=75e-9 sb3=75e-9 spa=100e-9 spa1=100e-9 spa2=100e-9 spa3=100e-9 sap=91.9776e-9 sapb=114.444e-9 spba=115.996e-9 spba1=117.547e-9 dfm_flag=0 spmt=1.11111e15 spomt=0 spomt1=1.11111e60 spmb=1.11111e15 spomb=0 spomb1=1.11111e60
xmm71 q qf_x vss vss nch_mac l=35e-9 w=280e-9 multi=1 nf=1 sd=100e-9 ad=21e-15 as=21e-15 pd=710e-9 ps=710e-9 nrd=1.382006 nrs=1.382006 sa=75e-9 sb=75e-9 sa1=75e-9 sa2=75e-9 sa3=75e-9 sa4=75e-9 sb1=75e-9 sb2=75e-9 sb3=75e-9 spa=100e-9 spa1=100e-9 spa2=100e-9 spa3=100e-9 sap=91.9776e-9 sapb=114.444e-9 spba=115.996e-9 spba1=117.547e-9 dfm_flag=0 spmt=1.11111e15 spomt=0 spomt1=1.11111e60 spmb=1.11111e15 spomb=0 spomb1=1.11111e60
xmm65 net176 mq net184 vss nch_mac l=35e-9 w=120e-9 multi=1 nf=1 sd=100e-9 ad=9e-15 as=9e-15 pd=390e-9 ps=390e-9 nrd=2.627076 nrs=2.627076 sa=75e-9 sb=75e-9 sa1=75e-9 sa2=75e-9 sa3=75e-9 sa4=75e-9 sb1=75e-9 sb2=75e-9 sb3=75e-9 spa=100e-9 spa1=100e-9 spa2=100e-9 spa3=100e-9 sap=91.9776e-9 sapb=114.444e-9 spba=115.996e-9 spba1=117.547e-9 dfm_flag=0 spmt=1.11111e15 spomt=0 spomt1=1.11111e60 spmb=1.11111e15 spomb=0 spomb1=1.11111e60
xmm64 mq_x clkbb net176 vss nch_mac l=35e-9 w=120e-9 multi=1 nf=1 sd=100e-9 ad=9e-15 as=9e-15 pd=390e-9 ps=390e-9 nrd=2.627076 nrs=2.627076 sa=75e-9 sb=75e-9 sa1=75e-9 sa2=75e-9 sa3=75e-9 sa4=75e-9 sb1=75e-9 sb2=75e-9 sb3=75e-9 spa=100e-9 spa1=100e-9 spa2=100e-9 spa3=100e-9 sap=91.9776e-9 sapb=114.444e-9 spba=115.996e-9 spba1=117.547e-9 dfm_flag=0 spmt=1.11111e15 spomt=0 spomt1=1.11111e60 spmb=1.11111e15 spomb=0 spomb1=1.11111e60
xmm66 net184 cdn vss vss nch_mac l=35e-9 w=120e-9 multi=1 nf=1 sd=100e-9 ad=9e-15 as=9e-15 pd=390e-9 ps=390e-9 nrd=2.627076 nrs=2.627076 sa=75e-9 sb=75e-9 sa1=75e-9 sa2=75e-9 sa3=75e-9 sa4=75e-9 sb1=75e-9 sb2=75e-9 sb3=75e-9 spa=100e-9 spa1=100e-9 spa2=100e-9 spa3=100e-9 sap=91.9776e-9 sapb=114.444e-9 spba=115.996e-9 spba1=117.547e-9 dfm_flag=0 spmt=1.11111e15 spomt=0 spomt1=1.11111e60 spmb=1.11111e15 spomb=0 spomb1=1.11111e60
xmm55 clkbb clkb vss vss nch_mac l=35e-9 w=140e-9 multi=1 nf=1 sd=100e-9 ad=10.5e-15 as=10.5e-15 pd=430e-9 ps=430e-9 nrd=2.677526 nrs=2.677526 sa=75e-9 sb=75e-9 sa1=75e-9 sa2=75e-9 sa3=75e-9 sa4=75e-9 sb1=75e-9 sb2=75e-9 sb3=75e-9 spa=100e-9 spa1=100e-9 spa2=100e-9 spa3=100e-9 sap=91.9776e-9 sapb=114.444e-9 spba=115.996e-9 spba1=117.547e-9 dfm_flag=0 spmt=1.11111e15 spomt=0 spomt1=1.11111e60 spmb=1.11111e15 spomb=0 spomb1=1.11111e60
xmm46 mq_x clkb net212 vss nch_mac l=35e-9 w=185e-9 multi=1 nf=1 sd=100e-9 ad=13.875e-15 as=13.875e-15 pd=520e-9 ps=520e-9 nrd=2.791039 nrs=2.791039 sa=75e-9 sb=75e-9 sa1=75e-9 sa2=75e-9 sa3=75e-9 sa4=75e-9 sb1=75e-9 sb2=75e-9 sb3=75e-9 spa=100e-9 spa1=100e-9 spa2=100e-9 spa3=100e-9 sap=91.9776e-9 sapb=114.444e-9 spba=115.996e-9 spba1=117.547e-9 dfm_flag=0 spmt=1.11111e15 spomt=0 spomt1=1.11111e60 spmb=1.11111e15 spomb=0 spomb1=1.11111e60
xmm76 qf_x qf net208 vss nch_mac l=35e-9 w=280e-9 multi=1 nf=1 sd=100e-9 ad=21e-15 as=21e-15 pd=710e-9 ps=710e-9 nrd=1.382006 nrs=1.382006 sa=75e-9 sb=75e-9 sa1=75e-9 sa2=75e-9 sa3=75e-9 sa4=75e-9 sb1=75e-9 sb2=75e-9 sb3=75e-9 spa=100e-9 spa1=100e-9 spa2=100e-9 spa3=100e-9 sap=91.9776e-9 sapb=114.444e-9 spba=115.996e-9 spba1=117.547e-9 dfm_flag=0 spmt=1.11111e15 spomt=0 spomt1=1.11111e60 spmb=1.11111e15 spomb=0 spomb1=1.11111e60
xmm1 mq mq_x vss vss nch_mac l=35e-9 w=280e-9 multi=1 nf=1 sd=100e-9 ad=21e-15 as=21e-15 pd=710e-9 ps=710e-9 nrd=1.382006 nrs=1.382006 sa=75e-9 sb=75e-9 sa1=75e-9 sa2=75e-9 sa3=75e-9 sa4=75e-9 sb1=75e-9 sb2=75e-9 sb3=75e-9 spa=100e-9 spa1=100e-9 spa2=100e-9 spa3=100e-9 sap=91.9776e-9 sapb=114.444e-9 spba=115.996e-9 spba1=117.547e-9 dfm_flag=0 spmt=1.11111e15 spomt=0 spomt1=1.11111e60 spmb=1.11111e15 spomb=0 spomb1=1.11111e60
xmm53 clkb cp vss vss nch_mac l=35e-9 w=140e-9 multi=1 nf=1 sd=100e-9 ad=10.5e-15 as=10.5e-15 pd=430e-9 ps=430e-9 nrd=2.677526 nrs=2.677526 sa=75e-9 sb=75e-9 sa1=75e-9 sa2=75e-9 sa3=75e-9 sa4=75e-9 sb1=75e-9 sb2=75e-9 sb3=75e-9 spa=100e-9 spa1=100e-9 spa2=100e-9 spa3=100e-9 sap=91.9776e-9 sapb=114.444e-9 spba=115.996e-9 spba1=117.547e-9 dfm_flag=0 spmt=1.11111e15 spomt=0 spomt1=1.11111e60 spmb=1.11111e15 spomb=0 spomb1=1.11111e60
xmm75 net208 cdn vss vss nch_mac l=35e-9 w=280e-9 multi=1 nf=1 sd=100e-9 ad=21e-15 as=21e-15 pd=710e-9 ps=710e-9 nrd=1.382006 nrs=1.382006 sa=75e-9 sb=75e-9 sa1=75e-9 sa2=75e-9 sa3=75e-9 sa4=75e-9 sb1=75e-9 sb2=75e-9 sb3=75e-9 spa=100e-9 spa1=100e-9 spa2=100e-9 spa3=100e-9 sap=91.9776e-9 sapb=114.444e-9 spba=115.996e-9 spba1=117.547e-9 dfm_flag=0 spmt=1.11111e15 spomt=0 spomt1=1.11111e60 spmb=1.11111e15 spomb=0 spomb1=1.11111e60
xmm47 net212 d vss vss nch_mac l=35e-9 w=185e-9 multi=1 nf=1 sd=100e-9 ad=13.875e-15 as=13.875e-15 pd=520e-9 ps=520e-9 nrd=2.791039 nrs=2.791039 sa=75e-9 sb=75e-9 sa1=75e-9 sa2=75e-9 sa3=75e-9 sa4=75e-9 sb1=75e-9 sb2=75e-9 sb3=75e-9 spa=100e-9 spa1=100e-9 spa2=100e-9 spa3=100e-9 sap=91.9776e-9 sapb=114.444e-9 spba=115.996e-9 spba1=117.547e-9 dfm_flag=0 spmt=1.11111e15 spomt=0 spomt1=1.11111e60 spmb=1.11111e15 spomb=0 spomb1=1.11111e60
xmm45 mq_x clkbb net103 vdd pch_mac l=35e-9 w=295e-9 multi=1 nf=1 sd=100e-9 ad=22.125e-15 as=22.125e-15 pd=740e-9 ps=740e-9 nrd=837.099e-3 nrs=837.099e-3 sa=75e-9 sb=75e-9 sa1=75e-9 sa2=75e-9 sa3=75e-9 sa4=75e-9 sb1=75e-9 sb2=75e-9 sb3=75e-9 spa=100e-9 spa1=100e-9 spa2=100e-9 spa3=100e-9 sap=91.9776e-9 sapb=114.444e-9 spba=115.996e-9 spba1=117.547e-9 dfm_flag=0 spmt=1.11111e15 spomt=0 spomt1=1.11111e60 spmb=1.11111e15 spomb=0 spomb1=1.11111e60
xmm70 qn net172 vdd vdd pch_mac l=35e-9 w=340e-9 multi=1 nf=1 sd=100e-9 ad=25.5e-15 as=25.5e-15 pd=830e-9 ps=830e-9 nrd=500.473e-3 nrs=500.473e-3 sa=75e-9 sb=75e-9 sa1=75e-9 sa2=75e-9 sa3=75e-9 sa4=75e-9 sb1=75e-9 sb2=75e-9 sb3=75e-9 spa=100e-9 spa1=100e-9 spa2=100e-9 spa3=100e-9 sap=91.9776e-9 sapb=114.444e-9 spba=115.996e-9 spba1=117.547e-9 dfm_flag=0 spmt=1.11111e15 spomt=0 spomt1=1.11111e60 spmb=1.11111e15 spomb=0 spomb1=1.11111e60
xmm74 net172 qf_x vdd vdd pch_mac l=35e-9 w=295e-9 multi=1 nf=1 sd=100e-9 ad=22.125e-15 as=22.125e-15 pd=740e-9 ps=740e-9 nrd=837.099e-3 nrs=837.099e-3 sa=75e-9 sb=75e-9 sa1=75e-9 sa2=75e-9 sa3=75e-9 sa4=75e-9 sb1=75e-9 sb2=75e-9 sb3=75e-9 spa=100e-9 spa1=100e-9 spa2=100e-9 spa3=100e-9 sap=91.9776e-9 sapb=114.444e-9 spba=115.996e-9 spba1=117.547e-9 dfm_flag=0 spmt=1.11111e15 spomt=0 spomt1=1.11111e60 spmb=1.11111e15 spomb=0 spomb1=1.11111e60
xmm3 net0149 cdn vdd vdd pch_mac l=35e-9 w=100e-9 multi=1 nf=1 sd=100e-9 ad=7.5e-15 as=7.5e-15 pd=350e-9 ps=350e-9 nrd=1.466664 nrs=1.466664 sa=75e-9 sb=75e-9 sa1=75e-9 sa2=75e-9 sa3=75e-9 sa4=75e-9 sb1=75e-9 sb2=75e-9 sb3=75e-9 spa=100e-9 spa1=100e-9 spa2=100e-9 spa3=100e-9 sap=91.9776e-9 sapb=114.444e-9 spba=115.996e-9 spba1=117.547e-9 dfm_flag=0 spmt=1.11111e15 spomt=0 spomt1=1.11111e60 spmb=1.11111e15 spomb=0 spomb1=1.11111e60
xmm0 mq mq_x vdd vdd pch_mac l=35e-9 w=295e-9 multi=1 nf=1 sd=100e-9 ad=22.125e-15 as=22.125e-15 pd=740e-9 ps=740e-9 nrd=837.099e-3 nrs=837.099e-3 sa=75e-9 sb=75e-9 sa1=75e-9 sa2=75e-9 sa3=75e-9 sa4=75e-9 sb1=75e-9 sb2=75e-9 sb3=75e-9 spa=100e-9 spa1=100e-9 spa2=100e-9 spa3=100e-9 sap=91.9776e-9 sapb=114.444e-9 spba=115.996e-9 spba1=117.547e-9 dfm_flag=0 spmt=1.11111e15 spomt=0 spomt1=1.11111e60 spmb=1.11111e15 spomb=0 spomb1=1.11111e60
xmm4 net0149 mq vdd vdd pch_mac l=35e-9 w=100e-9 multi=1 nf=1 sd=100e-9 ad=7.5e-15 as=7.5e-15 pd=350e-9 ps=350e-9 nrd=1.466664 nrs=1.466664 sa=75e-9 sb=75e-9 sa1=75e-9 sa2=75e-9 sa3=75e-9 sa4=75e-9 sb1=75e-9 sb2=75e-9 sb3=75e-9 spa=100e-9 spa1=100e-9 spa2=100e-9 spa3=100e-9 sap=91.9776e-9 sapb=114.444e-9 spba=115.996e-9 spba1=117.547e-9 dfm_flag=0 spmt=1.11111e15 spomt=0 spomt1=1.11111e60 spmb=1.11111e15 spomb=0 spomb1=1.11111e60
xmm56 clkbb clkb vdd vdd pch_mac l=35e-9 w=170e-9 multi=1 nf=1 sd=100e-9 ad=12.75e-15 as=12.75e-15 pd=490e-9 ps=490e-9 nrd=1.62222 nrs=1.62222 sa=75e-9 sb=75e-9 sa1=75e-9 sa2=75e-9 sa3=75e-9 sa4=75e-9 sb1=75e-9 sb2=75e-9 sb3=75e-9 spa=100e-9 spa1=100e-9 spa2=100e-9 spa3=100e-9 sap=91.9776e-9 sapb=114.444e-9 spba=115.996e-9 spba1=117.547e-9 dfm_flag=0 spmt=1.11111e15 spomt=0 spomt1=1.11111e60 spmb=1.11111e15 spomb=0 spomb1=1.11111e60
xmm78 qf_x cdn vdd vdd pch_mac l=35e-9 w=340e-9 multi=1 nf=1 sd=100e-9 ad=25.5e-15 as=25.5e-15 pd=830e-9 ps=830e-9 nrd=500.473e-3 nrs=500.473e-3 sa=75e-9 sb=75e-9 sa1=75e-9 sa2=75e-9 sa3=75e-9 sa4=75e-9 sb1=75e-9 sb2=75e-9 sb3=75e-9 spa=100e-9 spa1=100e-9 spa2=100e-9 spa3=100e-9 sap=91.9776e-9 sapb=114.444e-9 spba=115.996e-9 spba1=117.547e-9 dfm_flag=0 spmt=1.11111e15 spomt=0 spomt1=1.11111e60 spmb=1.11111e15 spomb=0 spomb1=1.11111e60
xmm77 qf_x qf vdd vdd pch_mac l=35e-9 w=340e-9 multi=1 nf=1 sd=100e-9 ad=25.5e-15 as=25.5e-15 pd=830e-9 ps=830e-9 nrd=500.473e-3 nrs=500.473e-3 sa=75e-9 sb=75e-9 sa1=75e-9 sa2=75e-9 sa3=75e-9 sa4=75e-9 sb1=75e-9 sb2=75e-9 sb3=75e-9 spa=100e-9 spa1=100e-9 spa2=100e-9 spa3=100e-9 sap=91.9776e-9 sapb=114.444e-9 spba=115.996e-9 spba1=117.547e-9 dfm_flag=0 spmt=1.11111e15 spomt=0 spomt1=1.11111e60 spmb=1.11111e15 spomb=0 spomb1=1.11111e60
xmm44 net103 d vdd vdd pch_mac l=35e-9 w=295e-9 multi=1 nf=1 sd=100e-9 ad=22.125e-15 as=22.125e-15 pd=740e-9 ps=740e-9 nrd=837.099e-3 nrs=837.099e-3 sa=75e-9 sb=75e-9 sa1=75e-9 sa2=75e-9 sa3=75e-9 sa4=75e-9 sb1=75e-9 sb2=75e-9 sb3=75e-9 spa=100e-9 spa1=100e-9 spa2=100e-9 spa3=100e-9 sap=91.9776e-9 sapb=114.444e-9 spba=115.996e-9 spba1=117.547e-9 dfm_flag=0 spmt=1.11111e15 spomt=0 spomt1=1.11111e60 spmb=1.11111e15 spomb=0 spomb1=1.11111e60
xmm68 net172 clkbb qf vdd pch_mac l=35e-9 w=295e-9 multi=1 nf=1 sd=100e-9 ad=22.125e-15 as=22.125e-15 pd=740e-9 ps=740e-9 nrd=837.099e-3 nrs=837.099e-3 sa=75e-9 sb=75e-9 sa1=75e-9 sa2=75e-9 sa3=75e-9 sa4=75e-9 sb1=75e-9 sb2=75e-9 sb3=75e-9 spa=100e-9 spa1=100e-9 spa2=100e-9 spa3=100e-9 sap=91.9776e-9 sapb=114.444e-9 spba=115.996e-9 spba1=117.547e-9 dfm_flag=0 spmt=1.11111e15 spomt=0 spomt1=1.11111e60 spmb=1.11111e15 spomb=0 spomb1=1.11111e60
xmm72 q qf_x vdd vdd pch_mac l=35e-9 w=340e-9 multi=1 nf=1 sd=100e-9 ad=25.5e-15 as=25.5e-15 pd=830e-9 ps=830e-9 nrd=500.473e-3 nrs=500.473e-3 sa=75e-9 sb=75e-9 sa1=75e-9 sa2=75e-9 sa3=75e-9 sa4=75e-9 sb1=75e-9 sb2=75e-9 sb3=75e-9 spa=100e-9 spa1=100e-9 spa2=100e-9 spa3=100e-9 sap=91.9776e-9 sapb=114.444e-9 spba=115.996e-9 spba1=117.547e-9 dfm_flag=0 spmt=1.11111e15 spomt=0 spomt1=1.11111e60 spmb=1.11111e15 spomb=0 spomb1=1.11111e60
xmm79 mq_x clkb net0149 vdd pch_mac l=35e-9 w=120e-9 multi=1 nf=1 sd=100e-9 ad=9e-15 as=9e-15 pd=390e-9 ps=390e-9 nrd=1.511109 nrs=1.511109 sa=75e-9 sb=75e-9 sa1=75e-9 sa2=75e-9 sa3=75e-9 sa4=75e-9 sb1=75e-9 sb2=75e-9 sb3=75e-9 spa=100e-9 spa1=100e-9 spa2=100e-9 spa3=100e-9 sap=91.9776e-9 sapb=114.444e-9 spba=115.996e-9 spba1=117.547e-9 dfm_flag=0 spmt=1.11111e15 spomt=0 spomt1=1.11111e60 spmb=1.11111e15 spomb=0 spomb1=1.11111e60
xmsltp1 qf clkb mq vdd pch_mac l=35e-9 w=295e-9 multi=1 nf=1 sd=100e-9 ad=22.125e-15 as=22.125e-15 pd=740e-9 ps=740e-9 nrd=837.099e-3 nrs=837.099e-3 sa=75e-9 sb=75e-9 sa1=75e-9 sa2=75e-9 sa3=75e-9 sa4=75e-9 sb1=75e-9 sb2=75e-9 sb3=75e-9 spa=100e-9 spa1=100e-9 spa2=100e-9 spa3=100e-9 sap=91.9776e-9 sapb=114.444e-9 spba=115.996e-9 spba1=117.547e-9 dfm_flag=0 spmt=1.11111e15 spomt=0 spomt1=1.11111e60 spmb=1.11111e15 spomb=0 spomb1=1.11111e60
xmm54 clkb cp vdd vdd pch_mac l=35e-9 w=170e-9 multi=1 nf=1 sd=100e-9 ad=12.75e-15 as=12.75e-15 pd=490e-9 ps=490e-9 nrd=1.62222 nrs=1.62222 sa=75e-9 sb=75e-9 sa1=75e-9 sa2=75e-9 sa3=75e-9 sa4=75e-9 sb1=75e-9 sb2=75e-9 sb3=75e-9 spa=100e-9 spa1=100e-9 spa2=100e-9 spa3=100e-9 sap=91.9776e-9 sapb=114.444e-9 spba=115.996e-9 spba1=117.547e-9 dfm_flag=0 spmt=1.11111e15 spomt=0 spomt1=1.11111e60 spmb=1.11111e15 spomb=0 spomb1=1.11111e60
.ends DFCND1BWP35P140
** End of subcircuit definition.

** Library name: OpenRAM_cells
** Cell name: ADO_DFCND1_HK
** View name: schematic
xi0 d cp cdn q qn vdd vss DFCND1BWP35P140
.END
