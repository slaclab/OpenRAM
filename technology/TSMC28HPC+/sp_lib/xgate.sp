** Generated for: hspiceD
** Generated on: Apr 29 13:48:19 2025
** Design library name: OpenRAM_cells
** Design cell name: ADO_XG_16X_HK
** Design view name: schematic

.TEMP 25
.OPTION
+    ARTIST=2
+    INGOLD=2
+    PARHIER=LOCAL
+    PSF=2
+    HIER_DELIM=0
.LIB "/lscratch/TSMC28HPC+/TSMC28nm/models/hspice/toplevel.l" TOP_TT

** Library name: OpenRAM_cells
** Cell name: ADO_XG_16X_HK
** View name: schematic
xm0 vi selb vo vdd pch_mac l=35e-9 w=2.72e-6 multi=1 nf=16 sd=100e-9 ad=136e-15 as=144.5e-15 pd=4.32e-6 ps=4.76e-6 nrd=125.003e-3 nrs=125.003e-3 sa=516.231e-9 sb=516.231e-9 sa1=189.845e-9 sa2=432.406e-9 sa3=736.224e-9 sa4=483.633e-9 sb1=189.845e-9 sb2=432.406e-9 sb3=736.224e-9 spa=100e-9 spa1=100e-9 spa2=100e-9 spa3=100e-9 sap=170.492e-9 sapb=184.833e-9 spba=118.058e-9 spba1=119.583e-9 dfm_flag=0 spmt=1.11111e15 spomt=0 spomt1=1.11111e60 spmb=1.11111e15 spomb=0 spomb1=1.11111e60
xm1 vi sel vo vss nch_mac l=35e-9 w=2.24e-6 multi=1 nf=16 sd=100e-9 ad=112e-15 as=119e-15 pd=3.84e-6 ps=4.22e-6 nrd=286.61e-3 nrs=286.61e-3 sa=516.231e-9 sb=516.231e-9 sa1=189.845e-9 sa2=432.406e-9 sa3=736.224e-9 sa4=483.633e-9 sb1=189.845e-9 sb2=432.406e-9 sb3=736.224e-9 spa=100e-9 spa1=100e-9 spa2=100e-9 spa3=100e-9 sap=170.492e-9 sapb=184.833e-9 spba=118.058e-9 spba1=119.583e-9 dfm_flag=0 spmt=1.11111e15 spomt=0 spomt1=1.11111e60 spmb=1.11111e15 spomb=0 spomb1=1.11111e60
.END
