** Generated for: hspiceD
** Generated on: Apr 23 13:40:01 2025
** Design library name: OpenRAM_cells
** Design cell name: ADO_BLDRV_REG_HK
** Design view name: schematic

.TEMP 25
.OPTION
+    ARTIST=2
+    INGOLD=2
+    PARHIER=LOCAL
+    PSF=2
+    HIER_DELIM=0
.LIB "/lscratch/TSMC28HPC+/TSMC28nm/models/hspice/toplevel.l" TOP_TT

** Library name: tcbn28hpcplusbwp35p140
** Cell name: BUFFD8BWP35P140
** View name: schematic
.subckt BUFFD8BWP35P140 i z vdd vss
xmm0 z net9 vss vss nch_mac l=35e-9 w=280e-9 multi=1 nf=1 sd=100e-9 ad=21e-15 as=21e-15 pd=710e-9 ps=710e-9 nrd=1.382006 nrs=1.382006 sa=75e-9 sb=75e-9 sa1=75e-9 sa2=75e-9 sa3=75e-9 sa4=75e-9 sb1=75e-9 sb2=75e-9 sb3=75e-9 spa=100e-9 spa1=100e-9 spa2=100e-9 spa3=100e-9 sap=91.9776e-9 sapb=114.444e-9 spba=115.996e-9 spba1=117.547e-9 dfm_flag=0 spmt=1.11111e15 spomt=0 spomt1=1.11111e60 spmb=1.11111e15 spomb=0 spomb1=1.11111e60
xmm0_2 z net9 vss vss nch_mac l=35e-9 w=280e-9 multi=1 nf=1 sd=100e-9 ad=21e-15 as=21e-15 pd=710e-9 ps=710e-9 nrd=1.382006 nrs=1.382006 sa=75e-9 sb=75e-9 sa1=75e-9 sa2=75e-9 sa3=75e-9 sa4=75e-9 sb1=75e-9 sb2=75e-9 sb3=75e-9 spa=100e-9 spa1=100e-9 spa2=100e-9 spa3=100e-9 sap=91.9776e-9 sapb=114.444e-9 spba=115.996e-9 spba1=117.547e-9 dfm_flag=0 spmt=1.11111e15 spomt=0 spomt1=1.11111e60 spmb=1.11111e15 spomb=0 spomb1=1.11111e60
xmm0_3 z net9 vss vss nch_mac l=35e-9 w=280e-9 multi=1 nf=1 sd=100e-9 ad=21e-15 as=21e-15 pd=710e-9 ps=710e-9 nrd=1.382006 nrs=1.382006 sa=75e-9 sb=75e-9 sa1=75e-9 sa2=75e-9 sa3=75e-9 sa4=75e-9 sb1=75e-9 sb2=75e-9 sb3=75e-9 spa=100e-9 spa1=100e-9 spa2=100e-9 spa3=100e-9 sap=91.9776e-9 sapb=114.444e-9 spba=115.996e-9 spba1=117.547e-9 dfm_flag=0 spmt=1.11111e15 spomt=0 spomt1=1.11111e60 spmb=1.11111e15 spomb=0 spomb1=1.11111e60
xmm0_4 z net9 vss vss nch_mac l=35e-9 w=280e-9 multi=1 nf=1 sd=100e-9 ad=21e-15 as=21e-15 pd=710e-9 ps=710e-9 nrd=1.382006 nrs=1.382006 sa=75e-9 sb=75e-9 sa1=75e-9 sa2=75e-9 sa3=75e-9 sa4=75e-9 sb1=75e-9 sb2=75e-9 sb3=75e-9 spa=100e-9 spa1=100e-9 spa2=100e-9 spa3=100e-9 sap=91.9776e-9 sapb=114.444e-9 spba=115.996e-9 spba1=117.547e-9 dfm_flag=0 spmt=1.11111e15 spomt=0 spomt1=1.11111e60 spmb=1.11111e15 spomb=0 spomb1=1.11111e60
xmm0_5 z net9 vss vss nch_mac l=35e-9 w=280e-9 multi=1 nf=1 sd=100e-9 ad=21e-15 as=21e-15 pd=710e-9 ps=710e-9 nrd=1.382006 nrs=1.382006 sa=75e-9 sb=75e-9 sa1=75e-9 sa2=75e-9 sa3=75e-9 sa4=75e-9 sb1=75e-9 sb2=75e-9 sb3=75e-9 spa=100e-9 spa1=100e-9 spa2=100e-9 spa3=100e-9 sap=91.9776e-9 sapb=114.444e-9 spba=115.996e-9 spba1=117.547e-9 dfm_flag=0 spmt=1.11111e15 spomt=0 spomt1=1.11111e60 spmb=1.11111e15 spomb=0 spomb1=1.11111e60
xmm0_6 z net9 vss vss nch_mac l=35e-9 w=280e-9 multi=1 nf=1 sd=100e-9 ad=21e-15 as=21e-15 pd=710e-9 ps=710e-9 nrd=1.382006 nrs=1.382006 sa=75e-9 sb=75e-9 sa1=75e-9 sa2=75e-9 sa3=75e-9 sa4=75e-9 sb1=75e-9 sb2=75e-9 sb3=75e-9 spa=100e-9 spa1=100e-9 spa2=100e-9 spa3=100e-9 sap=91.9776e-9 sapb=114.444e-9 spba=115.996e-9 spba1=117.547e-9 dfm_flag=0 spmt=1.11111e15 spomt=0 spomt1=1.11111e60 spmb=1.11111e15 spomb=0 spomb1=1.11111e60
xmm0_7 z net9 vss vss nch_mac l=35e-9 w=280e-9 multi=1 nf=1 sd=100e-9 ad=21e-15 as=21e-15 pd=710e-9 ps=710e-9 nrd=1.382006 nrs=1.382006 sa=75e-9 sb=75e-9 sa1=75e-9 sa2=75e-9 sa3=75e-9 sa4=75e-9 sb1=75e-9 sb2=75e-9 sb3=75e-9 spa=100e-9 spa1=100e-9 spa2=100e-9 spa3=100e-9 sap=91.9776e-9 sapb=114.444e-9 spba=115.996e-9 spba1=117.547e-9 dfm_flag=0 spmt=1.11111e15 spomt=0 spomt1=1.11111e60 spmb=1.11111e15 spomb=0 spomb1=1.11111e60
xmm0_8 z net9 vss vss nch_mac l=35e-9 w=280e-9 multi=1 nf=1 sd=100e-9 ad=21e-15 as=21e-15 pd=710e-9 ps=710e-9 nrd=1.382006 nrs=1.382006 sa=75e-9 sb=75e-9 sa1=75e-9 sa2=75e-9 sa3=75e-9 sa4=75e-9 sb1=75e-9 sb2=75e-9 sb3=75e-9 spa=100e-9 spa1=100e-9 spa2=100e-9 spa3=100e-9 sap=91.9776e-9 sapb=114.444e-9 spba=115.996e-9 spba1=117.547e-9 dfm_flag=0 spmt=1.11111e15 spomt=0 spomt1=1.11111e60 spmb=1.11111e15 spomb=0 spomb1=1.11111e60
xmm5 net9 i vss vss nch_mac l=35e-9 w=280e-9 multi=1 nf=1 sd=100e-9 ad=21e-15 as=21e-15 pd=710e-9 ps=710e-9 nrd=1.382006 nrs=1.382006 sa=75e-9 sb=75e-9 sa1=75e-9 sa2=75e-9 sa3=75e-9 sa4=75e-9 sb1=75e-9 sb2=75e-9 sb3=75e-9 spa=100e-9 spa1=100e-9 spa2=100e-9 spa3=100e-9 sap=91.9776e-9 sapb=114.444e-9 spba=115.996e-9 spba1=117.547e-9 dfm_flag=0 spmt=1.11111e15 spomt=0 spomt1=1.11111e60 spmb=1.11111e15 spomb=0 spomb1=1.11111e60
xmm5_2 net9 i vss vss nch_mac l=35e-9 w=280e-9 multi=1 nf=1 sd=100e-9 ad=21e-15 as=21e-15 pd=710e-9 ps=710e-9 nrd=1.382006 nrs=1.382006 sa=75e-9 sb=75e-9 sa1=75e-9 sa2=75e-9 sa3=75e-9 sa4=75e-9 sb1=75e-9 sb2=75e-9 sb3=75e-9 spa=100e-9 spa1=100e-9 spa2=100e-9 spa3=100e-9 sap=91.9776e-9 sapb=114.444e-9 spba=115.996e-9 spba1=117.547e-9 dfm_flag=0 spmt=1.11111e15 spomt=0 spomt1=1.11111e60 spmb=1.11111e15 spomb=0 spomb1=1.11111e60
xmm5_3 net9 i vss vss nch_mac l=35e-9 w=280e-9 multi=1 nf=1 sd=100e-9 ad=21e-15 as=21e-15 pd=710e-9 ps=710e-9 nrd=1.382006 nrs=1.382006 sa=75e-9 sb=75e-9 sa1=75e-9 sa2=75e-9 sa3=75e-9 sa4=75e-9 sb1=75e-9 sb2=75e-9 sb3=75e-9 spa=100e-9 spa1=100e-9 spa2=100e-9 spa3=100e-9 sap=91.9776e-9 sapb=114.444e-9 spba=115.996e-9 spba1=117.547e-9 dfm_flag=0 spmt=1.11111e15 spomt=0 spomt1=1.11111e60 spmb=1.11111e15 spomb=0 spomb1=1.11111e60
xmm1 z net9 vdd vdd pch_mac l=35e-9 w=340e-9 multi=1 nf=1 sd=100e-9 ad=25.5e-15 as=25.5e-15 pd=830e-9 ps=830e-9 nrd=500.473e-3 nrs=500.473e-3 sa=75e-9 sb=75e-9 sa1=75e-9 sa2=75e-9 sa3=75e-9 sa4=75e-9 sb1=75e-9 sb2=75e-9 sb3=75e-9 spa=100e-9 spa1=100e-9 spa2=100e-9 spa3=100e-9 sap=91.9776e-9 sapb=114.444e-9 spba=115.996e-9 spba1=117.547e-9 dfm_flag=0 spmt=1.11111e15 spomt=0 spomt1=1.11111e60 spmb=1.11111e15 spomb=0 spomb1=1.11111e60
xmm1_2 z net9 vdd vdd pch_mac l=35e-9 w=340e-9 multi=1 nf=1 sd=100e-9 ad=25.5e-15 as=25.5e-15 pd=830e-9 ps=830e-9 nrd=500.473e-3 nrs=500.473e-3 sa=75e-9 sb=75e-9 sa1=75e-9 sa2=75e-9 sa3=75e-9 sa4=75e-9 sb1=75e-9 sb2=75e-9 sb3=75e-9 spa=100e-9 spa1=100e-9 spa2=100e-9 spa3=100e-9 sap=91.9776e-9 sapb=114.444e-9 spba=115.996e-9 spba1=117.547e-9 dfm_flag=0 spmt=1.11111e15 spomt=0 spomt1=1.11111e60 spmb=1.11111e15 spomb=0 spomb1=1.11111e60
xmm1_3 z net9 vdd vdd pch_mac l=35e-9 w=340e-9 multi=1 nf=1 sd=100e-9 ad=25.5e-15 as=25.5e-15 pd=830e-9 ps=830e-9 nrd=500.473e-3 nrs=500.473e-3 sa=75e-9 sb=75e-9 sa1=75e-9 sa2=75e-9 sa3=75e-9 sa4=75e-9 sb1=75e-9 sb2=75e-9 sb3=75e-9 spa=100e-9 spa1=100e-9 spa2=100e-9 spa3=100e-9 sap=91.9776e-9 sapb=114.444e-9 spba=115.996e-9 spba1=117.547e-9 dfm_flag=0 spmt=1.11111e15 spomt=0 spomt1=1.11111e60 spmb=1.11111e15 spomb=0 spomb1=1.11111e60
xmm1_4 z net9 vdd vdd pch_mac l=35e-9 w=340e-9 multi=1 nf=1 sd=100e-9 ad=25.5e-15 as=25.5e-15 pd=830e-9 ps=830e-9 nrd=500.473e-3 nrs=500.473e-3 sa=75e-9 sb=75e-9 sa1=75e-9 sa2=75e-9 sa3=75e-9 sa4=75e-9 sb1=75e-9 sb2=75e-9 sb3=75e-9 spa=100e-9 spa1=100e-9 spa2=100e-9 spa3=100e-9 sap=91.9776e-9 sapb=114.444e-9 spba=115.996e-9 spba1=117.547e-9 dfm_flag=0 spmt=1.11111e15 spomt=0 spomt1=1.11111e60 spmb=1.11111e15 spomb=0 spomb1=1.11111e60
xmm1_5 z net9 vdd vdd pch_mac l=35e-9 w=340e-9 multi=1 nf=1 sd=100e-9 ad=25.5e-15 as=25.5e-15 pd=830e-9 ps=830e-9 nrd=500.473e-3 nrs=500.473e-3 sa=75e-9 sb=75e-9 sa1=75e-9 sa2=75e-9 sa3=75e-9 sa4=75e-9 sb1=75e-9 sb2=75e-9 sb3=75e-9 spa=100e-9 spa1=100e-9 spa2=100e-9 spa3=100e-9 sap=91.9776e-9 sapb=114.444e-9 spba=115.996e-9 spba1=117.547e-9 dfm_flag=0 spmt=1.11111e15 spomt=0 spomt1=1.11111e60 spmb=1.11111e15 spomb=0 spomb1=1.11111e60
xmm1_6 z net9 vdd vdd pch_mac l=35e-9 w=340e-9 multi=1 nf=1 sd=100e-9 ad=25.5e-15 as=25.5e-15 pd=830e-9 ps=830e-9 nrd=500.473e-3 nrs=500.473e-3 sa=75e-9 sb=75e-9 sa1=75e-9 sa2=75e-9 sa3=75e-9 sa4=75e-9 sb1=75e-9 sb2=75e-9 sb3=75e-9 spa=100e-9 spa1=100e-9 spa2=100e-9 spa3=100e-9 sap=91.9776e-9 sapb=114.444e-9 spba=115.996e-9 spba1=117.547e-9 dfm_flag=0 spmt=1.11111e15 spomt=0 spomt1=1.11111e60 spmb=1.11111e15 spomb=0 spomb1=1.11111e60
xmm1_7 z net9 vdd vdd pch_mac l=35e-9 w=340e-9 multi=1 nf=1 sd=100e-9 ad=25.5e-15 as=25.5e-15 pd=830e-9 ps=830e-9 nrd=500.473e-3 nrs=500.473e-3 sa=75e-9 sb=75e-9 sa1=75e-9 sa2=75e-9 sa3=75e-9 sa4=75e-9 sb1=75e-9 sb2=75e-9 sb3=75e-9 spa=100e-9 spa1=100e-9 spa2=100e-9 spa3=100e-9 sap=91.9776e-9 sapb=114.444e-9 spba=115.996e-9 spba1=117.547e-9 dfm_flag=0 spmt=1.11111e15 spomt=0 spomt1=1.11111e60 spmb=1.11111e15 spomb=0 spomb1=1.11111e60
xmm1_8 z net9 vdd vdd pch_mac l=35e-9 w=340e-9 multi=1 nf=1 sd=100e-9 ad=25.5e-15 as=25.5e-15 pd=830e-9 ps=830e-9 nrd=500.473e-3 nrs=500.473e-3 sa=75e-9 sb=75e-9 sa1=75e-9 sa2=75e-9 sa3=75e-9 sa4=75e-9 sb1=75e-9 sb2=75e-9 sb3=75e-9 spa=100e-9 spa1=100e-9 spa2=100e-9 spa3=100e-9 sap=91.9776e-9 sapb=114.444e-9 spba=115.996e-9 spba1=117.547e-9 dfm_flag=0 spmt=1.11111e15 spomt=0 spomt1=1.11111e60 spmb=1.11111e15 spomb=0 spomb1=1.11111e60
xmm4 net9 i vdd vdd pch_mac l=35e-9 w=340e-9 multi=1 nf=1 sd=100e-9 ad=25.5e-15 as=25.5e-15 pd=830e-9 ps=830e-9 nrd=500.473e-3 nrs=500.473e-3 sa=75e-9 sb=75e-9 sa1=75e-9 sa2=75e-9 sa3=75e-9 sa4=75e-9 sb1=75e-9 sb2=75e-9 sb3=75e-9 spa=100e-9 spa1=100e-9 spa2=100e-9 spa3=100e-9 sap=91.9776e-9 sapb=114.444e-9 spba=115.996e-9 spba1=117.547e-9 dfm_flag=0 spmt=1.11111e15 spomt=0 spomt1=1.11111e60 spmb=1.11111e15 spomb=0 spomb1=1.11111e60
xmm4_2 net9 i vdd vdd pch_mac l=35e-9 w=340e-9 multi=1 nf=1 sd=100e-9 ad=25.5e-15 as=25.5e-15 pd=830e-9 ps=830e-9 nrd=500.473e-3 nrs=500.473e-3 sa=75e-9 sb=75e-9 sa1=75e-9 sa2=75e-9 sa3=75e-9 sa4=75e-9 sb1=75e-9 sb2=75e-9 sb3=75e-9 spa=100e-9 spa1=100e-9 spa2=100e-9 spa3=100e-9 sap=91.9776e-9 sapb=114.444e-9 spba=115.996e-9 spba1=117.547e-9 dfm_flag=0 spmt=1.11111e15 spomt=0 spomt1=1.11111e60 spmb=1.11111e15 spomb=0 spomb1=1.11111e60
xmm4_3 net9 i vdd vdd pch_mac l=35e-9 w=340e-9 multi=1 nf=1 sd=100e-9 ad=25.5e-15 as=25.5e-15 pd=830e-9 ps=830e-9 nrd=500.473e-3 nrs=500.473e-3 sa=75e-9 sb=75e-9 sa1=75e-9 sa2=75e-9 sa3=75e-9 sa4=75e-9 sb1=75e-9 sb2=75e-9 sb3=75e-9 spa=100e-9 spa1=100e-9 spa2=100e-9 spa3=100e-9 sap=91.9776e-9 sapb=114.444e-9 spba=115.996e-9 spba1=117.547e-9 dfm_flag=0 spmt=1.11111e15 spomt=0 spomt1=1.11111e60 spmb=1.11111e15 spomb=0 spomb1=1.11111e60
.ends BUFFD8BWP35P140
** End of subcircuit definition.

** Library name: OpenRAM_cells
** Cell name: ADO_XG_16X_HK
** View name: schematic
.subckt ADO_XG_16X_HK sel selb vdd vi vo vss
xm0 vi selb vo vdd pch_mac l=35e-9 w=2.72e-6 multi=1 nf=16 sd=100e-9 ad=136e-15 as=144.5e-15 pd=4.32e-6 ps=4.76e-6 nrd=125.003e-3 nrs=125.003e-3 sa=516.231e-9 sb=516.231e-9 sa1=189.845e-9 sa2=432.406e-9 sa3=736.224e-9 sa4=483.633e-9 sb1=189.845e-9 sb2=432.406e-9 sb3=736.224e-9 spa=100e-9 spa1=100e-9 spa2=100e-9 spa3=100e-9 sap=170.492e-9 sapb=184.833e-9 spba=118.058e-9 spba1=119.583e-9 dfm_flag=0 spmt=1.11111e15 spomt=0 spomt1=1.11111e60 spmb=1.11111e15 spomb=0 spomb1=1.11111e60
xm1 vi sel vo vss nch_mac l=35e-9 w=2.24e-6 multi=1 nf=16 sd=100e-9 ad=112e-15 as=119e-15 pd=3.84e-6 ps=4.22e-6 nrd=286.61e-3 nrs=286.61e-3 sa=516.231e-9 sb=516.231e-9 sa1=189.845e-9 sa2=432.406e-9 sa3=736.224e-9 sa4=483.633e-9 sb1=189.845e-9 sb2=432.406e-9 sb3=736.224e-9 spa=100e-9 spa1=100e-9 spa2=100e-9 spa3=100e-9 sap=170.492e-9 sapb=184.833e-9 spba=118.058e-9 spba1=119.583e-9 dfm_flag=0 spmt=1.11111e15 spomt=0 spomt1=1.11111e60 spmb=1.11111e15 spomb=0 spomb1=1.11111e60
.ends ADO_XG_16X_HK
** End of subcircuit definition.

** Library name: tcbn28hpcplusbwp35p140
** Cell name: INVD8BWP35P140
** View name: schematic
.subckt INVD8BWP35P140 i zn vdd vss
xmm1 zn i vss vss nch_mac l=35e-9 w=280e-9 multi=1 nf=1 sd=100e-9 ad=21e-15 as=21e-15 pd=710e-9 ps=710e-9 nrd=1.382006 nrs=1.382006 sa=75e-9 sb=75e-9 sa1=75e-9 sa2=75e-9 sa3=75e-9 sa4=75e-9 sb1=75e-9 sb2=75e-9 sb3=75e-9 spa=100e-9 spa1=100e-9 spa2=100e-9 spa3=100e-9 sap=91.9776e-9 sapb=114.444e-9 spba=115.996e-9 spba1=117.547e-9 dfm_flag=0 spmt=1.11111e15 spomt=0 spomt1=1.11111e60 spmb=1.11111e15 spomb=0 spomb1=1.11111e60
xmm1_2 zn i vss vss nch_mac l=35e-9 w=280e-9 multi=1 nf=1 sd=100e-9 ad=21e-15 as=21e-15 pd=710e-9 ps=710e-9 nrd=1.382006 nrs=1.382006 sa=75e-9 sb=75e-9 sa1=75e-9 sa2=75e-9 sa3=75e-9 sa4=75e-9 sb1=75e-9 sb2=75e-9 sb3=75e-9 spa=100e-9 spa1=100e-9 spa2=100e-9 spa3=100e-9 sap=91.9776e-9 sapb=114.444e-9 spba=115.996e-9 spba1=117.547e-9 dfm_flag=0 spmt=1.11111e15 spomt=0 spomt1=1.11111e60 spmb=1.11111e15 spomb=0 spomb1=1.11111e60
xmm1_3 zn i vss vss nch_mac l=35e-9 w=280e-9 multi=1 nf=1 sd=100e-9 ad=21e-15 as=21e-15 pd=710e-9 ps=710e-9 nrd=1.382006 nrs=1.382006 sa=75e-9 sb=75e-9 sa1=75e-9 sa2=75e-9 sa3=75e-9 sa4=75e-9 sb1=75e-9 sb2=75e-9 sb3=75e-9 spa=100e-9 spa1=100e-9 spa2=100e-9 spa3=100e-9 sap=91.9776e-9 sapb=114.444e-9 spba=115.996e-9 spba1=117.547e-9 dfm_flag=0 spmt=1.11111e15 spomt=0 spomt1=1.11111e60 spmb=1.11111e15 spomb=0 spomb1=1.11111e60
xmm1_4 zn i vss vss nch_mac l=35e-9 w=280e-9 multi=1 nf=1 sd=100e-9 ad=21e-15 as=21e-15 pd=710e-9 ps=710e-9 nrd=1.382006 nrs=1.382006 sa=75e-9 sb=75e-9 sa1=75e-9 sa2=75e-9 sa3=75e-9 sa4=75e-9 sb1=75e-9 sb2=75e-9 sb3=75e-9 spa=100e-9 spa1=100e-9 spa2=100e-9 spa3=100e-9 sap=91.9776e-9 sapb=114.444e-9 spba=115.996e-9 spba1=117.547e-9 dfm_flag=0 spmt=1.11111e15 spomt=0 spomt1=1.11111e60 spmb=1.11111e15 spomb=0 spomb1=1.11111e60
xmm1_5 zn i vss vss nch_mac l=35e-9 w=280e-9 multi=1 nf=1 sd=100e-9 ad=21e-15 as=21e-15 pd=710e-9 ps=710e-9 nrd=1.382006 nrs=1.382006 sa=75e-9 sb=75e-9 sa1=75e-9 sa2=75e-9 sa3=75e-9 sa4=75e-9 sb1=75e-9 sb2=75e-9 sb3=75e-9 spa=100e-9 spa1=100e-9 spa2=100e-9 spa3=100e-9 sap=91.9776e-9 sapb=114.444e-9 spba=115.996e-9 spba1=117.547e-9 dfm_flag=0 spmt=1.11111e15 spomt=0 spomt1=1.11111e60 spmb=1.11111e15 spomb=0 spomb1=1.11111e60
xmm1_6 zn i vss vss nch_mac l=35e-9 w=280e-9 multi=1 nf=1 sd=100e-9 ad=21e-15 as=21e-15 pd=710e-9 ps=710e-9 nrd=1.382006 nrs=1.382006 sa=75e-9 sb=75e-9 sa1=75e-9 sa2=75e-9 sa3=75e-9 sa4=75e-9 sb1=75e-9 sb2=75e-9 sb3=75e-9 spa=100e-9 spa1=100e-9 spa2=100e-9 spa3=100e-9 sap=91.9776e-9 sapb=114.444e-9 spba=115.996e-9 spba1=117.547e-9 dfm_flag=0 spmt=1.11111e15 spomt=0 spomt1=1.11111e60 spmb=1.11111e15 spomb=0 spomb1=1.11111e60
xmm1_7 zn i vss vss nch_mac l=35e-9 w=280e-9 multi=1 nf=1 sd=100e-9 ad=21e-15 as=21e-15 pd=710e-9 ps=710e-9 nrd=1.382006 nrs=1.382006 sa=75e-9 sb=75e-9 sa1=75e-9 sa2=75e-9 sa3=75e-9 sa4=75e-9 sb1=75e-9 sb2=75e-9 sb3=75e-9 spa=100e-9 spa1=100e-9 spa2=100e-9 spa3=100e-9 sap=91.9776e-9 sapb=114.444e-9 spba=115.996e-9 spba1=117.547e-9 dfm_flag=0 spmt=1.11111e15 spomt=0 spomt1=1.11111e60 spmb=1.11111e15 spomb=0 spomb1=1.11111e60
xmm1_8 zn i vss vss nch_mac l=35e-9 w=280e-9 multi=1 nf=1 sd=100e-9 ad=21e-15 as=21e-15 pd=710e-9 ps=710e-9 nrd=1.382006 nrs=1.382006 sa=75e-9 sb=75e-9 sa1=75e-9 sa2=75e-9 sa3=75e-9 sa4=75e-9 sb1=75e-9 sb2=75e-9 sb3=75e-9 spa=100e-9 spa1=100e-9 spa2=100e-9 spa3=100e-9 sap=91.9776e-9 sapb=114.444e-9 spba=115.996e-9 spba1=117.547e-9 dfm_flag=0 spmt=1.11111e15 spomt=0 spomt1=1.11111e60 spmb=1.11111e15 spomb=0 spomb1=1.11111e60
xmm0 zn i vdd vdd pch_mac l=35e-9 w=340e-9 multi=1 nf=1 sd=100e-9 ad=25.5e-15 as=25.5e-15 pd=830e-9 ps=830e-9 nrd=500.473e-3 nrs=500.473e-3 sa=75e-9 sb=75e-9 sa1=75e-9 sa2=75e-9 sa3=75e-9 sa4=75e-9 sb1=75e-9 sb2=75e-9 sb3=75e-9 spa=100e-9 spa1=100e-9 spa2=100e-9 spa3=100e-9 sap=91.9776e-9 sapb=114.444e-9 spba=115.996e-9 spba1=117.547e-9 dfm_flag=0 spmt=1.11111e15 spomt=0 spomt1=1.11111e60 spmb=1.11111e15 spomb=0 spomb1=1.11111e60
xmm0_2 zn i vdd vdd pch_mac l=35e-9 w=340e-9 multi=1 nf=1 sd=100e-9 ad=25.5e-15 as=25.5e-15 pd=830e-9 ps=830e-9 nrd=500.473e-3 nrs=500.473e-3 sa=75e-9 sb=75e-9 sa1=75e-9 sa2=75e-9 sa3=75e-9 sa4=75e-9 sb1=75e-9 sb2=75e-9 sb3=75e-9 spa=100e-9 spa1=100e-9 spa2=100e-9 spa3=100e-9 sap=91.9776e-9 sapb=114.444e-9 spba=115.996e-9 spba1=117.547e-9 dfm_flag=0 spmt=1.11111e15 spomt=0 spomt1=1.11111e60 spmb=1.11111e15 spomb=0 spomb1=1.11111e60
xmm0_3 zn i vdd vdd pch_mac l=35e-9 w=340e-9 multi=1 nf=1 sd=100e-9 ad=25.5e-15 as=25.5e-15 pd=830e-9 ps=830e-9 nrd=500.473e-3 nrs=500.473e-3 sa=75e-9 sb=75e-9 sa1=75e-9 sa2=75e-9 sa3=75e-9 sa4=75e-9 sb1=75e-9 sb2=75e-9 sb3=75e-9 spa=100e-9 spa1=100e-9 spa2=100e-9 spa3=100e-9 sap=91.9776e-9 sapb=114.444e-9 spba=115.996e-9 spba1=117.547e-9 dfm_flag=0 spmt=1.11111e15 spomt=0 spomt1=1.11111e60 spmb=1.11111e15 spomb=0 spomb1=1.11111e60
xmm0_4 zn i vdd vdd pch_mac l=35e-9 w=340e-9 multi=1 nf=1 sd=100e-9 ad=25.5e-15 as=25.5e-15 pd=830e-9 ps=830e-9 nrd=500.473e-3 nrs=500.473e-3 sa=75e-9 sb=75e-9 sa1=75e-9 sa2=75e-9 sa3=75e-9 sa4=75e-9 sb1=75e-9 sb2=75e-9 sb3=75e-9 spa=100e-9 spa1=100e-9 spa2=100e-9 spa3=100e-9 sap=91.9776e-9 sapb=114.444e-9 spba=115.996e-9 spba1=117.547e-9 dfm_flag=0 spmt=1.11111e15 spomt=0 spomt1=1.11111e60 spmb=1.11111e15 spomb=0 spomb1=1.11111e60
xmm0_5 zn i vdd vdd pch_mac l=35e-9 w=340e-9 multi=1 nf=1 sd=100e-9 ad=25.5e-15 as=25.5e-15 pd=830e-9 ps=830e-9 nrd=500.473e-3 nrs=500.473e-3 sa=75e-9 sb=75e-9 sa1=75e-9 sa2=75e-9 sa3=75e-9 sa4=75e-9 sb1=75e-9 sb2=75e-9 sb3=75e-9 spa=100e-9 spa1=100e-9 spa2=100e-9 spa3=100e-9 sap=91.9776e-9 sapb=114.444e-9 spba=115.996e-9 spba1=117.547e-9 dfm_flag=0 spmt=1.11111e15 spomt=0 spomt1=1.11111e60 spmb=1.11111e15 spomb=0 spomb1=1.11111e60
xmm0_6 zn i vdd vdd pch_mac l=35e-9 w=340e-9 multi=1 nf=1 sd=100e-9 ad=25.5e-15 as=25.5e-15 pd=830e-9 ps=830e-9 nrd=500.473e-3 nrs=500.473e-3 sa=75e-9 sb=75e-9 sa1=75e-9 sa2=75e-9 sa3=75e-9 sa4=75e-9 sb1=75e-9 sb2=75e-9 sb3=75e-9 spa=100e-9 spa1=100e-9 spa2=100e-9 spa3=100e-9 sap=91.9776e-9 sapb=114.444e-9 spba=115.996e-9 spba1=117.547e-9 dfm_flag=0 spmt=1.11111e15 spomt=0 spomt1=1.11111e60 spmb=1.11111e15 spomb=0 spomb1=1.11111e60
xmm0_7 zn i vdd vdd pch_mac l=35e-9 w=340e-9 multi=1 nf=1 sd=100e-9 ad=25.5e-15 as=25.5e-15 pd=830e-9 ps=830e-9 nrd=500.473e-3 nrs=500.473e-3 sa=75e-9 sb=75e-9 sa1=75e-9 sa2=75e-9 sa3=75e-9 sa4=75e-9 sb1=75e-9 sb2=75e-9 sb3=75e-9 spa=100e-9 spa1=100e-9 spa2=100e-9 spa3=100e-9 sap=91.9776e-9 sapb=114.444e-9 spba=115.996e-9 spba1=117.547e-9 dfm_flag=0 spmt=1.11111e15 spomt=0 spomt1=1.11111e60 spmb=1.11111e15 spomb=0 spomb1=1.11111e60
xmm0_8 zn i vdd vdd pch_mac l=35e-9 w=340e-9 multi=1 nf=1 sd=100e-9 ad=25.5e-15 as=25.5e-15 pd=830e-9 ps=830e-9 nrd=500.473e-3 nrs=500.473e-3 sa=75e-9 sb=75e-9 sa1=75e-9 sa2=75e-9 sa3=75e-9 sa4=75e-9 sb1=75e-9 sb2=75e-9 sb3=75e-9 spa=100e-9 spa1=100e-9 spa2=100e-9 spa3=100e-9 sap=91.9776e-9 sapb=114.444e-9 spba=115.996e-9 spba1=117.547e-9 dfm_flag=0 spmt=1.11111e15 spomt=0 spomt1=1.11111e60 spmb=1.11111e15 spomb=0 spomb1=1.11111e60
.ends INVD8BWP35P140
** End of subcircuit definition.

** Library name: tcbn28hpcplusbwp35p140
** Cell name: INVD4BWP35P140
** View name: schematic
.subckt INVD4BWP35P140 i zn vdd vss
xmm1 zn i vss vss nch_mac l=35e-9 w=280e-9 multi=1 nf=1 sd=100e-9 ad=21e-15 as=21e-15 pd=710e-9 ps=710e-9 nrd=1.382006 nrs=1.382006 sa=75e-9 sb=75e-9 sa1=75e-9 sa2=75e-9 sa3=75e-9 sa4=75e-9 sb1=75e-9 sb2=75e-9 sb3=75e-9 spa=100e-9 spa1=100e-9 spa2=100e-9 spa3=100e-9 sap=91.9776e-9 sapb=114.444e-9 spba=115.996e-9 spba1=117.547e-9 dfm_flag=0 spmt=1.11111e15 spomt=0 spomt1=1.11111e60 spmb=1.11111e15 spomb=0 spomb1=1.11111e60
xmm1_2 zn i vss vss nch_mac l=35e-9 w=280e-9 multi=1 nf=1 sd=100e-9 ad=21e-15 as=21e-15 pd=710e-9 ps=710e-9 nrd=1.382006 nrs=1.382006 sa=75e-9 sb=75e-9 sa1=75e-9 sa2=75e-9 sa3=75e-9 sa4=75e-9 sb1=75e-9 sb2=75e-9 sb3=75e-9 spa=100e-9 spa1=100e-9 spa2=100e-9 spa3=100e-9 sap=91.9776e-9 sapb=114.444e-9 spba=115.996e-9 spba1=117.547e-9 dfm_flag=0 spmt=1.11111e15 spomt=0 spomt1=1.11111e60 spmb=1.11111e15 spomb=0 spomb1=1.11111e60
xmm1_3 zn i vss vss nch_mac l=35e-9 w=280e-9 multi=1 nf=1 sd=100e-9 ad=21e-15 as=21e-15 pd=710e-9 ps=710e-9 nrd=1.382006 nrs=1.382006 sa=75e-9 sb=75e-9 sa1=75e-9 sa2=75e-9 sa3=75e-9 sa4=75e-9 sb1=75e-9 sb2=75e-9 sb3=75e-9 spa=100e-9 spa1=100e-9 spa2=100e-9 spa3=100e-9 sap=91.9776e-9 sapb=114.444e-9 spba=115.996e-9 spba1=117.547e-9 dfm_flag=0 spmt=1.11111e15 spomt=0 spomt1=1.11111e60 spmb=1.11111e15 spomb=0 spomb1=1.11111e60
xmm1_4 zn i vss vss nch_mac l=35e-9 w=280e-9 multi=1 nf=1 sd=100e-9 ad=21e-15 as=21e-15 pd=710e-9 ps=710e-9 nrd=1.382006 nrs=1.382006 sa=75e-9 sb=75e-9 sa1=75e-9 sa2=75e-9 sa3=75e-9 sa4=75e-9 sb1=75e-9 sb2=75e-9 sb3=75e-9 spa=100e-9 spa1=100e-9 spa2=100e-9 spa3=100e-9 sap=91.9776e-9 sapb=114.444e-9 spba=115.996e-9 spba1=117.547e-9 dfm_flag=0 spmt=1.11111e15 spomt=0 spomt1=1.11111e60 spmb=1.11111e15 spomb=0 spomb1=1.11111e60
xmm0 zn i vdd vdd pch_mac l=35e-9 w=340e-9 multi=1 nf=1 sd=100e-9 ad=25.5e-15 as=25.5e-15 pd=830e-9 ps=830e-9 nrd=500.473e-3 nrs=500.473e-3 sa=75e-9 sb=75e-9 sa1=75e-9 sa2=75e-9 sa3=75e-9 sa4=75e-9 sb1=75e-9 sb2=75e-9 sb3=75e-9 spa=100e-9 spa1=100e-9 spa2=100e-9 spa3=100e-9 sap=91.9776e-9 sapb=114.444e-9 spba=115.996e-9 spba1=117.547e-9 dfm_flag=0 spmt=1.11111e15 spomt=0 spomt1=1.11111e60 spmb=1.11111e15 spomb=0 spomb1=1.11111e60
xmm0_2 zn i vdd vdd pch_mac l=35e-9 w=340e-9 multi=1 nf=1 sd=100e-9 ad=25.5e-15 as=25.5e-15 pd=830e-9 ps=830e-9 nrd=500.473e-3 nrs=500.473e-3 sa=75e-9 sb=75e-9 sa1=75e-9 sa2=75e-9 sa3=75e-9 sa4=75e-9 sb1=75e-9 sb2=75e-9 sb3=75e-9 spa=100e-9 spa1=100e-9 spa2=100e-9 spa3=100e-9 sap=91.9776e-9 sapb=114.444e-9 spba=115.996e-9 spba1=117.547e-9 dfm_flag=0 spmt=1.11111e15 spomt=0 spomt1=1.11111e60 spmb=1.11111e15 spomb=0 spomb1=1.11111e60
xmm0_3 zn i vdd vdd pch_mac l=35e-9 w=340e-9 multi=1 nf=1 sd=100e-9 ad=25.5e-15 as=25.5e-15 pd=830e-9 ps=830e-9 nrd=500.473e-3 nrs=500.473e-3 sa=75e-9 sb=75e-9 sa1=75e-9 sa2=75e-9 sa3=75e-9 sa4=75e-9 sb1=75e-9 sb2=75e-9 sb3=75e-9 spa=100e-9 spa1=100e-9 spa2=100e-9 spa3=100e-9 sap=91.9776e-9 sapb=114.444e-9 spba=115.996e-9 spba1=117.547e-9 dfm_flag=0 spmt=1.11111e15 spomt=0 spomt1=1.11111e60 spmb=1.11111e15 spomb=0 spomb1=1.11111e60
xmm0_4 zn i vdd vdd pch_mac l=35e-9 w=340e-9 multi=1 nf=1 sd=100e-9 ad=25.5e-15 as=25.5e-15 pd=830e-9 ps=830e-9 nrd=500.473e-3 nrs=500.473e-3 sa=75e-9 sb=75e-9 sa1=75e-9 sa2=75e-9 sa3=75e-9 sa4=75e-9 sb1=75e-9 sb2=75e-9 sb3=75e-9 spa=100e-9 spa1=100e-9 spa2=100e-9 spa3=100e-9 sap=91.9776e-9 sapb=114.444e-9 spba=115.996e-9 spba1=117.547e-9 dfm_flag=0 spmt=1.11111e15 spomt=0 spomt1=1.11111e60 spmb=1.11111e15 spomb=0 spomb1=1.11111e60
.ends INVD4BWP35P140
** End of subcircuit definition.

** Library name: tcbn28hpcplusbwp35p140
** Cell name: LHQD1BWP35P140
** View name: schematic
.subckt LHQD1BWP35P140 d e q vdd vss
xmm9 clkbb clkb vss vss nch_mac l=35e-9 w=140e-9 multi=1 nf=1 sd=100e-9 ad=10.5e-15 as=10.5e-15 pd=430e-9 ps=430e-9 nrd=2.677526 nrs=2.677526 sa=75e-9 sb=75e-9 sa1=75e-9 sa2=75e-9 sa3=75e-9 sa4=75e-9 sb1=75e-9 sb2=75e-9 sb3=75e-9 spa=100e-9 spa1=100e-9 spa2=100e-9 spa3=100e-9 sap=91.9776e-9 sapb=114.444e-9 spba=115.996e-9 spba1=117.547e-9 dfm_flag=0 spmt=1.11111e15 spomt=0 spomt1=1.11111e60 spmb=1.11111e15 spomb=0 spomb1=1.11111e60
xmm8 net076 clkb qf_x vss nch_mac l=35e-9 w=155e-9 multi=1 nf=1 sd=100e-9 ad=11.625e-15 as=11.625e-15 pd=460e-9 ps=460e-9 nrd=2.715364 nrs=2.715364 sa=75e-9 sb=75e-9 sa1=75e-9 sa2=75e-9 sa3=75e-9 sa4=75e-9 sb1=75e-9 sb2=75e-9 sb3=75e-9 spa=100e-9 spa1=100e-9 spa2=100e-9 spa3=100e-9 sap=91.9776e-9 sapb=114.444e-9 spba=115.996e-9 spba1=117.547e-9 dfm_flag=0 spmt=1.11111e15 spomt=0 spomt1=1.11111e60 spmb=1.11111e15 spomb=0 spomb1=1.11111e60
xmm0 clkb e vss vss nch_mac l=35e-9 w=140e-9 multi=1 nf=1 sd=100e-9 ad=10.5e-15 as=10.5e-15 pd=430e-9 ps=430e-9 nrd=2.677526 nrs=2.677526 sa=75e-9 sb=75e-9 sa1=75e-9 sa2=75e-9 sa3=75e-9 sa4=75e-9 sb1=75e-9 sb2=75e-9 sb3=75e-9 spa=100e-9 spa1=100e-9 spa2=100e-9 spa3=100e-9 sap=91.9776e-9 sapb=114.444e-9 spba=115.996e-9 spba1=117.547e-9 dfm_flag=0 spmt=1.11111e15 spomt=0 spomt1=1.11111e60 spmb=1.11111e15 spomb=0 spomb1=1.11111e60
xmm4 qf_x clkbb net088 vss nch_mac l=35e-9 w=155e-9 multi=1 nf=1 sd=100e-9 ad=11.625e-15 as=11.625e-15 pd=460e-9 ps=460e-9 nrd=2.715364 nrs=2.715364 sa=75e-9 sb=75e-9 sa1=75e-9 sa2=75e-9 sa3=75e-9 sa4=75e-9 sb1=75e-9 sb2=75e-9 sb3=75e-9 spa=100e-9 spa1=100e-9 spa2=100e-9 spa3=100e-9 sap=91.9776e-9 sapb=114.444e-9 spba=115.996e-9 spba1=117.547e-9 dfm_flag=0 spmt=1.11111e15 spomt=0 spomt1=1.11111e60 spmb=1.11111e15 spomb=0 spomb1=1.11111e60
xmm5 net088 d vss vss nch_mac l=35e-9 w=155e-9 multi=1 nf=1 sd=100e-9 ad=11.625e-15 as=11.625e-15 pd=460e-9 ps=460e-9 nrd=2.715364 nrs=2.715364 sa=75e-9 sb=75e-9 sa1=75e-9 sa2=75e-9 sa3=75e-9 sa4=75e-9 sb1=75e-9 sb2=75e-9 sb3=75e-9 spa=100e-9 spa1=100e-9 spa2=100e-9 spa3=100e-9 sap=91.9776e-9 sapb=114.444e-9 spba=115.996e-9 spba1=117.547e-9 dfm_flag=0 spmt=1.11111e15 spomt=0 spomt1=1.11111e60 spmb=1.11111e15 spomb=0 spomb1=1.11111e60
xmm11 qf qf_x vss vss nch_mac l=35e-9 w=280e-9 multi=1 nf=1 sd=100e-9 ad=21e-15 as=21e-15 pd=710e-9 ps=710e-9 nrd=1.382006 nrs=1.382006 sa=75e-9 sb=75e-9 sa1=75e-9 sa2=75e-9 sa3=75e-9 sa4=75e-9 sb1=75e-9 sb2=75e-9 sb3=75e-9 spa=100e-9 spa1=100e-9 spa2=100e-9 spa3=100e-9 sap=91.9776e-9 sapb=114.444e-9 spba=115.996e-9 spba1=117.547e-9 dfm_flag=0 spmt=1.11111e15 spomt=0 spomt1=1.11111e60 spmb=1.11111e15 spomb=0 spomb1=1.11111e60
xmm12 q qf_x vss vss nch_mac l=35e-9 w=280e-9 multi=1 nf=1 sd=100e-9 ad=21e-15 as=21e-15 pd=710e-9 ps=710e-9 nrd=1.382006 nrs=1.382006 sa=75e-9 sb=75e-9 sa1=75e-9 sa2=75e-9 sa3=75e-9 sa4=75e-9 sb1=75e-9 sb2=75e-9 sb3=75e-9 spa=100e-9 spa1=100e-9 spa2=100e-9 spa3=100e-9 sap=91.9776e-9 sapb=114.444e-9 spba=115.996e-9 spba1=117.547e-9 dfm_flag=0 spmt=1.11111e15 spomt=0 spomt1=1.11111e60 spmb=1.11111e15 spomb=0 spomb1=1.11111e60
xmm19 vss qf net076 vss nch_mac l=35e-9 w=155e-9 multi=1 nf=1 sd=100e-9 ad=11.625e-15 as=11.625e-15 pd=460e-9 ps=460e-9 nrd=2.715364 nrs=2.715364 sa=75e-9 sb=75e-9 sa1=75e-9 sa2=75e-9 sa3=75e-9 sa4=75e-9 sb1=75e-9 sb2=75e-9 sb3=75e-9 spa=100e-9 spa1=100e-9 spa2=100e-9 spa3=100e-9 sap=91.9776e-9 sapb=114.444e-9 spba=115.996e-9 spba1=117.547e-9 dfm_flag=0 spmt=1.11111e15 spomt=0 spomt1=1.11111e60 spmb=1.11111e15 spomb=0 spomb1=1.11111e60
xmm6 net071 clkbb qf_x vdd pch_mac l=35e-9 w=230e-9 multi=1 nf=1 sd=100e-9 ad=17.25e-15 as=17.25e-15 pd=610e-9 ps=610e-9 nrd=756.521e-3 nrs=756.521e-3 sa=75e-9 sb=75e-9 sa1=75e-9 sa2=75e-9 sa3=75e-9 sa4=75e-9 sb1=75e-9 sb2=75e-9 sb3=75e-9 spa=100e-9 spa1=100e-9 spa2=100e-9 spa3=100e-9 sap=91.9776e-9 sapb=114.444e-9 spba=115.996e-9 spba1=117.547e-9 dfm_flag=0 spmt=1.11111e15 spomt=0 spomt1=1.11111e60 spmb=1.11111e15 spomb=0 spomb1=1.11111e60
xmm7 clkbb clkb vdd vdd pch_mac l=35e-9 w=170e-9 multi=1 nf=1 sd=100e-9 ad=12.75e-15 as=12.75e-15 pd=490e-9 ps=490e-9 nrd=1.62222 nrs=1.62222 sa=75e-9 sb=75e-9 sa1=75e-9 sa2=75e-9 sa3=75e-9 sa4=75e-9 sb1=75e-9 sb2=75e-9 sb3=75e-9 spa=100e-9 spa1=100e-9 spa2=100e-9 spa3=100e-9 sap=91.9776e-9 sapb=114.444e-9 spba=115.996e-9 spba1=117.547e-9 dfm_flag=0 spmt=1.11111e15 spomt=0 spomt1=1.11111e60 spmb=1.11111e15 spomb=0 spomb1=1.11111e60
xmm1 clkb e vdd vdd pch_mac l=35e-9 w=170e-9 multi=1 nf=1 sd=100e-9 ad=12.75e-15 as=12.75e-15 pd=490e-9 ps=490e-9 nrd=1.62222 nrs=1.62222 sa=75e-9 sb=75e-9 sa1=75e-9 sa2=75e-9 sa3=75e-9 sa4=75e-9 sb1=75e-9 sb2=75e-9 sb3=75e-9 spa=100e-9 spa1=100e-9 spa2=100e-9 spa3=100e-9 sap=91.9776e-9 sapb=114.444e-9 spba=115.996e-9 spba1=117.547e-9 dfm_flag=0 spmt=1.11111e15 spomt=0 spomt1=1.11111e60 spmb=1.11111e15 spomb=0 spomb1=1.11111e60
xmm2 net052 d vdd vdd pch_mac l=35e-9 w=230e-9 multi=1 nf=1 sd=100e-9 ad=17.25e-15 as=17.25e-15 pd=610e-9 ps=610e-9 nrd=756.521e-3 nrs=756.521e-3 sa=75e-9 sb=75e-9 sa1=75e-9 sa2=75e-9 sa3=75e-9 sa4=75e-9 sb1=75e-9 sb2=75e-9 sb3=75e-9 spa=100e-9 spa1=100e-9 spa2=100e-9 spa3=100e-9 sap=91.9776e-9 sapb=114.444e-9 spba=115.996e-9 spba1=117.547e-9 dfm_flag=0 spmt=1.11111e15 spomt=0 spomt1=1.11111e60 spmb=1.11111e15 spomb=0 spomb1=1.11111e60
xmm3 qf_x clkb net052 vdd pch_mac l=35e-9 w=230e-9 multi=1 nf=1 sd=100e-9 ad=17.25e-15 as=17.25e-15 pd=610e-9 ps=610e-9 nrd=756.521e-3 nrs=756.521e-3 sa=75e-9 sb=75e-9 sa1=75e-9 sa2=75e-9 sa3=75e-9 sa4=75e-9 sb1=75e-9 sb2=75e-9 sb3=75e-9 spa=100e-9 spa1=100e-9 spa2=100e-9 spa3=100e-9 sap=91.9776e-9 sapb=114.444e-9 spba=115.996e-9 spba1=117.547e-9 dfm_flag=0 spmt=1.11111e15 spomt=0 spomt1=1.11111e60 spmb=1.11111e15 spomb=0 spomb1=1.11111e60
xmm10 qf qf_x vdd vdd pch_mac l=35e-9 w=340e-9 multi=1 nf=1 sd=100e-9 ad=25.5e-15 as=25.5e-15 pd=830e-9 ps=830e-9 nrd=500.473e-3 nrs=500.473e-3 sa=75e-9 sb=75e-9 sa1=75e-9 sa2=75e-9 sa3=75e-9 sa4=75e-9 sb1=75e-9 sb2=75e-9 sb3=75e-9 spa=100e-9 spa1=100e-9 spa2=100e-9 spa3=100e-9 sap=91.9776e-9 sapb=114.444e-9 spba=115.996e-9 spba1=117.547e-9 dfm_flag=0 spmt=1.11111e15 spomt=0 spomt1=1.11111e60 spmb=1.11111e15 spomb=0 spomb1=1.11111e60
xmm13 q qf_x vdd vdd pch_mac l=35e-9 w=340e-9 multi=1 nf=1 sd=100e-9 ad=25.5e-15 as=25.5e-15 pd=830e-9 ps=830e-9 nrd=500.473e-3 nrs=500.473e-3 sa=75e-9 sb=75e-9 sa1=75e-9 sa2=75e-9 sa3=75e-9 sa4=75e-9 sb1=75e-9 sb2=75e-9 sb3=75e-9 spa=100e-9 spa1=100e-9 spa2=100e-9 spa3=100e-9 sap=91.9776e-9 sapb=114.444e-9 spba=115.996e-9 spba1=117.547e-9 dfm_flag=0 spmt=1.11111e15 spomt=0 spomt1=1.11111e60 spmb=1.11111e15 spomb=0 spomb1=1.11111e60
xmm16 vdd qf net071 vdd pch_mac l=35e-9 w=230e-9 multi=1 nf=1 sd=100e-9 ad=17.25e-15 as=17.25e-15 pd=610e-9 ps=610e-9 nrd=756.521e-3 nrs=756.521e-3 sa=75e-9 sb=75e-9 sa1=75e-9 sa2=75e-9 sa3=75e-9 sa4=75e-9 sb1=75e-9 sb2=75e-9 sb3=75e-9 spa=100e-9 spa1=100e-9 spa2=100e-9 spa3=100e-9 sap=91.9776e-9 sapb=114.444e-9 spba=115.996e-9 spba1=117.547e-9 dfm_flag=0 spmt=1.11111e15 spomt=0 spomt1=1.11111e60 spmb=1.11111e15 spomb=0 spomb1=1.11111e60
.ends LHQD1BWP35P140
** End of subcircuit definition.

** Library name: OpenRAM_cells
** Cell name: ADO_BLDRV_REG_HK
** View name: schematic
xi4 net3 net7 vdd vss BUFFD8BWP35P140
xi6 en enb vdd net2 bl vss ADO_XG_16X_HK
xi5 en enb vdd net7 blb vss ADO_XG_16X_HK
xi3 net3 net2 vdd vss INVD8BWP35P140
xi2 do net3 vdd vss INVD4BWP35P140
xi14 net1 ck2 do vdd vss LHQD1BWP35P140
xi0 di ck1 net1 vdd vss LHQD1BWP35P140
.END
