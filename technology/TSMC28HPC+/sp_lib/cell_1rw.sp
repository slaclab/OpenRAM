** Generated for: hspiceD
** Generated on: Apr 29 13:23:22 2025
** Design library name: OpenRAM_cells
** Design cell name: ADO_SRAM_6T_HK
** Design view name: schematic

.TEMP 25
.OPTION
+    ARTIST=2
+    INGOLD=2
+    PARHIER=LOCAL
+    PSF=2
+    HIER_DELIM=0
.LIB "/lscratch/TSMC28HPC+/TSMC28nm/models/hspice/toplevel.l" TOP_TT

** Library name: OpenRAM_cells
** Cell name: ADO_SRAM_6T_HK
** View name: schematic
xm8 wb w vdd vdd pch_mac l=30e-9 w=100e-9 multi=1 nf=1 sd=100e-9 ad=7.5e-15 as=7.5e-15 pd=350e-9 ps=350e-9 nrd=1.466664 nrs=1.466664 sa=75e-9 sb=75e-9 sa1=75e-9 sa2=75e-9 sa3=75e-9 sa4=75e-9 sb1=75e-9 sb2=75e-9 sb3=75e-9 spa=100e-9 spa1=100e-9 spa2=100e-9 spa3=100e-9 sap=91.9776e-9 sapb=114.444e-9 spba=115.715e-9 spba1=117.043e-9 dfm_flag=0 spmt=1.11111e15 spomt=0 spomt1=1.11111e60 spmb=1.11111e15 spomb=0 spomb1=1.11111e60
xm0 w wb vdd vdd pch_mac l=30e-9 w=100e-9 multi=1 nf=1 sd=100e-9 ad=7.5e-15 as=7.5e-15 pd=350e-9 ps=350e-9 nrd=1.466664 nrs=1.466664 sa=75e-9 sb=75e-9 sa1=75e-9 sa2=75e-9 sa3=75e-9 sa4=75e-9 sb1=75e-9 sb2=75e-9 sb3=75e-9 spa=100e-9 spa1=100e-9 spa2=100e-9 spa3=100e-9 sap=91.9776e-9 sapb=114.444e-9 spba=115.715e-9 spba1=117.043e-9 dfm_flag=0 spmt=1.11111e15 spomt=0 spomt1=1.11111e60 spmb=1.11111e15 spomb=0 spomb1=1.11111e60
xm9 w wl bl vss nch_mac l=30e-9 w=100e-9 multi=1 nf=1 sd=100e-9 ad=7.5e-15 as=7.5e-15 pd=350e-9 ps=350e-9 nrd=2.576626 nrs=2.576626 sa=75e-9 sb=75e-9 sa1=75e-9 sa2=75e-9 sa3=75e-9 sa4=75e-9 sb1=75e-9 sb2=75e-9 sb3=75e-9 spa=100e-9 spa1=100e-9 spa2=100e-9 spa3=100e-9 sap=91.9776e-9 sapb=114.444e-9 spba=115.715e-9 spba1=117.043e-9 dfm_flag=0 spmt=1.11111e15 spomt=0 spomt1=1.11111e60 spmb=1.11111e15 spomb=0 spomb1=1.11111e60
xm5 wb w vss vss nch_mac l=30e-9 w=100e-9 multi=1 nf=1 sd=100e-9 ad=7.5e-15 as=7.5e-15 pd=350e-9 ps=350e-9 nrd=2.576626 nrs=2.576626 sa=75e-9 sb=75e-9 sa1=75e-9 sa2=75e-9 sa3=75e-9 sa4=75e-9 sb1=75e-9 sb2=75e-9 sb3=75e-9 spa=100e-9 spa1=100e-9 spa2=100e-9 spa3=100e-9 sap=91.9776e-9 sapb=114.444e-9 spba=115.715e-9 spba1=117.043e-9 dfm_flag=0 spmt=1.11111e15 spomt=0 spomt1=1.11111e60 spmb=1.11111e15 spomb=0 spomb1=1.11111e60
xm4 wb wl blb vss nch_mac l=30e-9 w=100e-9 multi=1 nf=1 sd=100e-9 ad=7.5e-15 as=7.5e-15 pd=350e-9 ps=350e-9 nrd=2.576626 nrs=2.576626 sa=75e-9 sb=75e-9 sa1=75e-9 sa2=75e-9 sa3=75e-9 sa4=75e-9 sb1=75e-9 sb2=75e-9 sb3=75e-9 spa=100e-9 spa1=100e-9 spa2=100e-9 spa3=100e-9 sap=91.9776e-9 sapb=114.444e-9 spba=115.715e-9 spba1=117.043e-9 dfm_flag=0 spmt=1.11111e15 spomt=0 spomt1=1.11111e60 spmb=1.11111e15 spomb=0 spomb1=1.11111e60
xm10 w wb vss vss nch_mac l=30e-9 w=100e-9 multi=1 nf=1 sd=100e-9 ad=7.5e-15 as=7.5e-15 pd=350e-9 ps=350e-9 nrd=2.576626 nrs=2.576626 sa=75e-9 sb=75e-9 sa1=75e-9 sa2=75e-9 sa3=75e-9 sa4=75e-9 sb1=75e-9 sb2=75e-9 sb3=75e-9 spa=100e-9 spa1=100e-9 spa2=100e-9 spa3=100e-9 sap=91.9776e-9 sapb=114.444e-9 spba=115.715e-9 spba1=117.043e-9 dfm_flag=0 spmt=1.11111e15 spomt=0 spomt1=1.11111e60 spmb=1.11111e15 spomb=0 spomb1=1.11111e60
.END
